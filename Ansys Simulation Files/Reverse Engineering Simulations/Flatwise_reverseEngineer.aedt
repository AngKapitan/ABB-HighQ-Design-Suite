# Ansys Electronics Desktop project, version 2023.1
project datasets:
  $f_Pcv: (94451.011, 10.239803) (100000, 11.257915) (111386.35, 13.607888) (122505.13, 15.87399) (133035.31, 18.517463) (139960.51, 20.118799) (151030.05, 22.919537) (165055.82, 26.110164) (176983.95, 29.394602) (185019.55, 31.56039) (190981.69, 33.486623) (199652.84, 35.953911) (212727.53, 40.476609) (223801.12, 45.031488) (236949.42, 50.098933) (247707.64, 54.431344) (257316.91, 58.441835) (265608.78, 62.747818) (279435.12, 68.986642) (292122.32, 74.952408) (299629.12, 79.526996) (311252.57, 85.38653) (323326.93, 90.597946) (333745.93, 96.127432) (342322.36, 100.79304) (353353.47, 106.94476) (362433.76, 112.13539) (374112.96, 117.57795) (383726.72, 124.75412) (396092.07, 133.94598) (408855.88, 142.12113) (424716.54, 152.59259) (435630.68, 165.78836) (443999.95, 173.835) (455409.62, 182.27219) (467112.5, 193.39685) (482164.9, 205.20049) (500869.42, 225.60295) (520299.54, 242.22533) (540483.41, 266.30906) (557900.14, 289.33869) (575878.12, 306.99797) (598218.04, 333.54627) (621424.58, 358.1219) (641449.59, 384.50825) (657933.22, 412.83874) (674840.44, 432.87613) (696586.75, 453.88604) (714487.26, 487.32828) (732847.78, 517.0715) (756463.33, 548.63005) (775902.52, 575.25815) (795841.25, 610.36801) (821486.73, 655.33981) (847958.61, 703.62512) (880853.29, 764.47259) (909238.23, 811.13083) (938537.85, 870.89479) (962655.89, 924.04832) (987393.71, 968.89758)
materials:
  aluminum: permeability=1.000021 conductivity=38000000 thermal_conductivity=237.5 mass_density=2689 specific_heat=951 youngs_modulus=69000000000 poissons_ratio=0.31 thermal_expansion_coefficient=2.33e-05
  copper: permeability=0.999991 conductivity=58000000 thermal_conductivity=400 mass_density=8933 specific_heat=385 youngs_modulus=120000000000 poissons_ratio=0.38 thermal_expansion_coefficient=1.77e-05
  ferrite - Copy (2): core_loss_curve{25kHz (0, 0) (0.050633, 1) (0.0590114, 1.50406) (0.0691674, 2.34392) (0.0792528, 3.65275) (0.088772, 5.02746) (0.0939521, 6.11121) (0.1, 7.16954) (0.109499, 8.56175) (0.121957, 11.5767) (0.138164, 16.5092) (0.153013, 23.1293) (0.173347, 32.9841) (0.195272, 44.5991) (0.21382, 61.3838) (0.235462, 78.6962) (0.259294, 104.536) (0.280722, 138.862) (0.295422, 151.746)} core_loss_curve{100kHz (0, 0) (0.0263744, 1.03613) (0.0293752, 1.42608) (0.0332788, 2.03369) (0.0396755, 3.1693) (0.0449479, 4.44016) (0.0523856, 6.91954) (0.0628101, 11.373) (0.0753091, 20.068) (0.0882699, 32.4039) (0.103461, 49.6099) (0.118547, 74.6161) (0.142138, 118.363) (0.165658, 191.122) (0.184506, 245.025) (0.1975, 325.48) (0.215037, 409.937) (0.242235, 554.291) (0.26827, 762.898) (0.287163, 911.04)} core_loss_curve{200kHz (0, 0) (0.0153013, 1.07357) (0.0196383, 2.03369) (0.0260769, 4.28533) (0.0305648, 7.42858) (0.0396755, 14.0722) (0.0481134, 22.7224) (0.059347, 38.6962) (0.0757374, 74.6161) (0.0994345, 162.909) (0.110748, 216.401) (0.130546, 319.755) (0.147894, 472.47) (0.164721, 605.722) (0.183462, 848.612) (0.194168, 1013.4) (0.210213, 1167.99) (0.235462, 1607.55) (0.252045, 2024.69) (0.274425, 2333.54) (0.290439, 2939.06)} core_loss_curve{500kHz (0, 0) (0.0101716, 5.89811) (0.01199, 8.71505) (0.0149581, 13.5815) (0.0170423, 18.6929) (0.0202031, 30.1834) (0.0235462, 38.6962) (0.0266752, 55.1837) (0.0309135, 72.0142) (0.0356225, 99.1166) (0.0401281, 129.346) (0.0465037, 187.76) (0.0515018, 236.481) (0.0580159, 319.755) (0.067616, 447.974) (0.0761681, 574.318) (0.0892769, 776.557) (0.101141, 1068.81) (0.1199, 1524.21) (0.142138, 2292.49) (0.174333, 3327.81) (0.199753, 5186.04) (0.22248, 6531.74) (0.249202, 8373.92)} permittivity=12 permeability=3400 conductivity=0.25 thermal_conductivity=4 core_loss_type="Power Ferrite" core_loss_cm=0.062032234 core_loss_x=1.7066326 core_loss_y=2.5354555 mass_density=4800 specific_heat=750 youngs_modulus=119000000000 thermal_expansion_coefficient=1e-05 core_loss_equiv_cut_depth=0.001meter
  silicon - Copy: permittivity=9 thermal_conductivity=10 mass_density=3700 specific_heat=712 youngs_modulus=135000000000 poissons_ratio=0.25 thermal_expansion_coefficient=2.54e-06
  vacuum: permittivity=1
  air: permittivity=1.0006 permeability=1.0000004 thermal_conductivity=0.0261 mass_density=1.1614 specific_heat=1005 thermal_expansion_coefficient=0.00333 thermal_material_type=Fluid diffusivity=2.88e-05 molecular_mass=0.028966 viscosity=1.84e-05 material_refractive_index=1.000293
  Al-Extruded: thermal_conductivity=205 mass_density=2800 specific_heat=900 youngs_modulus=69000000000 poissons_ratio=0.33 thermal_expansion_coefficient=2.277e-06 thermal_material_type=Solid
  coppe_real: permeability=0.999991 conductivity=59880239.52 thermal_conductivity=393 mass_density=8890 specific_heat=385 youngs_modulus=111000000000 poissons_ratio=0.38 thermal_expansion_coefficient=1.7e-05
  ferrite - real: core_loss_curve{25kHz (0, 0) (0.050633, 1) (0.0590114, 1.50406) (0.0691674, 2.34392) (0.0792528, 3.65275) (0.088772, 5.02746) (0.0939521, 6.11121) (0.1, 7.16954) (0.109499, 8.56175) (0.121957, 11.5767) (0.138164, 16.5092) (0.153013, 23.1293) (0.173347, 32.9841) (0.195272, 44.5991) (0.21382, 61.3838) (0.235462, 78.6962) (0.259294, 104.536) (0.280722, 138.862) (0.295422, 151.746)} core_loss_curve{100kHz (0, 0) (0.0263744, 1.03613) (0.0293752, 1.42608) (0.0332788, 2.03369) (0.0396755, 3.1693) (0.0449479, 4.44016) (0.0523856, 6.91954) (0.0628101, 11.373) (0.0753091, 20.068) (0.0882699, 32.4039) (0.103461, 49.6099) (0.118547, 74.6161) (0.142138, 118.363) (0.165658, 191.122) (0.184506, 245.025) (0.1975, 325.48) (0.215037, 409.937) (0.242235, 554.291) (0.26827, 762.898) (0.287163, 911.04)} core_loss_curve{200kHz (0, 0) (0.0153013, 1.07357) (0.0196383, 2.03369) (0.0260769, 4.28533) (0.0305648, 7.42858) (0.0396755, 14.0722) (0.0481134, 22.7224) (0.059347, 38.6962) (0.0757374, 74.6161) (0.0994345, 162.909) (0.110748, 216.401) (0.130546, 319.755) (0.147894, 472.47) (0.164721, 605.722) (0.183462, 848.612) (0.194168, 1013.4) (0.210213, 1167.99) (0.235462, 1607.55) (0.252045, 2024.69) (0.274425, 2333.54) (0.290439, 2939.06)} core_loss_curve{500kHz (0, 0) (0.0101716, 5.89811) (0.01199, 8.71505) (0.0149581, 13.5815) (0.0170423, 18.6929) (0.0202031, 30.1834) (0.0235462, 38.6962) (0.0266752, 55.1837) (0.0309135, 72.0142) (0.0356225, 99.1166) (0.0401281, 129.346) (0.0465037, 187.76) (0.0515018, 236.481) (0.0580159, 319.755) (0.067616, 447.974) (0.0761681, 574.318) (0.0892769, 776.557) (0.101141, 1068.81) (0.1199, 1524.21) (0.142138, 2292.49) (0.174333, 3327.81) (0.199753, 5186.04) (0.22248, 6531.74) (0.249202, 8373.92)} permittivity=12 permeability=3300 conductivity=0.25 thermal_conductivity=4 core_loss_type="Power Ferrite" core_loss_cm=2.0420624 core_loss_x=1.4062949 core_loss_y=2.7267175 mass_density=4800 specific_heat=750 youngs_modulus=119000000000 thermal_expansion_coefficient=1e-05 core_loss_equiv_cut_depth=0.001meter
  aluminum_real: permeability=1.000021 conductivity=38000000 thermal_conductivity=176.5 mass_density=2700 specific_heat=897 youngs_modulus=69000000000 poissons_ratio=0.31 thermal_expansion_coefficient=2.32e-05
  silicon_TIMreal: permittivity=7 conductivity=1e-11 thermal_conductivity=10 mass_density=3500 specific_heat=712 youngs_modulus=135000000000 poissons_ratio=0.25 thermal_expansion_coefficient=2.54e-06
  ferrite - real2: core_loss_curve{25kHz (0, 0) (0.050633, 1) (0.0590114, 1.50406) (0.0691674, 2.34392) (0.0792528, 3.65275) (0.088772, 5.02746) (0.0939521, 6.11121) (0.1, 7.16954) (0.109499, 8.56175) (0.121957, 11.5767) (0.138164, 16.5092) (0.153013, 23.1293) (0.173347, 32.9841) (0.195272, 44.5991) (0.21382, 61.3838) (0.235462, 78.6962) (0.259294, 104.536) (0.280722, 138.862) (0.295422, 151.746)} core_loss_curve{100kHz (0, 0) (0.0263744, 1.03613) (0.0293752, 1.42608) (0.0332788, 2.03369) (0.0396755, 3.1693) (0.0449479, 4.44016) (0.0523856, 6.91954) (0.0628101, 11.373) (0.0753091, 20.068) (0.0882699, 32.4039) (0.103461, 49.6099) (0.118547, 74.6161) (0.142138, 118.363) (0.165658, 191.122) (0.184506, 245.025) (0.1975, 325.48) (0.215037, 409.937) (0.242235, 554.291) (0.26827, 762.898) (0.287163, 911.04)} core_loss_curve{200kHz (0, 0) (0.0153013, 1.07357) (0.0196383, 2.03369) (0.0260769, 4.28533) (0.0305648, 7.42858) (0.0396755, 14.0722) (0.0481134, 22.7224) (0.059347, 38.6962) (0.0757374, 74.6161) (0.0994345, 162.909) (0.110748, 216.401) (0.130546, 319.755) (0.147894, 472.47) (0.164721, 605.722) (0.183462, 848.612) (0.194168, 1013.4) (0.210213, 1167.99) (0.235462, 1607.55) (0.252045, 2024.69) (0.274425, 2333.54) (0.290439, 2939.06)} core_loss_curve{500kHz (0, 0) (0.0101716, 5.89811) (0.01199, 8.71505) (0.0149581, 13.5815) (0.0170423, 18.6929) (0.0202031, 30.1834) (0.0235462, 38.6962) (0.0266752, 55.1837) (0.0309135, 72.0142) (0.0356225, 99.1166) (0.0401281, 129.346) (0.0465037, 187.76) (0.0515018, 236.481) (0.0580159, 319.755) (0.067616, 447.974) (0.0761681, 574.318) (0.0892769, 776.557) (0.101141, 1068.81) (0.1199, 1524.21) (0.142138, 2292.49) (0.174333, 3327.81) (0.199753, 5186.04) (0.22248, 6531.74) (0.249202, 8373.92)} permittivity=12 permeability=3300 conductivity=0.25 thermal_conductivity=4 core_loss_type="Power Ferrite" core_loss_cm=2.0420624 core_loss_x=1.4062949 core_loss_y=2.7267175 mass_density=4800 specific_heat=750 youngs_modulus=119000000000 thermal_expansion_coefficient=1e-05 core_loss_equiv_cut_depth=0.001meter
  Material1: thermal_conductivity=0.14 mass_density=600 specific_heat=1600
  polyimide: permittivity=3.5 dielectric_loss_tangent=0.008 thermal_conductivity=0.25 mass_density=1400 specific_heat=1150 youngs_modulus=7500000000 poissons_ratio=0.35 thermal_expansion_coefficient=7e-05
  kapton_real: permittivity=3.5 dielectric_loss_tangent=0.008 thermal_conductivity=0.2 mass_density=1420 specific_heat=1090 youngs_modulus=7500000000 poissons_ratio=0.35 thermal_expansion_coefficient=7e-05
  Acrylic Resin-JSME: thermal_conductivity=0.21 mass_density=1190 specific_heat=1400 thermal_material_type=Solid
surface materials:
  Steel-oxidised-surface: surface_emissivity=0.8

design Flatwise_0.30_interleaved_full_old (Maxwell 3D, EddyCurrent, model units mm)
variables:
  freq_hz = 28500Hz
  volt_ac = 141/28500*Freq
geometry:
  Region [vacuum] = region(percentage_offset=0 on all sides)
  Np1..Np8, Ns1..Ns8 [copper] = imported_body(C:\Users\karlr\Documents\ICMaSS_sweeping\flatwise_0.1_0.3.step)
  plate_1, plate_2 [silicon - Copy] = imported_body(C:\Users\karlr\Documents\ICMaSS_sweeping\flatwise_0.1_0.3.step)
  Body1 [ferrite - Copy (2)] = imported_body(C:\Users\karlr\Documents\ICMaSS_sweeping\flatwise_0.1_0.3.step)
  Body1_1, Body1_2 [aluminum] = imported_body(C:\Users\karlr\Documents\ICMaSS_sweeping\flatwise_0.1_0.3.step)
  Body1_3 [ferrite - Copy (2)] = imported_body(C:\Users\karlr\Documents\ICMaSS_sweeping\flatwise_0.1_0.3.step)
  Body1_4, Body1_5 [aluminum] = imported_body(C:\Users\karlr\Documents\ICMaSS_sweeping\flatwise_0.1_0.3.step)
  Np1_Section1 = Np1.section(plane=ZX)
  Np2_Section1 = Np2.section(plane=ZX)
  Np3_Section1 [copper] = Np3.section(plane=ZX)
  Np4_Section1 [copper] = Np4.section(plane=ZX)
  Np5_Section1 [copper] = Np5.section(plane=ZX)
  Np6_Section1 [copper] = Np6.section(plane=ZX)
  Np7_Section1 [copper] = Np7.section(plane=ZX)
  Np8_Section1 [copper] = Np8.section(plane=ZX)
  Ns1_Section1 = Ns1.section(plane=ZX)
  Ns2_Section1 = Ns2.section(plane=ZX)
  Ns3_Section1 [copper] = Ns3.section(plane=ZX)
  Ns4_Section1 [copper] = Ns4.section(plane=ZX)
  Ns5_Section1 [copper] = Ns5.section(plane=ZX)
  Ns6_Section1 [copper] = Ns6.section(plane=ZX)
  Ns7_Section1 [copper] = Ns7.section(plane=ZX)
  Ns8_Section1 [copper] = Ns8.section(plane=ZX)
  Np1_Section1_Separate1 [copper] = Np1_Section1.separate_bodies()
  Np1_Section1.delete()
  Np2_Section1_Separate1 [copper] = Np2_Section1.separate_bodies()
  Np2_Section1.delete()
  Np3_Section1.separate_bodies()
  Np4_Section1.separate_bodies()
  Np5_Section1.separate_bodies()
  Np6_Section1.separate_bodies()
  Np7_Section1.separate_bodies()
  Np8_Section1.separate_bodies()
  Ns1_Section1_Separate1 [copper] = Ns1_Section1.separate_bodies()
  Ns1_Section1.delete()
  Ns2_Section1_Separate1 [copper] = Ns2_Section1.separate_bodies()
  Ns2_Section1.delete()
  Ns3_Section1.separate_bodies()
  Ns4_Section1.separate_bodies()
  Ns5_Section1.separate_bodies()
  Ns6_Section1.separate_bodies()
  Ns7_Section1.separate_bodies()
  Ns8_Section1.separate_bodies()
  Rectangle1 [non-model] = rectangle(corner=(36.6mm, 25.43mm, 1.6666608e-08mm), z_size=18.666667mm, x_size=-36.6mm)
  [Np1..Np8, Ns1..Ns8, plate_1, plate_2, Body1, Body1_1..Body1_5, Np3_Section1, Np4_Section1, Np5_Section1, Np6_Section1, Np7_Section1, Np8_Section1, Ns3_Section1, Ns4_Section1, Ns5_Section1, Ns6_Section1, Ns7_Section1, Ns8_Section1, Np1_Section1_Separate1, Np2_Section1_Separate1, Ns1_Section1_Separate1, Ns2_Section1_Separate1, Rectangle1].move(-18.3mm, -25.43mm, -0.38333333mm)
  [Np1..Np8, Ns1..Ns8, plate_1, plate_2, Body1, Body1_1..Body1_5, Np3_Section1, Np4_Section1, Np5_Section1, Np6_Section1, Np7_Section1, Np8_Section1, Ns3_Section1, Ns4_Section1, Ns5_Section1, Ns6_Section1, Ns7_Section1, Ns8_Section1, Np1_Section1_Separate1, Np2_Section1_Separate1, Ns1_Section1_Separate1, Ns2_Section1_Separate1, Rectangle1].move(-5mm, 0mm, -6.7583333mm)
  Rectangle2 [non-model] = rectangle(corner=(7.3mm, -32.73mm, 2.1916667mm), x_size=-24.6mm, y_size=65.46mm)
  group core_assembled_flatwise = Np1..Np8, Ns1..Ns8, plate_1, plate_2, Np3_Section1, Np4_Section1, Np5_Section1, Np6_Section1, Np7_Section1, Np8_Section1, Ns3_Section1, Ns4_Section1, Ns5_Section1, Ns6_Section1, Ns7_Section1, Ns8_Section1, Np1_Section1_Separate1, Np2_Section1_Separate1, Ns1_Section1_Separate1, Ns2_Section1_Separate1
  group core_together_1 = Body1, Body1_1, Body1_2
  group core_together = Body1_3, Body1_4, Body1_5
boundaries and excitations:
  Ns_1: Coil Terminal Objects=Ns1_Section1_Separate1 Conductor_number=1 Winding=Ns Point_out_of_terminal=true
  Ns_2: Coil Terminal Objects=Ns2_Section1_Separate1 Conductor_number=1 Winding=Ns Point_out_of_terminal=true
  Ns_3: Coil Terminal Objects=Ns3_Section1 Conductor_number=1 Winding=Ns Point_out_of_terminal=true
  Ns_4: Coil Terminal Objects=Ns4_Section1 Conductor_number=1 Winding=Ns Point_out_of_terminal=true
  Ns_5: Coil Terminal Objects=Ns5_Section1 Conductor_number=1 Winding=Ns Point_out_of_terminal=true
  Ns_6: Coil Terminal Objects=Ns6_Section1 Conductor_number=1 Winding=Ns Point_out_of_terminal=true
  Ns_7: Coil Terminal Objects=Ns7_Section1 Conductor_number=1 Winding=Ns Point_out_of_terminal=true
  Ns_8: Coil Terminal Objects=Ns8_Section1 Conductor_number=1 Winding=Ns Point_out_of_terminal=true
  Np_1: Coil Terminal Objects=Np1_Section1_Separate1 Conductor_number=1 Winding=Np Point_out_of_terminal=false
  Np_2: Coil Terminal Objects=Np2_Section1_Separate1 Conductor_number=1 Winding=Np Point_out_of_terminal=false
  Np_3: Coil Terminal Objects=Np3_Section1 Conductor_number=1 Winding=Np Point_out_of_terminal=false
  Np_4: Coil Terminal Objects=Np4_Section1 Conductor_number=1 Winding=Np Point_out_of_terminal=false
  Np_5: Coil Terminal Objects=Np5_Section1 Conductor_number=1 Winding=Np Point_out_of_terminal=false
  Np_6: Coil Terminal Objects=Np6_Section1 Conductor_number=1 Winding=Np Point_out_of_terminal=false
  Np_7: Coil Terminal Objects=Np7_Section1 Conductor_number=1 Winding=Np Point_out_of_terminal=false
  Np_8: Coil Terminal Objects=Np8_Section1 Conductor_number=1 Winding=Np Point_out_of_terminal=false
  Np: Winding Group Type=Voltage IsSolid=true Current=16.36A Resistance=0ohm Inductance=0nH Voltage=volt_ac ParallelBranchesNum=1 Phase=0rad
  Ns: Winding Group Type=Current IsSolid=true Current=1000*1.41/volt_ac*1.414 ParallelBranchesNum=1 Phase=0.1522rad
  core loss on: Body1, Body1_3
parameters:
  Matrix1: Matrix Np, Ns:
mesh:
  Length1: LengthBased Objects=[Body1, Body1_1..Body1_5] MaxLength=2mm
  SkinDepth1: SkinDepthBased Objects=[Np1..Np8, Ns1..Ns8, plate_1, plate_2] SkinDepth=0.020898162mm SurfTriMaxLength=1mm NumLayers=2
  initial mesh: GlobalSurfApproximation{CurvedSurfaceApproxChoice=UseSlider SliderMeshSettings=9} GlobalCurvilinear{Apply}
setups:
  Setup1: EddyCurrent MaximumPasses=20 MinimumPasses=2 MinimumConvergedPasses=1 PercentRefinement=30 PercentError=1 NonLinearResidual=0.0001 SmoothBHCurve Frequency=10MHz SweepRanges{0.1Hz to 1Hz, log, 1 per decade 1Hz to 1000Hz, log, 5 per decade 1000Hz to 10000Hz, log, 10 per decade 10000Hz to 100000Hz, log, 10 per decade 100000Hz to 1000000Hz, log, 10 per decade} SaveAllFields
field plots:
  Mag_B1: B over a plane on Setup1 : LastAdaptive at Freq=1MHz Phase=45deg
  Mesh1: MeshPlots in Np1..Np8, Ns1..Ns8 on Setup1 : LastAdaptive at Freq=1000000Hz Phase=0deg
  Mesh2: MeshPlots over a plane on Setup1 : LastAdaptive at Freq=10000000Hz Phase=0deg
  Mag_J1: J over a plane on Setup1 : LastAdaptive at Freq=25.1189kHz Phase=45deg
reports:
  L Table 1: Matrix1.L(Np,Np), Matrix1.L(Ns,Np), Matrix1.L(Np,Ns), Matrix1.L(Ns,Ns), Matrix1.R(Np,Np), Matrix1.R(Ns,Np), Matrix1.R(Np,Ns), Matrix1.R(Ns,Ns) vs Freq on Setup1 : LastAdaptive

design Flatwise_0.30_interleaved_fullmesh (Maxwell 3D, EddyCurrent, model units mm)
variables:
  freq_hz = 28500Hz
  volt_ac = 141/28500*Freq
geometry:
  Region [vacuum] = region(percentage_offset=0 on all sides)
  Np1..Np8, Ns1..Ns8 [coppe_real] = imported_body(C:\Users\karlr\Documents\ICMaSS_sweeping\flatwise_0.1_0.3.step)
  plate_1, plate_2 [silicon - Copy] = imported_body(C:\Users\karlr\Documents\ICMaSS_sweeping\flatwise_0.1_0.3.step)
  Body1 [ferrite - real] = imported_body(C:\Users\karlr\Documents\ICMaSS_sweeping\flatwise_0.1_0.3.step)
  Body1_1, Body1_2 [aluminum] = imported_body(C:\Users\karlr\Documents\ICMaSS_sweeping\flatwise_0.1_0.3.step)
  Body1_3 [ferrite - Copy (2)] = imported_body(C:\Users\karlr\Documents\ICMaSS_sweeping\flatwise_0.1_0.3.step)
  Body1_4, Body1_5 [aluminum] = imported_body(C:\Users\karlr\Documents\ICMaSS_sweeping\flatwise_0.1_0.3.step)
  Np1_Section1 = Np1.section(plane=ZX)
  Np2_Section1 = Np2.section(plane=ZX)
  Np3_Section1 [copper] = Np3.section(plane=ZX)
  Np4_Section1 [copper] = Np4.section(plane=ZX)
  Np5_Section1 [copper] = Np5.section(plane=ZX)
  Np6_Section1 [copper] = Np6.section(plane=ZX)
  Np7_Section1 [copper] = Np7.section(plane=ZX)
  Np8_Section1 [copper] = Np8.section(plane=ZX)
  Ns1_Section1 = Ns1.section(plane=ZX)
  Ns2_Section1 = Ns2.section(plane=ZX)
  Ns3_Section1 [copper] = Ns3.section(plane=ZX)
  Ns4_Section1 [copper] = Ns4.section(plane=ZX)
  Ns5_Section1 [copper] = Ns5.section(plane=ZX)
  Ns6_Section1 [copper] = Ns6.section(plane=ZX)
  Ns7_Section1 [copper] = Ns7.section(plane=ZX)
  Ns8_Section1 [copper] = Ns8.section(plane=ZX)
  Np1_Section1_Separate1 [copper] = Np1_Section1.separate_bodies()
  Np1_Section1.delete()
  Np2_Section1_Separate1 [copper] = Np2_Section1.separate_bodies()
  Np2_Section1.delete()
  Np3_Section1.separate_bodies()
  Np4_Section1.separate_bodies()
  Np5_Section1.separate_bodies()
  Np6_Section1.separate_bodies()
  Np7_Section1.separate_bodies()
  Np8_Section1.separate_bodies()
  Ns1_Section1_Separate1 [copper] = Ns1_Section1.separate_bodies()
  Ns1_Section1.delete()
  Ns2_Section1_Separate1 [copper] = Ns2_Section1.separate_bodies()
  Ns2_Section1.delete()
  Ns3_Section1.separate_bodies()
  Ns4_Section1.separate_bodies()
  Ns5_Section1.separate_bodies()
  Ns6_Section1.separate_bodies()
  Ns7_Section1.separate_bodies()
  Ns8_Section1.separate_bodies()
  Rectangle1 [non-model] = rectangle(corner=(36.6mm, 25.43mm, 1.6666608e-08mm), z_size=18.666667mm, x_size=-36.6mm)
  [Np1..Np8, Ns1..Ns8, plate_1, plate_2, Body1, Body1_1..Body1_5, Np3_Section1, Np4_Section1, Np5_Section1, Np6_Section1, Np7_Section1, Np8_Section1, Ns3_Section1, Ns4_Section1, Ns5_Section1, Ns6_Section1, Ns7_Section1, Ns8_Section1, Np1_Section1_Separate1, Np2_Section1_Separate1, Ns1_Section1_Separate1, Ns2_Section1_Separate1, Rectangle1].move(-18.3mm, -25.43mm, -0.38333333mm)
  [Np1..Np8, Ns1..Ns8, plate_1, plate_2, Body1, Body1_1..Body1_5, Np3_Section1, Np4_Section1, Np5_Section1, Np6_Section1, Np7_Section1, Np8_Section1, Ns3_Section1, Ns4_Section1, Ns5_Section1, Ns6_Section1, Ns7_Section1, Ns8_Section1, Np1_Section1_Separate1, Np2_Section1_Separate1, Ns1_Section1_Separate1, Ns2_Section1_Separate1, Rectangle1].move(-5mm, 0mm, -6.7583333mm)
  group core_assembled_flatwise = Np1..Np8, Ns1..Ns8, plate_1, plate_2, Np3_Section1, Np4_Section1, Np5_Section1, Np6_Section1, Np7_Section1, Np8_Section1, Ns3_Section1, Ns4_Section1, Ns5_Section1, Ns6_Section1, Ns7_Section1, Ns8_Section1, Np1_Section1_Separate1, Np2_Section1_Separate1, Ns1_Section1_Separate1, Ns2_Section1_Separate1
  group core_together_1 = Body1, Body1_1, Body1_2
  group core_together = Body1_3, Body1_4, Body1_5
boundaries and excitations:
  Ns_1: Coil Terminal Objects=Ns1_Section1_Separate1 Conductor_number=1 Winding=Ns Point_out_of_terminal=true
  Ns_2: Coil Terminal Objects=Ns2_Section1_Separate1 Conductor_number=1 Winding=Ns Point_out_of_terminal=true
  Ns_3: Coil Terminal Objects=Ns3_Section1 Conductor_number=1 Winding=Ns Point_out_of_terminal=true
  Ns_4: Coil Terminal Objects=Ns4_Section1 Conductor_number=1 Winding=Ns Point_out_of_terminal=true
  Ns_5: Coil Terminal Objects=Ns5_Section1 Conductor_number=1 Winding=Ns Point_out_of_terminal=true
  Ns_6: Coil Terminal Objects=Ns6_Section1 Conductor_number=1 Winding=Ns Point_out_of_terminal=true
  Ns_7: Coil Terminal Objects=Ns7_Section1 Conductor_number=1 Winding=Ns Point_out_of_terminal=true
  Ns_8: Coil Terminal Objects=Ns8_Section1 Conductor_number=1 Winding=Ns Point_out_of_terminal=true
  Np_1: Coil Terminal Objects=Np1_Section1_Separate1 Conductor_number=1 Winding=Np Point_out_of_terminal=false
  Np_2: Coil Terminal Objects=Np2_Section1_Separate1 Conductor_number=1 Winding=Np Point_out_of_terminal=false
  Np_3: Coil Terminal Objects=Np3_Section1 Conductor_number=1 Winding=Np Point_out_of_terminal=false
  Np_4: Coil Terminal Objects=Np4_Section1 Conductor_number=1 Winding=Np Point_out_of_terminal=false
  Np_5: Coil Terminal Objects=Np5_Section1 Conductor_number=1 Winding=Np Point_out_of_terminal=false
  Np_6: Coil Terminal Objects=Np6_Section1 Conductor_number=1 Winding=Np Point_out_of_terminal=false
  Np_7: Coil Terminal Objects=Np7_Section1 Conductor_number=1 Winding=Np Point_out_of_terminal=false
  Np_8: Coil Terminal Objects=Np8_Section1 Conductor_number=1 Winding=Np Point_out_of_terminal=false
  Np: Winding Group Type=Voltage IsSolid=true Current=16.36A Resistance=0ohm Inductance=0nH Voltage=volt_ac ParallelBranchesNum=1 Phase=0rad
  Ns: Winding Group Type=Current IsSolid=true Current=1000*1.41/volt_ac*1.414 ParallelBranchesNum=1 Phase=0.1522rad
  core loss on: Body1, Body1_3
parameters:
  Matrix1: Matrix Np, Ns:
mesh:
  Length1: LengthBased Objects=[Body1, Body1_1..Body1_5] MaxLength=2mm
  SkinDepth1: SkinDepthBased Objects=[Np1..Np8, Ns1..Ns8, plate_1, plate_2] SkinDepth=0.20567444mm SurfTriMaxLength=0.3mm NumLayers=2
  initial mesh: GlobalSurfApproximation{CurvedSurfaceApproxChoice=UseSlider SliderMeshSettings=9} GlobalCurvilinear{Apply}
setups:
  Setup1: EddyCurrent MaximumPasses=20 MinimumPasses=2 MinimumConvergedPasses=1 PercentRefinement=30 PercentError=1 NonLinearResidual=0.0001 SmoothBHCurve Frequency=100kHz SweepRanges{point 28500Hz} SaveAllFields
field plots:
  Mag_B1: B over a plane on Setup1 : LastAdaptive at Freq=28500Hz Phase=45deg
  Mesh1: MeshPlots in Np1..Np8, Ns1..Ns8 on Setup1 : LastAdaptive at Freq=28500Hz Phase=0deg
reports:
  L Table 1: Matrix1.L(Np,Np), Matrix1.L(Ns,Np), Matrix1.L(Np,Ns), Matrix1.L(Ns,Ns), Matrix1.R(Np,Np), Matrix1.R(Ns,Np), Matrix1.R(Np,Ns), Matrix1.R(Ns,Ns) vs Freq on Setup1 : LastAdaptive

design Edgewise_0.30_interleaved_new (Maxwell 3D, EddyCurrent, model units mm)
variables:
  freq_hz = 28500Hz
  volt_ac = 141/28500*Freq
geometry:
  Region [vacuum] = region(percentage_offset=0 on all sides)
  Body1 [ferrite - real] = imported_body(D:\Karl,reverseengineer\core_assembled_edgewise.step)
  Body1_1, Body1_2 [aluminum_real] = imported_body(D:\Karl,reverseengineer\core_assembled_edgewise.step)
  Body1_3 [ferrite - real] = imported_body(D:\Karl,reverseengineer\core_assembled_edgewise.step)
  Body1_4, Body1_5 [aluminum_real] = imported_body(D:\Karl,reverseengineer\core_assembled_edgewise.step)
  Np6, Np2, Np3, Np7, Np5, Np1, Np4, Np8, Ns6, Ns2, Ns3, Ns7, Ns5, Ns1, Ns4, Ns8 [coppe_real] = imported_body(D:\Karl,reverseengineer\core_assembled_edgewise.step)
  plate2, plate1 [silicon_TIMreal] = imported_body(D:\Karl,reverseengineer\core_assembled_edgewise.step)
  Np1_Section2 [coppe_real] = Np1.section(plane=ZX)
  Np2_Section2 [coppe_real] = Np2.section(plane=ZX)
  Np3_Section2 [coppe_real] = Np3.section(plane=ZX)
  Np4_Section2 [coppe_real] = Np4.section(plane=ZX)
  Np5_Section2 [coppe_real] = Np5.section(plane=ZX)
  Np6_Section2 [coppe_real] = Np6.section(plane=ZX)
  Np7_Section2 [coppe_real] = Np7.section(plane=ZX)
  Np8_Section2 [coppe_real] = Np8.section(plane=ZX)
  Ns1_Section2 [coppe_real] = Ns1.section(plane=ZX)
  Ns2_Section2 [coppe_real] = Ns2.section(plane=ZX)
  Ns3_Section2 [coppe_real] = Ns3.section(plane=ZX)
  Ns4_Section2 [coppe_real] = Ns4.section(plane=ZX)
  Ns5_Section2 [coppe_real] = Ns5.section(plane=ZX)
  Ns6_Section2 [coppe_real] = Ns6.section(plane=ZX)
  Ns7_Section2 [coppe_real] = Ns7.section(plane=ZX)
  Ns8_Section2 [coppe_real] = Ns8.section(plane=ZX)
  Np1_Section2.separate_bodies()
  Np2_Section2.separate_bodies()
  Np3_Section2.separate_bodies()
  Np4_Section2.separate_bodies()
  Np5_Section2.separate_bodies()
  Np6_Section2.separate_bodies()
  Np7_Section2.separate_bodies()
  Np8_Section2.separate_bodies()
  Ns1_Section2.separate_bodies()
  Ns2_Section2.separate_bodies()
  Ns3_Section2.separate_bodies()
  Ns4_Section2.separate_bodies()
  Ns5_Section2.separate_bodies()
  Ns6_Section2.separate_bodies()
  Ns7_Section2.separate_bodies()
  Ns8_Section2.separate_bodies()
  Rectangle1 [non-model] = rectangle(corner=(0mm, 25.43mm, 0mm), z_size=18.6mm, x_size=38.6mm)
  group core_togetherv4 = Body1, Body1_1, Body1_2
  group core_togetherv41 = Body1_3, Body1_4, Body1_5
  group Wire_face_edgewisaev15 = Np6, Np2, Np3, Np7, Np5, Np1, Np4, Np8, Ns6, Ns2, Ns3, Ns7, Ns5, Ns1, Ns4, Ns8, plate2, plate1, Np1_Section2, Np2_Section2, Np3_Section2, Np4_Section2, Np5_Section2, Np6_Section2, Np7_Section2, Np8_Section2, Ns1_Section2, Ns2_Section2, Ns3_Section2, Ns4_Section2, Ns5_Section2, Ns6_Section2, Ns7_Section2, Ns8_Section2
boundaries and excitations:
  CoilTerminal_1: Coil Terminal Objects=Np8_Section2 Conductor_number=1 Winding=Np Point_out_of_terminal=false
  CoilTerminal_2: Coil Terminal Objects=Np1_Section2 Conductor_number=1 Winding=Np Point_out_of_terminal=false
  CoilTerminal_3: Coil Terminal Objects=Np2_Section2 Conductor_number=1 Winding=Np Point_out_of_terminal=false
  CoilTerminal_4: Coil Terminal Objects=Np3_Section2 Conductor_number=1 Winding=Np Point_out_of_terminal=false
  CoilTerminal_5: Coil Terminal Objects=Np4_Section2 Conductor_number=1 Winding=Np Point_out_of_terminal=false
  CoilTerminal_6: Coil Terminal Objects=Np5_Section2 Conductor_number=1 Winding=Np Point_out_of_terminal=false
  CoilTerminal_7: Coil Terminal Objects=Np6_Section2 Conductor_number=1 Winding=Np Point_out_of_terminal=false
  CoilTerminal_8: Coil Terminal Objects=Np7_Section2 Conductor_number=1 Winding=Np Point_out_of_terminal=false
  CoilTerminal_9: Coil Terminal Objects=Ns1_Section2 Conductor_number=1 Winding=Ns Point_out_of_terminal=true
  CoilTerminal_10: Coil Terminal Objects=Ns2_Section2 Conductor_number=1 Winding=Ns Point_out_of_terminal=true
  CoilTerminal_11: Coil Terminal Objects=Ns3_Section2 Conductor_number=1 Winding=Ns Point_out_of_terminal=true
  CoilTerminal_12: Coil Terminal Objects=Ns4_Section2 Conductor_number=1 Winding=Ns Point_out_of_terminal=true
  CoilTerminal_13: Coil Terminal Objects=Ns5_Section2 Conductor_number=1 Winding=Ns Point_out_of_terminal=true
  CoilTerminal_14: Coil Terminal Objects=Ns6_Section2 Conductor_number=1 Winding=Ns Point_out_of_terminal=true
  CoilTerminal_15: Coil Terminal Objects=Ns7_Section2 Conductor_number=1 Winding=Ns Point_out_of_terminal=true
  CoilTerminal_16: Coil Terminal Objects=Ns8_Section2 Conductor_number=1 Winding=Ns Point_out_of_terminal=true
  Np: Winding Group Type=Voltage IsSolid=true Current=16.36A Resistance=0ohm Inductance=0nH Voltage=volt_ac ParallelBranchesNum=1 Phase=0rad
  Ns: Winding Group Type=Current IsSolid=true Current=1000*1.41/volt_ac*1.414 ParallelBranchesNum=1 Phase=0.1522rad
  eddy effects on: Body1_1, Body1_2, Body1_4, Body1_5, Np6, Np2, Np3, Np7, Np5, Np1, Np4, Np8, Ns6, Ns2, Ns3, Ns7, Ns5, Ns1, Ns4, Ns8
  core loss on: Body1, Body1_3
parameters:
  Matrix1: Matrix Np, Ns:
mesh:
  SkinDepth1: SkinDepthBased Objects=[Np1..Np8, Ns1..Ns8] SkinDepth=0.20567444mm SurfTriMaxLength=1mm NumLayers=2
  Length1: LengthBased Objects=[Body1_1, Body1_2, Body1, Body1_4, Body1_5, Body1_3, plate1, plate2] MaxLength=2mm
  initial mesh: GlobalSurfApproximation{CurvedSurfaceApproxChoice=UseSlider SliderMeshSettings=9} GlobalCurvilinear{Apply}
setups:
  Setup1: EddyCurrent MaximumPasses=20 MinimumPasses=4 MinimumConvergedPasses=1 PercentRefinement=30 PercentError=1 NonLinearResidual=0.0001 SmoothBHCurve Frequency=100kHz SweepRanges{point 28.5kHz} SaveAllFields
field plots:
  Mag_B1: B over a plane on Setup1 : LastAdaptive at Freq=28.5kHz Phase=90deg
  Mag_J1: J over a plane on Setup1 : LastAdaptive at Freq=28.5kHz Phase=45deg
reports:
  L Table 1: Matrix1.L(Np,Np), Matrix1.L(Ns,Np), Matrix1.L(Np,Ns), Matrix1.L(Ns,Ns), Matrix1.R(Np,Np), Matrix1.R(Ns,Np), Matrix1.R(Np,Ns), Matrix1.R(Ns,Ns) vs Freq on Setup1 : LastAdaptive

design Flatwise_0.30_interleaved_new (Maxwell 3D, EddyCurrent, model units mm)
variables:
  freq_hz = 28500Hz
  volt_ac = 141/28500*Freq
geometry:
  Body1, Body1_1 [aluminum_real] = imported_body(D:\Karl,reverseengineer\core_assembled_flatwise.step)
  Body1_2 [ferrite - real] = imported_body(D:\Karl,reverseengineer\core_assembled_flatwise.step)
  Body1_3, Body1_4 [aluminum_real] = imported_body(D:\Karl,reverseengineer\core_assembled_flatwise.step)
  Body1_5 [ferrite - real] = imported_body(D:\Karl,reverseengineer\core_assembled_flatwise.step)
  Np3, Np5, Np6, Np2, Np8, Np4, Np7, Np1, Ns3, Ns5, Ns6, Ns2, Ns8, Ns4, Ns7, Ns1 [coppe_real] = imported_body(D:\Karl,reverseengineer\core_assembled_flatwise.step)
  plate_1, plate_2 [silicon_TIMreal] = imported_body(D:\Karl,reverseengineer\core_assembled_flatwise.step)
  Region [vacuum] = region(percentage_offset=0 on all sides)
  Ns8_Section1 [coppe_real] = Ns8.section(plane=ZX)
  Np1_Section1 [coppe_real] = Np1.section(plane=ZX)
  Np2_Section1 [coppe_real] = Np2.section(plane=ZX)
  Np3_Section1 [coppe_real] = Np3.section(plane=ZX)
  Np4_Section1 [coppe_real] = Np4.section(plane=ZX)
  Np5_Section1 [coppe_real] = Np5.section(plane=ZX)
  Np6_Section1 [coppe_real] = Np6.section(plane=ZX)
  Np7_Section1 [coppe_real] = Np7.section(plane=ZX)
  Np8_Section1 [coppe_real] = Np8.section(plane=ZX)
  Ns1_Section1 [coppe_real] = Ns1.section(plane=ZX)
  Ns2_Section1 [coppe_real] = Ns2.section(plane=ZX)
  Ns3_Section1 [coppe_real] = Ns3.section(plane=ZX)
  Ns4_Section1 [coppe_real] = Ns4.section(plane=ZX)
  Ns5_Section1 [coppe_real] = Ns5.section(plane=ZX)
  Ns6_Section1 [coppe_real] = Ns6.section(plane=ZX)
  Ns7_Section1 [coppe_real] = Ns7.section(plane=ZX)
  Ns8_Section1.separate_bodies()
  Np1_Section1.separate_bodies()
  Np2_Section1.separate_bodies()
  Np3_Section1.separate_bodies()
  Np4_Section1.separate_bodies()
  Np5_Section1.separate_bodies()
  Np6_Section1.separate_bodies()
  Np7_Section1.separate_bodies()
  Np8_Section1.separate_bodies()
  Ns1_Section1.separate_bodies()
  Ns2_Section1.separate_bodies()
  Ns3_Section1.separate_bodies()
  Ns4_Section1.separate_bodies()
  Ns5_Section1.separate_bodies()
  Ns6_Section1.separate_bodies()
  Ns7_Section1.separate_bodies()
  Rectangle1 [non-model] = rectangle(corner=(0mm, 25.45mm, 0mm), z_size=18.7mm, x_size=38.6mm)
  group core_togetherv4 = Body1, Body1_1, Body1_2
  group core_togetherv41 = Body1_3, Body1_4, Body1_5
  group Wire_face_flatwise_newv8 = Np3, Np5, Np6, Np2, Np8, Np4, Np7, Np1, Ns3, Ns5, Ns6, Ns2, Ns8, Ns4, Ns7, Ns1, plate_1, plate_2, Ns8_Section1, Np1_Section1, Np2_Section1, Np3_Section1, Np4_Section1, Np5_Section1, Np6_Section1, Np7_Section1, Np8_Section1, Ns1_Section1, Ns2_Section1, Ns3_Section1, Ns4_Section1, Ns5_Section1, Ns6_Section1, Ns7_Section1
boundaries and excitations:
  CoilTerminal_1: Coil Terminal Objects=Np1_Section1 Conductor_number=1 Winding=Np Point_out_of_terminal=false
  CoilTerminal_2: Coil Terminal Objects=Np2_Section1 Conductor_number=1 Winding=Np Point_out_of_terminal=false
  CoilTerminal_3: Coil Terminal Objects=Np3_Section1 Conductor_number=1 Winding=Np Point_out_of_terminal=false
  CoilTerminal_4: Coil Terminal Objects=Np4_Section1 Conductor_number=1 Winding=Np Point_out_of_terminal=false
  CoilTerminal_5: Coil Terminal Objects=Np5_Section1 Conductor_number=1 Winding=Np Point_out_of_terminal=false
  CoilTerminal_6: Coil Terminal Objects=Np6_Section1 Conductor_number=1 Winding=Np Point_out_of_terminal=false
  CoilTerminal_7: Coil Terminal Objects=Np7_Section1 Conductor_number=1 Winding=Np Point_out_of_terminal=false
  CoilTerminal_8: Coil Terminal Objects=Np8_Section1 Conductor_number=1 Winding=Np Point_out_of_terminal=false
  CoilTerminal_9: Coil Terminal Objects=Ns1_Section1 Conductor_number=1 Winding=Ns Point_out_of_terminal=true
  CoilTerminal_10: Coil Terminal Objects=Ns2_Section1 Conductor_number=1 Winding=Ns Point_out_of_terminal=true
  CoilTerminal_11: Coil Terminal Objects=Ns3_Section1 Conductor_number=1 Winding=Ns Point_out_of_terminal=true
  CoilTerminal_12: Coil Terminal Objects=Ns4_Section1 Conductor_number=1 Winding=Ns Point_out_of_terminal=true
  CoilTerminal_13: Coil Terminal Objects=Ns5_Section1 Conductor_number=1 Winding=Ns Point_out_of_terminal=true
  CoilTerminal_14: Coil Terminal Objects=Ns6_Section1 Conductor_number=1 Winding=Ns Point_out_of_terminal=true
  CoilTerminal_15: Coil Terminal Objects=Ns7_Section1 Conductor_number=1 Winding=Ns Point_out_of_terminal=true
  CoilTerminal_16: Coil Terminal Objects=Ns8_Section1 Conductor_number=1 Winding=Ns Point_out_of_terminal=true
  Np: Winding Group Type=Voltage IsSolid=true Current=16.36A Resistance=0ohm Inductance=0nH Voltage=volt_ac ParallelBranchesNum=1 Phase=0rad
  Ns: Winding Group Type=Current IsSolid=true Current=1000*1.41/volt_ac*1.414 ParallelBranchesNum=1 Phase=0.1522rad
  eddy effects on: Body1, Body1_1, Body1_3, Body1_4, Np3, Np5, Np6, Np2, Np8, Np4, Np7, Np1, Ns3, Ns5, Ns6, Ns2, Ns8, Ns4, Ns7, Ns1
  core loss on: Body1_2, Body1_5
parameters:
  Matrix1: Matrix Np, Ns:
mesh:
  SkinDepth1: SkinDepthBased Objects=[Np1..Np8, Ns1..Ns8] SkinDepth=0.20567444mm SurfTriMaxLength=1mm NumLayers=2
  Length1: LengthBased Objects=[Body1, Body1_1..Body1_5, plate_1, plate_2] MaxLength=2mm
  initial mesh: GlobalSurfApproximation{CurvedSurfaceApproxChoice=UseSlider SliderMeshSettings=9} GlobalCurvilinear{Apply}
setups:
  Setup1: EddyCurrent MaximumPasses=20 MinimumPasses=4 MinimumConvergedPasses=1 PercentRefinement=30 PercentError=1 NonLinearResidual=0.0001 SmoothBHCurve Frequency=100kHz SweepRanges{point 28500Hz} SaveAllFields
field plots:
  Mesh1: MeshPlots on Setup1 : LastAdaptive at Freq=28500Hz Phase=0deg
  Mesh2: MeshPlots over a plane on Setup1 : LastAdaptive at Freq=28500Hz Phase=0deg
reports:
  L Table 1: Matrix1.L(Np,Np), Matrix1.L(Ns,Np), Matrix1.L(Np,Ns), Matrix1.L(Ns,Ns), Matrix1.R(Np,Np), Matrix1.R(Ns,Np), Matrix1.R(Np,Ns), Matrix1.R(Ns,Ns) vs Freq on Setup1 : LastAdaptive

design Flatwise_0.30_interleaved_new1 (Maxwell 3D, EddyCurrent, model units mm)
variables:
  freq_hz = 28500Hz
  volt_ac = 141/28500*Freq
geometry:
  Body1, Body1_1 [aluminum_real] = imported_body(D:\Karl,reverseengineer\core_assembled_flatwise.step)
  Body1_2 [ferrite - real] = imported_body(D:\Karl,reverseengineer\core_assembled_flatwise.step)
  Body1_3, Body1_4 [aluminum_real] = imported_body(D:\Karl,reverseengineer\core_assembled_flatwise.step)
  Body1_5 [ferrite - real] = imported_body(D:\Karl,reverseengineer\core_assembled_flatwise.step)
  Np3, Np5, Np6, Np2, Np8, Np4, Np7, Np1, Ns3, Ns5, Ns6, Ns2, Ns8, Ns4, Ns7, Ns1 [coppe_real] = imported_body(D:\Karl,reverseengineer\core_assembled_flatwise.step)
  plate_1, plate_2 [silicon_TIMreal] = imported_body(D:\Karl,reverseengineer\core_assembled_flatwise.step)
  Region [vacuum] = region(percentage_offset=0 on all sides)
  Ns8_Section1 [coppe_real] = Ns8.section(plane=ZX)
  Np1_Section1 [coppe_real] = Np1.section(plane=ZX)
  Np2_Section1 [coppe_real] = Np2.section(plane=ZX)
  Np3_Section1 [coppe_real] = Np3.section(plane=ZX)
  Np4_Section1 [coppe_real] = Np4.section(plane=ZX)
  Np5_Section1 [coppe_real] = Np5.section(plane=ZX)
  Np6_Section1 [coppe_real] = Np6.section(plane=ZX)
  Np7_Section1 [coppe_real] = Np7.section(plane=ZX)
  Np8_Section1 [coppe_real] = Np8.section(plane=ZX)
  Ns1_Section1 [coppe_real] = Ns1.section(plane=ZX)
  Ns2_Section1 [coppe_real] = Ns2.section(plane=ZX)
  Ns3_Section1 [coppe_real] = Ns3.section(plane=ZX)
  Ns4_Section1 [coppe_real] = Ns4.section(plane=ZX)
  Ns5_Section1 [coppe_real] = Ns5.section(plane=ZX)
  Ns6_Section1 [coppe_real] = Ns6.section(plane=ZX)
  Ns7_Section1 [coppe_real] = Ns7.section(plane=ZX)
  Ns8_Section1.separate_bodies()
  Np1_Section1.separate_bodies()
  Np2_Section1.separate_bodies()
  Np3_Section1.separate_bodies()
  Np4_Section1.separate_bodies()
  Np5_Section1.separate_bodies()
  Np6_Section1.separate_bodies()
  Np7_Section1.separate_bodies()
  Np8_Section1.separate_bodies()
  Ns1_Section1.separate_bodies()
  Ns2_Section1.separate_bodies()
  Ns3_Section1.separate_bodies()
  Ns4_Section1.separate_bodies()
  Ns5_Section1.separate_bodies()
  Ns6_Section1.separate_bodies()
  Ns7_Section1.separate_bodies()
  [Body1, Body1_1..Body1_5, Np3, Np5, Np6, Np2, Np8, Np4, Np7, Np1, Ns3, Ns5, Ns6, Ns2, Ns8, Ns4, Ns7, Ns1, plate_1, plate_2, Ns8_Section1, Np1_Section1, Np2_Section1, Np3_Section1, Np4_Section1, Np5_Section1, Np6_Section1, Np7_Section1, Np8_Section1, Ns1_Section1, Ns2_Section1, Ns3_Section1, Ns4_Section1, Ns5_Section1, Ns6_Section1, Ns7_Section1].move(-28.7mm, -25.45mm, -13.7mm)
  [Body1, Body1_1..Body1_5, Np3, Np5, Np6, Np2, Np8, Np4, Np7, Np1, Ns3, Ns5, Ns6, Ns2, Ns8, Ns4, Ns7, Ns1, plate_1, plate_2, Ns8_Section1, Np1_Section1, Np2_Section1, Np3_Section1, Np4_Section1, Np5_Section1, Np6_Section1, Np7_Section1, Np8_Section1, Ns1_Section1, Ns2_Section1, Ns3_Section1, Ns4_Section1, Ns5_Section1, Ns6_Section1, Ns7_Section1].move(9.4mm, -25.45mm, 9.7178433mm)
  [Body1, Body1_1..Body1_5, Np3, Np5, Np6, Np2, Np8, Np4, Np7, Np1, Ns3, Ns5, Ns6, Ns2, Ns8, Ns4, Ns7, Ns1, plate_1, plate_2, Ns8_Section1, Np1_Section1, Np2_Section1, Np3_Section1, Np4_Section1, Np5_Section1, Np6_Section1, Np7_Section1, Np8_Section1, Ns1_Section1, Ns2_Section1, Ns3_Section1, Ns4_Section1, Ns5_Section1, Ns6_Section1, Ns7_Section1].move(0mm, 25.45mm, -5.4178433mm)
  group core_togetherv4 = Body1, Body1_1, Body1_2
  group core_togetherv41 = Body1_3, Body1_4, Body1_5
  group Wire_face_flatwise_newv8 = Np3, Np5, Np6, Np2, Np8, Np4, Np7, Np1, Ns3, Ns5, Ns6, Ns2, Ns8, Ns4, Ns7, Ns1, plate_1, plate_2, Ns8_Section1, Np1_Section1, Np2_Section1, Np3_Section1, Np4_Section1, Np5_Section1, Np6_Section1, Np7_Section1, Np8_Section1, Ns1_Section1, Ns2_Section1, Ns3_Section1, Ns4_Section1, Ns5_Section1, Ns6_Section1, Ns7_Section1
boundaries and excitations:
  CoilTerminal_1: Coil Terminal Objects=Np1_Section1 Conductor_number=1 Winding=Np Point_out_of_terminal=false
  CoilTerminal_2: Coil Terminal Objects=Np2_Section1 Conductor_number=1 Winding=Np Point_out_of_terminal=false
  CoilTerminal_3: Coil Terminal Objects=Np3_Section1 Conductor_number=1 Winding=Np Point_out_of_terminal=false
  CoilTerminal_4: Coil Terminal Objects=Np4_Section1 Conductor_number=1 Winding=Np Point_out_of_terminal=false
  CoilTerminal_5: Coil Terminal Objects=Np5_Section1 Conductor_number=1 Winding=Np Point_out_of_terminal=false
  CoilTerminal_6: Coil Terminal Objects=Np6_Section1 Conductor_number=1 Winding=Np Point_out_of_terminal=false
  CoilTerminal_7: Coil Terminal Objects=Np7_Section1 Conductor_number=1 Winding=Np Point_out_of_terminal=false
  CoilTerminal_8: Coil Terminal Objects=Np8_Section1 Conductor_number=1 Winding=Np Point_out_of_terminal=false
  CoilTerminal_9: Coil Terminal Objects=Ns1_Section1 Conductor_number=1 Winding=Ns Point_out_of_terminal=true
  CoilTerminal_10: Coil Terminal Objects=Ns2_Section1 Conductor_number=1 Winding=Ns Point_out_of_terminal=true
  CoilTerminal_11: Coil Terminal Objects=Ns3_Section1 Conductor_number=1 Winding=Ns Point_out_of_terminal=true
  CoilTerminal_12: Coil Terminal Objects=Ns4_Section1 Conductor_number=1 Winding=Ns Point_out_of_terminal=true
  CoilTerminal_13: Coil Terminal Objects=Ns5_Section1 Conductor_number=1 Winding=Ns Point_out_of_terminal=true
  CoilTerminal_14: Coil Terminal Objects=Ns6_Section1 Conductor_number=1 Winding=Ns Point_out_of_terminal=true
  CoilTerminal_15: Coil Terminal Objects=Ns7_Section1 Conductor_number=1 Winding=Ns Point_out_of_terminal=true
  CoilTerminal_16: Coil Terminal Objects=Ns8_Section1 Conductor_number=1 Winding=Ns Point_out_of_terminal=true
  Np: Winding Group Type=Voltage IsSolid=true Current=16.36A Resistance=0ohm Inductance=0nH Voltage=volt_ac ParallelBranchesNum=1 Phase=0rad
  Ns: Winding Group Type=Current IsSolid=true Current=1000*1.41/volt_ac*1.414 ParallelBranchesNum=1 Phase=0.1522rad
  eddy effects on: Body1, Body1_1, Body1_3, Body1_4, Np3, Np5, Np6, Np2, Np8, Np4, Np7, Np1, Ns3, Ns5, Ns6, Ns2, Ns8, Ns4, Ns7, Ns1
  core loss on: Body1_2, Body1_5
parameters:
  Matrix1: Matrix Np, Ns:
mesh:
  SkinDepth1: SkinDepthBased Objects=[Np1..Np8, Ns1..Ns8] SkinDepth=0.20567444mm SurfTriMaxLength=1mm NumLayers=2
  Length1: LengthBased Objects=[Body1, Body1_1..Body1_5, plate_1, plate_2] MaxLength=2mm
  initial mesh: GlobalSurfApproximation{CurvedSurfaceApproxChoice=UseSlider SliderMeshSettings=9} GlobalCurvilinear{Apply}
setups:
  Setup1: EddyCurrent MaximumPasses=20 MinimumPasses=4 MinimumConvergedPasses=1 PercentRefinement=30 PercentError=1 NonLinearResidual=0.0001 SmoothBHCurve Frequency=100kHz SweepRanges{point 28500Hz} SaveAllFields
reports:
  L Table 1: Matrix1.L(Np,Np), Matrix1.L(Ns,Np), Matrix1.L(Np,Ns), Matrix1.L(Ns,Ns), Matrix1.R(Np,Np), Matrix1.R(Ns,Np), Matrix1.R(Np,Ns), Matrix1.R(Ns,Ns) vs Freq on Setup1 : LastAdaptive

design Flatwise_0.30_interleaved_new2 (Maxwell 3D, EddyCurrent, model units mm)
variables:
  freq_hz = 28500Hz
  volt_ac = 141/28500*Freq
geometry:
  Body1, Body1_1 [aluminum_real] = imported_body(D:\Karl,reverseengineer\core_assembled_flatwise.step)
  Body1_2 [ferrite - real] = imported_body(D:\Karl,reverseengineer\core_assembled_flatwise.step)
  Body1_3, Body1_4 [aluminum_real] = imported_body(D:\Karl,reverseengineer\core_assembled_flatwise.step)
  Body1_5 [ferrite - real] = imported_body(D:\Karl,reverseengineer\core_assembled_flatwise.step)
  Np3, Np5, Np6, Np2, Np8, Np4, Np7, Np1, Ns3, Ns5, Ns6, Ns2, Ns8, Ns4, Ns7, Ns1 [coppe_real] = imported_body(D:\Karl,reverseengineer\core_assembled_flatwise.step)
  plate_1, plate_2 [silicon_TIMreal] = imported_body(D:\Karl,reverseengineer\core_assembled_flatwise.step)
  Region [vacuum] = region(percentage_offset=0 on all sides)
  Ns8_Section1 [coppe_real] = Ns8.section(plane=ZX)
  Np1_Section1 [coppe_real] = Np1.section(plane=ZX)
  Np2_Section1 [coppe_real] = Np2.section(plane=ZX)
  Np3_Section1 [coppe_real] = Np3.section(plane=ZX)
  Np4_Section1 [coppe_real] = Np4.section(plane=ZX)
  Np5_Section1 [coppe_real] = Np5.section(plane=ZX)
  Np6_Section1 [coppe_real] = Np6.section(plane=ZX)
  Np7_Section1 [coppe_real] = Np7.section(plane=ZX)
  Np8_Section1 [coppe_real] = Np8.section(plane=ZX)
  Ns1_Section1 [coppe_real] = Ns1.section(plane=ZX)
  Ns2_Section1 [coppe_real] = Ns2.section(plane=ZX)
  Ns3_Section1 [coppe_real] = Ns3.section(plane=ZX)
  Ns4_Section1 [coppe_real] = Ns4.section(plane=ZX)
  Ns5_Section1 [coppe_real] = Ns5.section(plane=ZX)
  Ns6_Section1 [coppe_real] = Ns6.section(plane=ZX)
  Ns7_Section1 [coppe_real] = Ns7.section(plane=ZX)
  Ns8_Section1.separate_bodies()
  Np1_Section1.separate_bodies()
  Np2_Section1.separate_bodies()
  Np3_Section1.separate_bodies()
  Np4_Section1.separate_bodies()
  Np5_Section1.separate_bodies()
  Np6_Section1.separate_bodies()
  Np7_Section1.separate_bodies()
  Np8_Section1.separate_bodies()
  Ns1_Section1.separate_bodies()
  Ns2_Section1.separate_bodies()
  Ns3_Section1.separate_bodies()
  Ns4_Section1.separate_bodies()
  Ns5_Section1.separate_bodies()
  Ns6_Section1.separate_bodies()
  Ns7_Section1.separate_bodies()
  Rectangle1 [non-model] = rectangle(corner=(0mm, 25.45mm, 0mm), z_size=18.7mm, x_size=38.6mm)
  group core_togetherv4 = Body1, Body1_1, Body1_2
  group core_togetherv41 = Body1_3, Body1_4, Body1_5
  group Wire_face_flatwise_newv8 = Np3, Np5, Np6, Np2, Np8, Np4, Np7, Np1, Ns3, Ns5, Ns6, Ns2, Ns8, Ns4, Ns7, Ns1, plate_1, plate_2, Ns8_Section1, Np1_Section1, Np2_Section1, Np3_Section1, Np4_Section1, Np5_Section1, Np6_Section1, Np7_Section1, Np8_Section1, Ns1_Section1, Ns2_Section1, Ns3_Section1, Ns4_Section1, Ns5_Section1, Ns6_Section1, Ns7_Section1
boundaries and excitations:
  CoilTerminal_1: Coil Terminal Objects=Np1_Section1 Conductor_number=1 Winding=Np Point_out_of_terminal=false
  CoilTerminal_2: Coil Terminal Objects=Np2_Section1 Conductor_number=1 Winding=Np Point_out_of_terminal=false
  CoilTerminal_3: Coil Terminal Objects=Np3_Section1 Conductor_number=1 Winding=Np Point_out_of_terminal=false
  CoilTerminal_4: Coil Terminal Objects=Np4_Section1 Conductor_number=1 Winding=Np Point_out_of_terminal=false
  CoilTerminal_5: Coil Terminal Objects=Np5_Section1 Conductor_number=1 Winding=Np Point_out_of_terminal=false
  CoilTerminal_6: Coil Terminal Objects=Np6_Section1 Conductor_number=1 Winding=Np Point_out_of_terminal=false
  CoilTerminal_7: Coil Terminal Objects=Np7_Section1 Conductor_number=1 Winding=Np Point_out_of_terminal=false
  CoilTerminal_8: Coil Terminal Objects=Np8_Section1 Conductor_number=1 Winding=Np Point_out_of_terminal=false
  CoilTerminal_9: Coil Terminal Objects=Ns1_Section1 Conductor_number=1 Winding=Ns Point_out_of_terminal=true
  CoilTerminal_10: Coil Terminal Objects=Ns2_Section1 Conductor_number=1 Winding=Ns Point_out_of_terminal=true
  CoilTerminal_11: Coil Terminal Objects=Ns3_Section1 Conductor_number=1 Winding=Ns Point_out_of_terminal=true
  CoilTerminal_12: Coil Terminal Objects=Ns4_Section1 Conductor_number=1 Winding=Ns Point_out_of_terminal=true
  CoilTerminal_13: Coil Terminal Objects=Ns5_Section1 Conductor_number=1 Winding=Ns Point_out_of_terminal=true
  CoilTerminal_14: Coil Terminal Objects=Ns6_Section1 Conductor_number=1 Winding=Ns Point_out_of_terminal=true
  CoilTerminal_15: Coil Terminal Objects=Ns7_Section1 Conductor_number=1 Winding=Ns Point_out_of_terminal=true
  CoilTerminal_16: Coil Terminal Objects=Ns8_Section1 Conductor_number=1 Winding=Ns Point_out_of_terminal=true
  Np: Winding Group Type=Voltage IsSolid=true Current=16.36A Resistance=0ohm Inductance=0nH Voltage=volt_ac ParallelBranchesNum=1 Phase=0rad
  Ns: Winding Group Type=Current IsSolid=true Current=1000*1.41/volt_ac*1.414 ParallelBranchesNum=1 Phase=0.1522rad
  eddy effects on: Body1, Body1_1, Body1_3, Body1_4, Np3, Np5, Np6, Np2, Np8, Np4, Np7, Np1, Ns3, Ns5, Ns6, Ns2, Ns8, Ns4, Ns7, Ns1
  core loss on: Body1_2, Body1_5
parameters:
  Matrix1: Matrix Np, Ns:
mesh:
  SkinDepth1: SkinDepthBased disabled Objects=[Np1..Np8, Ns1..Ns8] SkinDepth=0.20567444mm SurfTriMaxLength=1mm NumLayers=2
  Length1: LengthBased disabled Objects=[Body1, Body1_1..Body1_5, plate_1, plate_2] MaxLength=2mm
  EdgeCut1: EdgeCutLayerMesh Objects=[Body1, Body1_1..Body1_5, Np3, Np5, Np6, Np2, Np8, Np4, Np7, Np1, Ns3, Ns5, Ns6, Ns2, Ns8, Ns4, Ns7, Ns1, plate_1, plate_2, Ns8_Section1, Np1_Section1, Np2_Section1, Np3_Section1, Np4_Section1, Np5_Section1, Np6_Section1, Np7_Section1, Np8_Section1, Ns1_Section1, Ns2_Section1, Ns3_Section1, Ns4_Section1, Ns5_Section1, Ns6_Section1, Ns7_Section1] Layer_Thickenss=0.3mm
  initial mesh: GlobalSurfApproximation{CurvedSurfaceApproxChoice=UseSlider SliderMeshSettings=9} GlobalCurvilinear{Apply}
setups:
  Setup1: EddyCurrent MaximumPasses=20 MinimumPasses=4 MinimumConvergedPasses=1 PercentRefinement=30 PercentError=1 NonLinearResidual=0.0001 SmoothBHCurve Frequency=100kHz SweepRanges{point 28500Hz} SaveAllFields
field plots:
  Mesh1: MeshPlots on Setup1 : LastAdaptive at Freq=28500Hz Phase=0deg
  Mesh2: MeshPlots over a plane on Setup1 : LastAdaptive at Freq=28500Hz Phase=0deg
reports:
  L Table 1: Matrix1.L(Np,Np), Matrix1.L(Ns,Np), Matrix1.L(Np,Ns), Matrix1.L(Ns,Ns), Matrix1.R(Np,Np), Matrix1.R(Ns,Np), Matrix1.R(Np,Ns), Matrix1.R(Ns,Ns) vs Freq on Setup1 : LastAdaptive

design Maxwell2DDesign4 (Maxwell 2D, Electrostatic, about Z geometry, model units mm)
geometry:
  Body1_2#36218, Body1_5#36398, Np3#36474, Np5#36526, Np6#36578, Np2#36630, Np8#36682, Np4#36734, Np7#36786, Np1#36838, Ns3#36890, Ns5#36942, Ns6#36994, Ns2#37046, Ns8#37098, Ns4#37150, Ns7#37202, Ns1#37254, plate_1#37306, plate_2#37358 = imported_body(D:\Karl,reverseengineer\core_assembled_flatwise.step)
  Region [vacuum] = region(percentage_offset=0 on all sides)
  [Body1_2#36218, Body1_5#36398, Np3#36474, Np5#36526, Np6#36578, Np2#36630, Np8#36682, Np4#36734, Np7#36786, Np1#36838, Ns3#36890, Ns5#36942, Ns6#36994, Ns2#37046, Ns8#37098, Ns4#37150, Ns7#37202, Ns1#37254, plate_1#37306, plate_2#37358].move(-28.7mm, -25.45mm, -13.7mm)
  [Body1_2#36218, Body1_5#36398, Np3#36474, Np5#36526, Np6#36578, Np2#36630, Np8#36682, Np4#36734, Np7#36786, Np1#36838, Ns3#36890, Ns5#36942, Ns6#36994, Ns2#37046, Ns8#37098, Ns4#37150, Ns7#37202, Ns1#37254, plate_1#37306, plate_2#37358].move(9.4mm, -25.45mm, 9.7178433mm)
  [Body1_2#36218, Body1_5#36398, Np3#36474, Np5#36526, Np6#36578, Np2#36630, Np8#36682, Np4#36734, Np7#36786, Np1#36838, Ns3#36890, Ns5#36942, Ns6#36994, Ns2#37046, Ns8#37098, Ns4#37150, Ns7#37202, Ns1#37254, plate_1#37306, plate_2#37358].move(0mm, 25.45mm, -5.4178433mm)
  Body1_2 [ferrite - real] = Body1_2#36218.section(plane=ZX)
  Body1_2#36218.delete()
  Body1_5 [ferrite - real] = Body1_5#36398.section(plane=ZX)
  Body1_5#36398.delete()
  Np3 [coppe_real] = Np3#36474.section(plane=ZX)
  Np3#36474.delete()
  Np5 [coppe_real] = Np5#36526.section(plane=ZX)
  Np5#36526.delete()
  Np6 [coppe_real] = Np6#36578.section(plane=ZX)
  Np6#36578.delete()
  Np2 [coppe_real] = Np2#36630.section(plane=ZX)
  Np2#36630.delete()
  Np8 [coppe_real] = Np8#36682.section(plane=ZX)
  Np8#36682.delete()
  Np4 [coppe_real] = Np4#36734.section(plane=ZX)
  Np4#36734.delete()
  Np7 [coppe_real] = Np7#36786.section(plane=ZX)
  Np7#36786.delete()
  Np1 [coppe_real] = Np1#36838.section(plane=ZX)
  Np1#36838.delete()
  Ns3 [coppe_real] = Ns3#36890.section(plane=ZX)
  Ns3#36890.delete()
  Ns5 [coppe_real] = Ns5#36942.section(plane=ZX)
  Ns5#36942.delete()
  Ns6 [coppe_real] = Ns6#36994.section(plane=ZX)
  Ns6#36994.delete()
  Ns2 [coppe_real] = Ns2#37046.section(plane=ZX)
  Ns2#37046.delete()
  Ns8 [coppe_real] = Ns8#37098.section(plane=ZX)
  Ns8#37098.delete()
  Ns4 [coppe_real] = Ns4#37150.section(plane=ZX)
  Ns4#37150.delete()
  Ns7 [coppe_real] = Ns7#37202.section(plane=ZX)
  Ns7#37202.delete()
  Ns1 [coppe_real] = Ns1#37254.section(plane=ZX)
  Ns1#37254.delete()
  plate_1 [silicon_TIMreal] = plate_1#37306.section(plane=ZX)
  plate_1#37306.delete()
  plate_2 [silicon_TIMreal] = plate_2#37358.section(plane=ZX)
  plate_2#37358.delete()
  [Body1_2, Body1_5, Np3, Np5, Np6, Np2, Np8, Np4, Np7, Np1, Ns3, Ns5, Ns6, Ns2, Ns8, Ns4, Ns7, Ns1, plate_1, plate_2].move(19.3mm, 0mm, 9.4mm)
  group core_togetherv4 = Body1_2
  group core_togetherv41 = Body1_5
  group Wire_face_flatwise_newv8 = Np3, Np5, Np6, Np2, Np8, Np4, Np7, Np1, Ns3, Ns5, Ns6, Ns2, Ns8, Ns4, Ns7, Ns1, plate_1, plate_2
mesh:
  EdgeCut1: EdgeCutLayerMesh Objects=[Body1_5, Region, Body1_2, Np3, Np5, Np6, Np2, Np8, Np4, Np7, Np1, Ns3, Ns5, Ns6, Ns2, Ns8, Ns4, Ns7, Ns1, plate_1, plate_2] Layer_Thickenss=0.01mm
  initial mesh: GlobalSurfApproximation{CurvedSurfaceApproxChoice=UseSlider SliderMeshSettings=9}
setups:
  Setup1: Electrostatic MaximumPasses=20 MinimumPasses=5 MinimumConvergedPasses=1 PercentRefinement=30 PercentError=1 NonLinearResidual=0.001
field plots:
  Mesh1: MeshPlots over Region, Body1_2, Body1_5, Np3, Np5, Np6, Np2, Np8, Np4, Np7, Np1, Ns3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 on Setup1 : LastAdaptive

design [Thermal]Flatwise_0.3_fix (Icepak, SteadyState TemperatureAndFlow, model units mm)
options: Default_Fluid_Material=air Default_Solid_Material=Al-Extruded Default_Surface_Material=Steel-oxidised-surface AmbientTemperature=25cel AmbientPressure=0n_per_meter_sq AmbientRadiationTemperature=25cel Gravity_Vector_CS_ID=Global Gravity_Vector_Axis=Z Positive=false SherlockExportDirectory=C:/Users/karlr/Documents/Ansoft/1kW_Final.aedtexport/[Thermal]8turns_3D_CoreLoss_FullInterleaved_Flatwise/ Altitude=0meter
geometry:
  Region [air] = region(percentage_offset=1000 on all sides)
  Body1, Body1_1 [aluminum_real] = imported_body(D:\Karl,reverseengineer\core_assembled_flatwise.step)
  Body1_2 [ferrite - real2] = imported_body(D:\Karl,reverseengineer\core_assembled_flatwise.step)
  Body1_3, Body1_4 [aluminum_real] = imported_body(D:\Karl,reverseengineer\core_assembled_flatwise.step)
  Body1_5 [ferrite - real2] = imported_body(D:\Karl,reverseengineer\core_assembled_flatwise.step)
  Np3 [coppe_real] = imported_body(D:\Karl,reverseengineer\core_assembled_flatwise.step)
  Np5 [coppe_real] = imported_body(D:\Karl,reverseengineer\core_assembled_flatwise.step)
  Np6 [coppe_real] = imported_body(D:\Karl,reverseengineer\core_assembled_flatwise.step)
  Np2 [coppe_real] = imported_body(D:\Karl,reverseengineer\core_assembled_flatwise.step)
  Np8 [coppe_real] = imported_body(D:\Karl,reverseengineer\core_assembled_flatwise.step)
  Np4 [coppe_real] = imported_body(D:\Karl,reverseengineer\core_assembled_flatwise.step)
  Np7 [coppe_real] = imported_body(D:\Karl,reverseengineer\core_assembled_flatwise.step)
  Np1 [coppe_real] = imported_body(D:\Karl,reverseengineer\core_assembled_flatwise.step)
  Ns3 [coppe_real] = imported_body(D:\Karl,reverseengineer\core_assembled_flatwise.step)
  Ns5 [coppe_real] = imported_body(D:\Karl,reverseengineer\core_assembled_flatwise.step)
  Ns6 [coppe_real] = imported_body(D:\Karl,reverseengineer\core_assembled_flatwise.step)
  Ns2 [coppe_real] = imported_body(D:\Karl,reverseengineer\core_assembled_flatwise.step)
  Ns8 [coppe_real] = imported_body(D:\Karl,reverseengineer\core_assembled_flatwise.step)
  Ns4 [coppe_real] = imported_body(D:\Karl,reverseengineer\core_assembled_flatwise.step)
  Ns7 [coppe_real] = imported_body(D:\Karl,reverseengineer\core_assembled_flatwise.step)
  Ns1 [coppe_real] = imported_body(D:\Karl,reverseengineer\core_assembled_flatwise.step)
  plate_1, plate_2 [silicon_TIMreal] = imported_body(D:\Karl,reverseengineer\core_assembled_flatwise.step)
  group core_togetherv4 = Body1, Body1_1, Body1_2
  group core_togetherv41 = Body1_3, Body1_4, Body1_5
  group Wire_face_flatwise_newv8 = Np3, Np5, Np6, Np2, Np8, Np4, Np7, Np1, Ns3, Ns5, Ns6, Ns2, Ns8, Ns4, Ns7, Ns1, plate_1, plate_2
boundaries and excitations:
  Opening1: Opening Faces=Region.face(-y) Temperature=AmbientTemp External_Rad._Temperature=AmbientRadTemp Inlet_Type=Pressure Total_Pressure=AmbientPressure
  Opening2: Opening Faces=Region.face(+y) Temperature=AmbientTemp External_Rad._Temperature=AmbientRadTemp Inlet_Type=Velocity Static_Pressure=AmbientPressure X_Velocity=0m_per_sec Y_Velocity=0m_per_sec Z_Velocity=0m_per_sec
  EMLoss1: EM Loss Objects=[Np1..Np8, Ns1..Ns8, Body1_5, Body1_3, Body1_4, Body1, Body1_1, Body1_2] LinkID=483 Project="This Project*" Product=ElectronicsDesktop Design=Flatwise_0.30_interleaved_new Params{freq_hz=28500Hz} ForceSourceToSolve PreservePartnerSoln PathRelativeTo=TargetProject Intrinsics(28.5kHz) LossMultiplier=1
mesh:
  MeshRegions:  Global{MeshMethod=MesherHD ComputeGap MeshRegionResolution=5 MinGapX=1mm MinGapY=1mm MinGapZ=1mm Objects=Region FacetLevel=5 ProximitySizeFunction CurvatureSizeFunction OptimizePCBMesh}
  MeshOperations:
setups:
  Setup1: IcepakSteadyState Flow_Regime=Laminar Include_Temperature=true Include_Flow=true Include_Gravity Solution_Initialization_-_Z_Velocity=0.000980665m_per_sec Convergence_Criteria_-_Flow=0.001 Convergence_Criteria_-_Energy=1e-07 Convergence_Criteria_-_Discrete_Ordinates=1e-06 Radiation_Model="Discrete Ordinates Model" Flow_Iteration_Per_Radiation_Iteration=10 ThetaDivision=2 PhiDivision=2 ThetaPixels=2 PhiPixels=2 Under-relaxation_-_Pressure=0.7 Under-relaxation_-_Momentum=0.3 Under-relaxation_-_Temperature=1 Discretization_Scheme_-_Pressure=Standard Discretization_Scheme_-_Momentum=First Discretization_Scheme_-_Temperature=First Discretization_Scheme_-_Discrete_Ordinates=First Convergence_Criteria_-_Max_Iterations=10000
field plots:
  Temperature1: Temperature over Body1, Body1_1..Body1_5, Np3, Np5, Np6, Np2, Np8, Np4, Np7, Np1, Ns3, Ns5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 on Setup1 : SteadyState

design [Thermal]Edgewise_0.3_fix (Icepak, SteadyState TemperatureAndFlow, model units mm)
options: Default_Fluid_Material=air Default_Solid_Material=Al-Extruded Default_Surface_Material=Steel-oxidised-surface AmbientTemperature=25cel AmbientPressure=0n_per_meter_sq AmbientRadiationTemperature=25cel Gravity_Vector_CS_ID=Global Gravity_Vector_Axis=Z Positive=false SherlockExportDirectory=C:/Users/karlr/Documents/Ansoft/1kW_Final.aedtexport/[Thermal]8turns_3D_CoreLoss_FullInterleaved_Flatwise/ Altitude=0meter
geometry:
  Region [air] = region(percentage_offset=1000 on all sides)
  Body1 [ferrite - real2] = imported_body(D:\Karl,reverseengineer\core_assembled_edgewise.step)
  Body1_1, Body1_2 [aluminum_real] = imported_body(D:\Karl,reverseengineer\core_assembled_edgewise.step)
  Body1_3 [ferrite - real2] = imported_body(D:\Karl,reverseengineer\core_assembled_edgewise.step)
  Body1_4, Body1_5 [aluminum_real] = imported_body(D:\Karl,reverseengineer\core_assembled_edgewise.step)
  Np6 [coppe_real] = imported_body(D:\Karl,reverseengineer\core_assembled_edgewise.step)
  Np2 [coppe_real] = imported_body(D:\Karl,reverseengineer\core_assembled_edgewise.step)
  Np3 [coppe_real] = imported_body(D:\Karl,reverseengineer\core_assembled_edgewise.step)
  Np7 [coppe_real] = imported_body(D:\Karl,reverseengineer\core_assembled_edgewise.step)
  Np5 [coppe_real] = imported_body(D:\Karl,reverseengineer\core_assembled_edgewise.step)
  Np1 [coppe_real] = imported_body(D:\Karl,reverseengineer\core_assembled_edgewise.step)
  Np4 [coppe_real] = imported_body(D:\Karl,reverseengineer\core_assembled_edgewise.step)
  Np8 [coppe_real] = imported_body(D:\Karl,reverseengineer\core_assembled_edgewise.step)
  Ns6 [coppe_real] = imported_body(D:\Karl,reverseengineer\core_assembled_edgewise.step)
  Ns2 [coppe_real] = imported_body(D:\Karl,reverseengineer\core_assembled_edgewise.step)
  Ns3 [coppe_real] = imported_body(D:\Karl,reverseengineer\core_assembled_edgewise.step)
  Ns7 [coppe_real] = imported_body(D:\Karl,reverseengineer\core_assembled_edgewise.step)
  Ns5 [coppe_real] = imported_body(D:\Karl,reverseengineer\core_assembled_edgewise.step)
  Ns1 [coppe_real] = imported_body(D:\Karl,reverseengineer\core_assembled_edgewise.step)
  Ns4 [coppe_real] = imported_body(D:\Karl,reverseengineer\core_assembled_edgewise.step)
  Ns8 [coppe_real] = imported_body(D:\Karl,reverseengineer\core_assembled_edgewise.step)
  plate2, plate1 [silicon_TIMreal] = imported_body(D:\Karl,reverseengineer\core_assembled_edgewise.step)
  group core_togetherv4 = Body1, Body1_1, Body1_2
  group core_togetherv41 = Body1_3, Body1_4, Body1_5
  group Wire_face_edgewisaev15 = Np6, Np2, Np3, Np7, Np5, Np1, Np4, Np8, Ns6, Ns2, Ns3, Ns7, Ns5, Ns1, Ns4, Ns8, plate2, plate1
boundaries and excitations:
  Opening1: Opening Faces=Region.face(-y) Temperature=AmbientTemp External_Rad._Temperature=AmbientRadTemp Inlet_Type=Pressure Total_Pressure=AmbientPressure
  Opening2: Opening Faces=Region.face(+y) Temperature=AmbientTemp External_Rad._Temperature=AmbientRadTemp Inlet_Type=Velocity Static_Pressure=AmbientPressure X_Velocity=0m_per_sec Y_Velocity=0m_per_sec Z_Velocity=0m_per_sec
  EMLoss1: EM Loss Objects=[Np1..Np8, Ns1..Ns8, Body1_1, Body1_2, Body1, Body1_4, Body1_5, Body1_3] LinkID=498 Project="This Project*" Product=ElectronicsDesktop Design=Edgewise_0.30_interleaved_new Params{freq_hz=28500Hz} ForceSourceToSolve PreservePartnerSoln PathRelativeTo=TargetProject Intrinsics(28.5kHz) LossMultiplier=1
mesh:
  MeshRegions:  Global{MeshMethod=MesherHD ComputeGap MeshRegionResolution=5 MinGapX=1mm MinGapY=1mm MinGapZ=1mm Objects=Region FacetLevel=5 ProximitySizeFunction CurvatureSizeFunction OptimizePCBMesh}
  MeshOperations:
setups:
  Setup1: IcepakSteadyState Flow_Regime=Laminar Include_Temperature=true Include_Flow=true Include_Gravity Solution_Initialization_-_Z_Velocity=0.000980665m_per_sec Convergence_Criteria_-_Flow=0.001 Convergence_Criteria_-_Energy=1e-07 Convergence_Criteria_-_Discrete_Ordinates=1e-06 Radiation_Model="Discrete Ordinates Model" Flow_Iteration_Per_Radiation_Iteration=10 ThetaDivision=2 PhiDivision=2 ThetaPixels=2 PhiPixels=2 Under-relaxation_-_Pressure=0.7 Under-relaxation_-_Momentum=0.3 Under-relaxation_-_Temperature=1 Discretization_Scheme_-_Pressure=Standard Discretization_Scheme_-_Momentum=First Discretization_Scheme_-_Temperature=First Discretization_Scheme_-_Discrete_Ordinates=First Convergence_Criteria_-_Max_Iterations=10000

design [Thermal]Flatwise_0.3_fix1 (Icepak, SteadyState TemperatureAndFlow, model units mm)
options: Default_Fluid_Material=air Default_Solid_Material=Al-Extruded Default_Surface_Material=Steel-oxidised-surface AmbientTemperature=25cel AmbientPressure=0n_per_meter_sq AmbientRadiationTemperature=25cel Gravity_Vector_CS_ID=Global Gravity_Vector_Axis=Z Positive=false SherlockExportDirectory=C:/Users/karlr/Documents/Ansoft/1kW_Final.aedtexport/[Thermal]8turns_3D_CoreLoss_FullInterleaved_Flatwise/ Altitude=0meter
geometry:
  Region [air] = region(percentage_offset=1000 on all sides)
  Body1, Body1_1 [aluminum_real] = imported_body(D:\Karl,reverseengineer\core_assembled_flatwise.step)
  Body1_2 [ferrite - real2] = imported_body(D:\Karl,reverseengineer\core_assembled_flatwise.step)
  Body1_3, Body1_4 [aluminum_real] = imported_body(D:\Karl,reverseengineer\core_assembled_flatwise.step)
  Body1_5 [ferrite - real2] = imported_body(D:\Karl,reverseengineer\core_assembled_flatwise.step)
  Np3 [coppe_real] = imported_body(D:\Karl,reverseengineer\core_assembled_flatwise.step)
  Np5 [coppe_real] = imported_body(D:\Karl,reverseengineer\core_assembled_flatwise.step)
  Np6 [coppe_real] = imported_body(D:\Karl,reverseengineer\core_assembled_flatwise.step)
  Np2 [coppe_real] = imported_body(D:\Karl,reverseengineer\core_assembled_flatwise.step)
  Np8 [coppe_real] = imported_body(D:\Karl,reverseengineer\core_assembled_flatwise.step)
  Np4 [coppe_real] = imported_body(D:\Karl,reverseengineer\core_assembled_flatwise.step)
  Np7 [coppe_real] = imported_body(D:\Karl,reverseengineer\core_assembled_flatwise.step)
  Np1 [coppe_real] = imported_body(D:\Karl,reverseengineer\core_assembled_flatwise.step)
  Ns3 [coppe_real] = imported_body(D:\Karl,reverseengineer\core_assembled_flatwise.step)
  Ns5 [coppe_real] = imported_body(D:\Karl,reverseengineer\core_assembled_flatwise.step)
  Ns6 [coppe_real] = imported_body(D:\Karl,reverseengineer\core_assembled_flatwise.step)
  Ns2 [coppe_real] = imported_body(D:\Karl,reverseengineer\core_assembled_flatwise.step)
  Ns8 [coppe_real] = imported_body(D:\Karl,reverseengineer\core_assembled_flatwise.step)
  Ns4 [coppe_real] = imported_body(D:\Karl,reverseengineer\core_assembled_flatwise.step)
  Ns7 [coppe_real] = imported_body(D:\Karl,reverseengineer\core_assembled_flatwise.step)
  Ns1 [coppe_real] = imported_body(D:\Karl,reverseengineer\core_assembled_flatwise.step)
  plate_1 [silicon_TIMreal] = imported_body(D:\Karl,reverseengineer\core_assembled_flatwise.step)
  group core_togetherv4 = Body1, Body1_1, Body1_2
  group core_togetherv41 = Body1_3, Body1_4, Body1_5
  group Wire_face_flatwise_newv8 = Np3, Np5, Np6, Np2, Np8, Np4, Np7, Np1, Ns3, Ns5, Ns6, Ns2, Ns8, Ns4, Ns7, Ns1, plate_1
boundaries and excitations:
  Opening1: Opening Faces=Region.face(-y) Temperature=AmbientTemp External_Rad._Temperature=AmbientRadTemp Inlet_Type=Pressure Total_Pressure=AmbientPressure
  Opening2: Opening Faces=Region.face(+y) Temperature=AmbientTemp External_Rad._Temperature=AmbientRadTemp Inlet_Type=Velocity Static_Pressure=AmbientPressure X_Velocity=0m_per_sec Y_Velocity=0m_per_sec Z_Velocity=0m_per_sec
  EMLoss1: EM Loss Objects=[Np1..Np8, Ns1..Ns8, Body1_5, Body1_3, Body1_4, Body1, Body1_1, Body1_2] LinkID=483 Project="This Project*" Product=ElectronicsDesktop Design=Flatwise_0.30_interleaved_new Params{freq_hz=28500Hz} ForceSourceToSolve PreservePartnerSoln PathRelativeTo=TargetProject Intrinsics(28.5kHz) LossMultiplier=1
mesh:
  MeshRegions:  Global{MeshMethod=MesherHD ComputeGap MeshRegionResolution=5 MinGapX=1mm MinGapY=1mm MinGapZ=1mm Objects=Region FacetLevel=5 ProximitySizeFunction CurvatureSizeFunction OptimizePCBMesh}
  MeshOperations:
setups:
  Setup1: IcepakSteadyState Flow_Regime=Laminar Include_Temperature=true Include_Flow=true Include_Gravity Solution_Initialization_-_Z_Velocity=0.000980665m_per_sec Convergence_Criteria_-_Flow=0.001 Convergence_Criteria_-_Energy=1e-07 Convergence_Criteria_-_Discrete_Ordinates=1e-06 Radiation_Model="Discrete Ordinates Model" Flow_Iteration_Per_Radiation_Iteration=10 ThetaDivision=2 PhiDivision=2 ThetaPixels=2 PhiPixels=2 Under-relaxation_-_Pressure=0.7 Under-relaxation_-_Momentum=0.3 Under-relaxation_-_Temperature=1 Discretization_Scheme_-_Pressure=Standard Discretization_Scheme_-_Momentum=First Discretization_Scheme_-_Temperature=First Discretization_Scheme_-_Discrete_Ordinates=First Convergence_Criteria_-_Max_Iterations=10000
field plots:
  Temperature1: Temperature over Body1, Body1_1..Body1_5, Np3, Np5, Np6, Np2, Np8, Np4, Np7, Np1, Ns3, Ns5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 on Setup1 : SteadyState

design [Thermal]Edgewise_0.3_forcedair (Icepak, SteadyState TemperatureAndFlow, model units mm)
options: Default_Fluid_Material=air Default_Solid_Material=Al-Extruded Default_Surface_Material=Steel-oxidised-surface AmbientTemperature=25cel AmbientPressure=0n_per_meter_sq AmbientRadiationTemperature=25cel Gravity_Vector_CS_ID=Global Gravity_Vector_Axis=Z Positive=false SherlockExportDirectory=C:/Users/karlr/Documents/Ansoft/1kW_Final.aedtexport/[Thermal]8turns_3D_CoreLoss_FullInterleaved_Flatwise/ Altitude=0meter
geometry:
  Body1 [ferrite - real2] = imported_body(D:\Karl,reverseengineer\core_assembled_edgewise.step)
  Body1_1, Body1_2 [aluminum_real] = imported_body(D:\Karl,reverseengineer\core_assembled_edgewise.step)
  Body1_3 [ferrite - real2] = imported_body(D:\Karl,reverseengineer\core_assembled_edgewise.step)
  Body1_4, Body1_5 [aluminum_real] = imported_body(D:\Karl,reverseengineer\core_assembled_edgewise.step)
  Np6 [coppe_real] = imported_body(D:\Karl,reverseengineer\core_assembled_edgewise.step)
  Np2 [coppe_real] = imported_body(D:\Karl,reverseengineer\core_assembled_edgewise.step)
  Np3 [coppe_real] = imported_body(D:\Karl,reverseengineer\core_assembled_edgewise.step)
  Np7 [coppe_real] = imported_body(D:\Karl,reverseengineer\core_assembled_edgewise.step)
  Np5 [coppe_real] = imported_body(D:\Karl,reverseengineer\core_assembled_edgewise.step)
  Np1 [coppe_real] = imported_body(D:\Karl,reverseengineer\core_assembled_edgewise.step)
  Np4 [coppe_real] = imported_body(D:\Karl,reverseengineer\core_assembled_edgewise.step)
  Np8 [coppe_real] = imported_body(D:\Karl,reverseengineer\core_assembled_edgewise.step)
  Ns6 [coppe_real] = imported_body(D:\Karl,reverseengineer\core_assembled_edgewise.step)
  Ns2 [coppe_real] = imported_body(D:\Karl,reverseengineer\core_assembled_edgewise.step)
  Ns3 [coppe_real] = imported_body(D:\Karl,reverseengineer\core_assembled_edgewise.step)
  Ns7 [coppe_real] = imported_body(D:\Karl,reverseengineer\core_assembled_edgewise.step)
  Ns5 [coppe_real] = imported_body(D:\Karl,reverseengineer\core_assembled_edgewise.step)
  Ns1 [coppe_real] = imported_body(D:\Karl,reverseengineer\core_assembled_edgewise.step)
  Ns4 [coppe_real] = imported_body(D:\Karl,reverseengineer\core_assembled_edgewise.step)
  Ns8 [coppe_real] = imported_body(D:\Karl,reverseengineer\core_assembled_edgewise.step)
  plate2, plate1 [silicon_TIMreal] = imported_body(D:\Karl,reverseengineer\core_assembled_edgewise.step)
  Body1_6 [aluminum] = imported_body(D:\Karl,reverseengineer\Heatsink (forcedair).step)
  Body2 [silicon - Copy] = imported_body(D:\Karl,reverseengineer\Heatsink (forcedair).step)
  [Body1_6, Body2].move(-252.5mm, -210mm, 4mm)
  [Body1_6, Body2].move(195.5mm, 132.715mm, -120.75mm)
  [Body1_6, Body2].move(-14.281756mm, -22.715mm, -0.25mm)
  [Body1_6, Body2].move(0mm, 220mm, 0mm)
  [Body1_6, Body2].move(28.081756mm, -184.57mm, -9mm)
  Box2 [non-model] = box(corner=(-1.6986412e-12mm, -8.8mm, -5.5511151e-14mm), size=(38.6mm, 68.46mm, 18.6mm))
  Region [air] = region(percentage_offset=1000 on all sides)
  Fan1_1 = component(Fan1, Type=Fan Unit=mm ModelAs=3D Shape=Circular MovePlane=ZX Radius=62.5mm HubRadius=2mm CaseSize=125mm CaseHeight=25mm SheetID=43 BodyID=34 HubID=49 CaseID=6 FlowDirChoice=NormalPositive FlowType=Curve SwirlType=Magnitude SolidCaseMaterial=Al-Extruded SolidHubMaterial=Al-Extruded PassageMaterial=air DimUnits(m3_per_min, pascal) X(0, 0.0020971274, 0.0035320053, 0.0050772617, 0.0060706398, 0.0072847678, 0.0082781459, 0.0093818952, 0.010596023, 0.01214128, 0.013796907, 0.015121414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) Y(19.46428667, 18.452381, 17.44047729, 16.13095345, 15.000001, 13.80952392, 12.61904934, 11.607142, 10.654764, 9.5833343, 8.6904778, 7.9761903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) Pressure_Loss_Curve{DimUnits(m_per_sec, n_per_meter_sq) X(0, 1, 2, 3) Y(1, 10, 100, 0)} IntakeTemp=AmbientTemp Swirl=0 OperatingRPM=0 HubPower=0W Magnitude=1)
  Fan1_Case [Al-Extruded] = part_of(Fan1_1)
  Fan1_Passage [air] = part_of(Fan1_1)
  Fan1_Surface = part_of(Fan1_1)
  Fan1_1.move(TranslateVectorX=19.299942mm TranslateVectorY=-64.57mm TranslateVectorZ=-63.5mm)
  Fan1_Hub [Al-Extruded] = part_of(Fan1_1)
  Box5 [non-model] = box(corner=(-29.2mm, -24.57mm, -1mm), size=(97mm, 100mm, 1mm))
  Box6 [Al-Extruded, non-model] = box(corner=(-43.2mm, 115.43mm, -126mm), size=(124.99994mm, -205mm, 125mm))
  group core_togetherv4 = Body1, Body1_1, Body1_2
  group core_togetherv41 = Body1_3, Body1_4, Body1_5
  group Wire_face_edgewisaev15 = Np6, Np2, Np3, Np7, Np5, Np1, Np4, Np8, Ns6, Ns2, Ns3, Ns7, Ns5, Ns1, Ns4, Ns8, plate2, plate1
  group Heatsinkforcedair = Body1_6, Body2
boundaries and excitations:
  EMLoss1: EM Loss Objects=[Np1..Np8, Ns1..Ns8, Body1_1, Body1_2, Body1, Body1_4, Body1_5, Body1_3] LinkID=498 Project="This Project*" Product=ElectronicsDesktop Design=Edgewise_0.30_interleaved_new Params{freq_hz=28500Hz} ForceSourceToSolve PreservePartnerSoln PathRelativeTo=TargetProject Intrinsics(28.5kHz) LossMultiplier=1
  Opening1: Opening Faces=Region.face(-y) Temperature=AmbientTemp External_Rad._Temperature=AmbientRadTemp Inlet_Type=Velocity Static_Pressure=AmbientPressure X_Velocity=0m_per_sec Y_Velocity=0m_per_sec Z_Velocity=0m_per_sec
  Opening2: Opening Faces=Region.face(+y) Temperature=AmbientTemp External_Rad._Temperature=AmbientRadTemp Inlet_Type=Pressure Total_Pressure=AmbientPressure
mesh:
  MeshRegions:  Global{MeshMethod=MesherHD ComputeGap MeshRegionResolution=5 MinGapX=1mm MinGapY=1mm MinGapZ=1mm Objects=Region FacetLevel=5 ProximitySizeFunction CurvatureSizeFunction OptimizePCBMesh} MeshRegion1{MeshMethod=MesherHD MeshRegionResolution=4 MinGapX=1mm MinGapY=1mm MinGapZ=1mm Objects=Box2 ProximitySizeFunction CurvatureSizeFunction OptimizePCBMesh} MeshRegion2{MeshMethod=MesherHD MeshRegionResolution=4 MinGapX=1mm MinGapY=1mm MinGapZ=1mm Objects=Box5 ProximitySizeFunction CurvatureSizeFunction OptimizePCBMesh} MeshRegion3{MeshMethod=MesherHD MeshRegionResolution=4 MinGapX=1mm MinGapY=1mm MinGapZ=1mm Objects=Box6 ProximitySizeFunction CurvatureSizeFunction OptimizePCBMesh}
  MeshOperations:
setups:
  Setup1: IcepakSteadyState Flow_Regime=Laminar Include_Temperature=true Include_Flow=true Include_Gravity Solution_Initialization_-_Z_Velocity=0.000980665m_per_sec Convergence_Criteria_-_Flow=0.001 Convergence_Criteria_-_Energy=1e-07 Convergence_Criteria_-_Discrete_Ordinates=1e-06 Radiation_Model="Discrete Ordinates Model" Flow_Iteration_Per_Radiation_Iteration=10 ThetaDivision=2 PhiDivision=2 ThetaPixels=2 PhiPixels=2 Under-relaxation_-_Pressure=0.7 Under-relaxation_-_Momentum=0.3 Under-relaxation_-_Temperature=1 Discretization_Scheme_-_Pressure=Standard Discretization_Scheme_-_Momentum=First Discretization_Scheme_-_Temperature=First Discretization_Scheme_-_Discrete_Ordinates=First Convergence_Criteria_-_Max_Iterations=10000
field plots:
  Temperature1: Temperature over Body1, Body1_1..Body1_5, Np6, Np2, Np3, Np7, Np5, Np1, Np4, Np8, Ns6, Ns2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 on Setup1 : SteadyState

design [Thermal]Flatwise_0.3_fix2 (Icepak, SteadyState TemperatureAndFlow, model units mm)
options: Default_Fluid_Material=air Default_Solid_Material=Al-Extruded Default_Surface_Material=Steel-oxidised-surface AmbientTemperature=25cel AmbientPressure=0n_per_meter_sq AmbientRadiationTemperature=25cel Gravity_Vector_CS_ID=Global Gravity_Vector_Axis=Z Positive=false SherlockExportDirectory=C:/Users/karlr/Documents/Ansoft/1kW_Final.aedtexport/[Thermal]8turns_3D_CoreLoss_FullInterleaved_Flatwise/ Altitude=0meter
geometry:
  Region [air] = region(percentage_offset=1000 on all sides)
  Body1, Body1_1 [aluminum_real] = imported_body(D:\Karl,reverseengineer\core_assembled_flatwise.step)
  Body1_2 [ferrite - real2] = imported_body(D:\Karl,reverseengineer\core_assembled_flatwise.step)
  Body1_3, Body1_4 [aluminum_real] = imported_body(D:\Karl,reverseengineer\core_assembled_flatwise.step)
  Body1_5 [ferrite - real2] = imported_body(D:\Karl,reverseengineer\core_assembled_flatwise.step)
  Np3 [coppe_real] = imported_body(D:\Karl,reverseengineer\core_assembled_flatwise.step)
  Np5 [coppe_real] = imported_body(D:\Karl,reverseengineer\core_assembled_flatwise.step)
  Np6 [coppe_real] = imported_body(D:\Karl,reverseengineer\core_assembled_flatwise.step)
  Np2 [coppe_real] = imported_body(D:\Karl,reverseengineer\core_assembled_flatwise.step)
  Np8 [coppe_real] = imported_body(D:\Karl,reverseengineer\core_assembled_flatwise.step)
  Np4 [coppe_real] = imported_body(D:\Karl,reverseengineer\core_assembled_flatwise.step)
  Np7 [coppe_real] = imported_body(D:\Karl,reverseengineer\core_assembled_flatwise.step)
  Np1 [coppe_real] = imported_body(D:\Karl,reverseengineer\core_assembled_flatwise.step)
  Ns3 [coppe_real] = imported_body(D:\Karl,reverseengineer\core_assembled_flatwise.step)
  Ns5 [coppe_real] = imported_body(D:\Karl,reverseengineer\core_assembled_flatwise.step)
  Ns6 [coppe_real] = imported_body(D:\Karl,reverseengineer\core_assembled_flatwise.step)
  Ns2 [coppe_real] = imported_body(D:\Karl,reverseengineer\core_assembled_flatwise.step)
  Ns8 [coppe_real] = imported_body(D:\Karl,reverseengineer\core_assembled_flatwise.step)
  Ns4 [coppe_real] = imported_body(D:\Karl,reverseengineer\core_assembled_flatwise.step)
  Ns7 [coppe_real] = imported_body(D:\Karl,reverseengineer\core_assembled_flatwise.step)
  Ns1 [coppe_real] = imported_body(D:\Karl,reverseengineer\core_assembled_flatwise.step)
  plate_1 [silicon_TIMreal] = imported_body(D:\Karl,reverseengineer\core_assembled_flatwise.step)
  group core_togetherv4 = Body1, Body1_1, Body1_2
  group core_togetherv41 = Body1_3, Body1_4, Body1_5
  group Wire_face_flatwise_newv8 = Np3, Np5, Np6, Np2, Np8, Np4, Np7, Np1, Ns3, Ns5, Ns6, Ns2, Ns8, Ns4, Ns7, Ns1, plate_1
boundaries and excitations:
  Opening1: Opening Faces=Region.face(-y) Temperature=AmbientTemp External_Rad._Temperature=AmbientRadTemp Inlet_Type=Pressure Total_Pressure=AmbientPressure
  Opening2: Opening Faces=Region.face(+y) Temperature=AmbientTemp External_Rad._Temperature=AmbientRadTemp Inlet_Type=Velocity Static_Pressure=AmbientPressure X_Velocity=0m_per_sec Y_Velocity=0m_per_sec Z_Velocity=0m_per_sec
  EMLoss1: EM Loss Objects=[Np1..Np8, Ns1..Ns8, Body1_5, Body1_3, Body1_4, Body1, Body1_1, Body1_2] LinkID=483 Project="This Project*" Product=ElectronicsDesktop Design=Flatwise_0.30_interleaved_new Params{freq_hz=28500Hz} ForceSourceToSolve PreservePartnerSoln PathRelativeTo=TargetProject Intrinsics(28.5kHz) LossMultiplier=1
mesh:
  MeshRegions:  Global{MeshMethod=MesherHD ComputeGap MeshRegionResolution=5 MinGapX=1mm MinGapY=1mm MinGapZ=1mm Objects=Region FacetLevel=5 ProximitySizeFunction CurvatureSizeFunction OptimizePCBMesh}
  MeshOperations:
setups:
  Setup1: IcepakSteadyState Flow_Regime=Laminar Include_Temperature=true Include_Flow=true Include_Gravity Solution_Initialization_-_Z_Velocity=0.000980665m_per_sec Convergence_Criteria_-_Flow=0.001 Convergence_Criteria_-_Energy=1e-07 Convergence_Criteria_-_Discrete_Ordinates=1e-06 Radiation_Model="Discrete Ordinates Model" Flow_Iteration_Per_Radiation_Iteration=10 ThetaDivision=2 PhiDivision=2 ThetaPixels=2 PhiPixels=2 Under-relaxation_-_Pressure=0.7 Under-relaxation_-_Momentum=0.3 Under-relaxation_-_Temperature=1 Discretization_Scheme_-_Pressure=Standard Discretization_Scheme_-_Momentum=First Discretization_Scheme_-_Temperature=First Discretization_Scheme_-_Discrete_Ordinates=First Convergence_Criteria_-_Max_Iterations=10000
field plots:
  Temperature1: Temperature over Body1, Body1_1..Body1_5, Np3, Np5, Np6, Np2, Np8, Np4, Np7, Np1, Ns3, Ns5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 on Setup1 : SteadyState

design [Thermal]Edgewise_0.3_natural (Icepak, SteadyState TemperatureAndFlow, model units mm)
options: Default_Fluid_Material=air Default_Solid_Material=Al-Extruded Default_Surface_Material=Steel-oxidised-surface AmbientTemperature=25cel AmbientPressure=0n_per_meter_sq AmbientRadiationTemperature=25cel Gravity_Vector_CS_ID=Global Gravity_Vector_Axis=Z Positive=false SherlockExportDirectory=C:/Users/karlr/Documents/Ansoft/1kW_Final.aedtexport/[Thermal]8turns_3D_CoreLoss_FullInterleaved_Flatwise/ Altitude=0meter
geometry:
  Region [air] = region(percentage_offset=1000 on all sides)
  Body1_6 [aluminum] = imported_body(D:\Karl,reverseengineer\Heatsink (naturalair).step)
  Body2 [silicon - Copy] = imported_body(D:\Karl,reverseengineer\Heatsink (naturalair).step)
  Body3 [Material1] = imported_body(D:\Karl,reverseengineer\Heatsink (naturalair).step)
  [Body1_6, Body2, Body3].move(461.4mm, 990.34mm, -18.6mm)
  [Body1_6, Body2, Body3].move(-504.6mm, -1054.91mm, -119.4mm)
  Body1 [ferrite - real2] = imported_body(D:\Karl,reverseengineer\core_assembled_edgewise.step)
  Body1_7, Body1_8 [aluminum_real] = imported_body(D:\Karl,reverseengineer\core_assembled_edgewise.step)
  Body1_9 [ferrite - real2] = imported_body(D:\Karl,reverseengineer\core_assembled_edgewise.step)
  Body1_10, Body1_11 [aluminum_real] = imported_body(D:\Karl,reverseengineer\core_assembled_edgewise.step)
  Np6, Np2, Np3, Np7, Np5, Np1, Np4, Np8, Ns6, Ns2, Ns3, Ns7, Ns5, Ns1, Ns4, Ns8 [coppe_real] = imported_body(D:\Karl,reverseengineer\core_assembled_edgewise.step)
  plate2, plate1 [silicon_TIMreal] = imported_body(D:\Karl,reverseengineer\core_assembled_edgewise.step)
  Box1 [non-model] = box(corner=(-1.7041923e-12mm, -8.8mm, -5.5511151e-14mm), size=(38.6mm, 68.46mm, 18.6mm))
  Box2 [non-model] = box(corner=(-29.2mm, -24.57mm, -13mm), size=(97mm, 100mm, 1mm))
  group Heatsinknaturalair = Body1_6, Body2, Body3
  group core_togetherv4 = Body1, Body1_7, Body1_8
  group core_togetherv41 = Body1_9, Body1_10, Body1_11
  group Wire_face_edgewisaev15 = Np6, Np2, Np3, Np7, Np5, Np1, Np4, Np8, Ns6, Ns2, Ns3, Ns7, Ns5, Ns1, Ns4, Ns8, plate2, plate1
boundaries and excitations:
  Opening1: Opening Faces=Region.face(-y) Temperature=AmbientTemp External_Rad._Temperature=AmbientRadTemp Inlet_Type=Pressure Total_Pressure=AmbientPressure
  Opening2: Opening Faces=Region.face(+y) Temperature=AmbientTemp External_Rad._Temperature=AmbientRadTemp Inlet_Type=Velocity Static_Pressure=AmbientPressure X_Velocity=0m_per_sec Y_Velocity=0m_per_sec Z_Velocity=0m_per_sec
  EMLoss1: EM Loss Objects=[Np1..Np8, Ns1..Ns8, Body1_9, Body1_10, Body1_11, Body1, Body1_7, Body1_8] LinkID=628 Project="This Project*" Product=ElectronicsDesktop Design=Edgewise_0.30_interleaved_new Params{freq_hz=28500Hz} ForceSourceToSolve PreservePartnerSoln PathRelativeTo=TargetProject Intrinsics(28.5kHz) LossMultiplier=1
mesh:
  MeshRegions:  Global{MeshMethod=MesherHD ComputeGap MeshRegionResolution=5 MinGapX=1mm MinGapY=1mm MinGapZ=1mm Objects=Region FacetLevel=5 ProximitySizeFunction CurvatureSizeFunction OptimizePCBMesh} MeshRegion1{MeshMethod=MesherHD MeshRegionResolution=4 MinGapX=1mm MinGapY=1mm MinGapZ=1mm Objects=Box1 ProximitySizeFunction CurvatureSizeFunction OptimizePCBMesh} MeshRegion2{MeshMethod=MesherHD MeshRegionResolution=4 MinGapX=1mm MinGapY=1mm MinGapZ=1mm Objects=Box2 ProximitySizeFunction CurvatureSizeFunction OptimizePCBMesh}
  MeshOperations:
setups:
  Setup1: IcepakSteadyState Flow_Regime=Laminar Include_Temperature=true Include_Flow=true Include_Gravity Solution_Initialization_-_Z_Velocity=0.000980665m_per_sec Convergence_Criteria_-_Flow=0.001 Convergence_Criteria_-_Energy=1e-07 Convergence_Criteria_-_Discrete_Ordinates=1e-06 Radiation_Model="Discrete Ordinates Model" Flow_Iteration_Per_Radiation_Iteration=10 ThetaDivision=2 PhiDivision=2 ThetaPixels=2 PhiPixels=2 Under-relaxation_-_Pressure=0.7 Under-relaxation_-_Momentum=0.3 Under-relaxation_-_Temperature=1 Discretization_Scheme_-_Pressure=Standard Discretization_Scheme_-_Momentum=First Discretization_Scheme_-_Temperature=First Discretization_Scheme_-_Discrete_Ordinates=First Convergence_Criteria_-_Max_Iterations=10000

design [Thermal]Flatwise_0.3_natural (Icepak, SteadyState TemperatureAndFlow, model units mm)
options: Default_Fluid_Material=air Default_Solid_Material=Al-Extruded Default_Surface_Material=Steel-oxidised-surface AmbientTemperature=25cel AmbientPressure=0n_per_meter_sq AmbientRadiationTemperature=25cel Gravity_Vector_CS_ID=Global Gravity_Vector_Axis=Z Positive=false SherlockExportDirectory=C:/Users/karlr/Documents/Ansoft/1kW_Final.aedtexport/[Thermal]8turns_3D_CoreLoss_FullInterleaved_Flatwise/ Altitude=0meter
geometry:
  Region [air] = region(percentage_offset=1000 on all sides)
  Body1_6 [aluminum] = imported_body(D:\Karl,reverseengineer\Heatsink (naturalair).step)
  Body2 [silicon - Copy] = imported_body(D:\Karl,reverseengineer\Heatsink (naturalair).step)
  Body3 [Material1] = imported_body(D:\Karl,reverseengineer\Heatsink (naturalair).step)
  [Body1_6, Body2, Body3].move(461.4mm, 990.34mm, -18.6mm)
  [Body1_6, Body2, Body3].move(-504.6mm, -1054.91mm, -119.4mm)
  Box1 [non-model] = box(corner=(-1.7041923e-12mm, -8.8mm, -5.5511151e-14mm), size=(38.6mm, 68.46mm, 18.6mm))
  Body1, Body1_7 [aluminum_real] = imported_body(D:\Karl,reverseengineer\core_assembled_flatwise.step)
  Body1_8 [ferrite - real2] = imported_body(D:\Karl,reverseengineer\core_assembled_flatwise.step)
  Body1_9, Body1_10 [aluminum_real] = imported_body(D:\Karl,reverseengineer\core_assembled_flatwise.step)
  Body1_11 [ferrite - real2] = imported_body(D:\Karl,reverseengineer\core_assembled_flatwise.step)
  Np3, Np5, Np6, Np2, Np8, Np4, Np7, Np1, Ns3, Ns5, Ns6, Ns2, Ns8, Ns4, Ns7, Ns1 [coppe_real] = imported_body(D:\Karl,reverseengineer\core_assembled_flatwise.step)
  plate_1, plate_2 [silicon_TIMreal] = imported_body(D:\Karl,reverseengineer\core_assembled_flatwise.step)
  group Heatsinknaturalair = Body1_6, Body2, Body3
  group core_togetherv4 = Body1, Body1_7, Body1_8
  group core_togetherv41 = Body1_9, Body1_10, Body1_11
  group Wire_face_flatwise_newv8 = Np3, Np5, Np6, Np2, Np8, Np4, Np7, Np1, Ns3, Ns5, Ns6, Ns2, Ns8, Ns4, Ns7, Ns1, plate_1, plate_2
boundaries and excitations:
  Opening1: Opening Faces=Region.face(-y) Temperature=AmbientTemp External_Rad._Temperature=AmbientRadTemp Inlet_Type=Pressure Total_Pressure=AmbientPressure
  Opening2: Opening Faces=Region.face(+y) Temperature=AmbientTemp External_Rad._Temperature=AmbientRadTemp Inlet_Type=Velocity Static_Pressure=AmbientPressure X_Velocity=0m_per_sec Y_Velocity=0m_per_sec Z_Velocity=0m_per_sec
  EMLoss1: EM Loss Objects=[Body1_9, Body1_10, Body1_11, Body1_8, Body1, Body1_7, Np1..Np8, Ns1..Ns8] LinkID=645 Project="This Project*" Product=ElectronicsDesktop Design=Flatwise_0.30_interleaved_new Params{freq_hz=28500Hz} ForceSourceToSolve PreservePartnerSoln PathRelativeTo=TargetProject Intrinsics(28.5kHz) LossMultiplier=1
mesh:
  MeshRegions:  Global{MeshMethod=MesherHD ComputeGap MeshRegionResolution=5 MinGapX=1mm MinGapY=1mm MinGapZ=1mm Objects=Region FacetLevel=5 ProximitySizeFunction CurvatureSizeFunction OptimizePCBMesh} MeshRegion1{MeshMethod=MesherHD MeshRegionResolution=4 MinGapX=1mm MinGapY=1mm MinGapZ=1mm Objects=Box1 ProximitySizeFunction CurvatureSizeFunction OptimizePCBMesh}
  MeshOperations:
setups:
  Setup1: IcepakSteadyState Flow_Regime=Laminar Include_Temperature=true Include_Flow=true Include_Gravity Solution_Initialization_-_Z_Velocity=0.000980665m_per_sec Convergence_Criteria_-_Flow=0.001 Convergence_Criteria_-_Energy=1e-07 Convergence_Criteria_-_Discrete_Ordinates=1e-06 Radiation_Model="Discrete Ordinates Model" Flow_Iteration_Per_Radiation_Iteration=10 ThetaDivision=2 PhiDivision=2 ThetaPixels=2 PhiPixels=2 Under-relaxation_-_Pressure=0.7 Under-relaxation_-_Momentum=0.3 Under-relaxation_-_Temperature=1 Discretization_Scheme_-_Pressure=Standard Discretization_Scheme_-_Momentum=First Discretization_Scheme_-_Temperature=First Discretization_Scheme_-_Discrete_Ordinates=First Convergence_Criteria_-_Max_Iterations=10000
field plots:
  Temperature1: Temperature over Body1, Body1_7..Body1_11, Np3, Np5, Np6, Np2, Np8, Np4, Np7, Np1, Ns3, Ns5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 on Setup1 : SteadyState

design [Thermal]Flatwise_0.3_forcedair (Icepak, SteadyState TemperatureAndFlow, model units mm)
options: Default_Fluid_Material=air Default_Solid_Material=Al-Extruded Default_Surface_Material=Steel-oxidised-surface AmbientTemperature=25cel AmbientPressure=0n_per_meter_sq AmbientRadiationTemperature=25cel Gravity_Vector_CS_ID=Global Gravity_Vector_Axis=Z Positive=false SherlockExportDirectory=C:/Users/karlr/Documents/Ansoft/1kW_Final.aedtexport/[Thermal]8turns_3D_CoreLoss_FullInterleaved_Flatwise/ Altitude=0meter
geometry:
  Body1_6 [aluminum] = imported_body(D:\Karl,reverseengineer\Heatsink (forcedair).step)
  Body2 [silicon - Copy] = imported_body(D:\Karl,reverseengineer\Heatsink (forcedair).step)
  [Body1_6, Body2].move(-252.5mm, -210mm, 4mm)
  [Body1_6, Body2].move(195.5mm, 132.715mm, -120.75mm)
  [Body1_6, Body2].move(-14.281756mm, -22.715mm, -0.25mm)
  [Body1_6, Body2].move(0mm, 220mm, 0mm)
  [Body1_6, Body2].move(28.081756mm, -184.57mm, -9mm)
  Box2 [non-model] = box(corner=(-1.6986412e-12mm, -8.8mm, -5.5511151e-14mm), size=(38.6mm, 68.46mm, 18.6mm))
  Region [air] = region(percentage_offset=1000 on all sides)
  Fan1_1 = component(Fan1, Type=Fan Unit=mm ModelAs=3D Shape=Circular MovePlane=ZX Radius=62.5mm HubRadius=2mm CaseSize=125mm CaseHeight=25mm SheetID=43 BodyID=34 HubID=49 CaseID=6 FlowDirChoice=NormalPositive FlowType=Curve SwirlType=Magnitude SolidCaseMaterial=Al-Extruded SolidHubMaterial=Al-Extruded PassageMaterial=air DimUnits(m3_per_s, n_per_meter_sq) X(0, 0.12582765, 0.211920315, 0.3046357, 0.364238389, 0.437086066, 0.49668875, 0.56291371, 0.63576139, 0.72847678, 0.82781444, 0.90728483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) Y(19.46428667, 18.452381, 17.44047729, 16.13095345, 15.000001, 13.80952392, 12.61904934, 11.607142, 10.654764, 9.5833343, 8.6904778, 7.9761903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) Pressure_Loss_Curve{DimUnits(m_per_sec, n_per_meter_sq) X(0, 1, 2, 3) Y(1, 10, 100, 0)} IntakeTemp=AmbientTemp Swirl=0 OperatingRPM=0 HubPower=0W Magnitude=1)
  Fan1_Case [Al-Extruded] = part_of(Fan1_1)
  Fan1_Passage [air] = part_of(Fan1_1)
  Fan1_Surface = part_of(Fan1_1)
  Fan1_1.move(TranslateVectorX=19.299942mm TranslateVectorY=-64.57mm TranslateVectorZ=-63.5mm)
  Box3 [non-model] = box(corner=(-29.2mm, -24.57mm, -1mm), size=(97mm, 100mm, 1mm))
  Body1, Body1_7 [aluminum_real] = imported_body(D:\Karl,reverseengineer\core_assembled_flatwise.step)
  Body1_8 [ferrite - real2] = imported_body(D:\Karl,reverseengineer\core_assembled_flatwise.step)
  Body1_9, Body1_10 [aluminum_real] = imported_body(D:\Karl,reverseengineer\core_assembled_flatwise.step)
  Body1_11 [ferrite - real2] = imported_body(D:\Karl,reverseengineer\core_assembled_flatwise.step)
  Np3, Np5, Np6, Np2, Np8, Np4, Np7, Np1, Ns3, Ns5, Ns6, Ns2, Ns8, Ns4, Ns7, Ns1 [coppe_real] = imported_body(D:\Karl,reverseengineer\core_assembled_flatwise.step)
  plate_1, plate_2 [silicon_TIMreal] = imported_body(D:\Karl,reverseengineer\core_assembled_flatwise.step)
  Box4 [Al-Extruded, non-model] = box(corner=(81.8mm, 115.43mm, -1mm), size=(-125.00006mm, -205mm, -125mm))
  Fan1_Hub [Al-Extruded] = part_of(Fan1_1)
  group Heatsinkforcedair = Body1_6, Body2
  group core_togetherv4 = Body1, Body1_7, Body1_8
  group core_togetherv41 = Body1_9, Body1_10, Body1_11
  group Wire_face_flatwise_newv8 = Np3, Np5, Np6, Np2, Np8, Np4, Np7, Np1, Ns3, Ns5, Ns6, Ns2, Ns8, Ns4, Ns7, Ns1, plate_1, plate_2
boundaries and excitations:
  Opening1: Opening Faces=Region.face(-y) Temperature=AmbientTemp External_Rad._Temperature=AmbientRadTemp Inlet_Type=Velocity Static_Pressure=AmbientPressure X_Velocity=0m_per_sec Y_Velocity=0m_per_sec Z_Velocity=0m_per_sec
  Opening2: Opening Faces=Region.face(+y) Temperature=AmbientTemp External_Rad._Temperature=AmbientRadTemp Inlet_Type=Pressure Total_Pressure=AmbientPressure
  EMLoss1: EM Loss Objects=[Body1, Body1_7..Body1_11, Np1..Np8, Ns1..Ns8] LinkID=763 Project="This Project*" Product=ElectronicsDesktop Design=Flatwise_0.30_interleaved_new Params{freq_hz=28500Hz} ForceSourceToSolve PreservePartnerSoln PathRelativeTo=TargetProject Intrinsics(28.5kHz) LossMultiplier=1
mesh:
  MeshRegions:  Global{MeshMethod=MesherHD ComputeGap MeshRegionResolution=5 MinGapX=1mm MinGapY=1mm MinGapZ=1mm Objects=Region FacetLevel=5 ProximitySizeFunction CurvatureSizeFunction OptimizePCBMesh} MeshRegion1{MeshMethod=MesherHD MeshRegionResolution=4 MinGapX=1mm MinGapY=1mm MinGapZ=1mm Objects=Box2 ProximitySizeFunction CurvatureSizeFunction OptimizePCBMesh} MeshRegion2{MeshMethod=MesherHD MeshRegionResolution=4 MinGapX=1mm MinGapY=1mm MinGapZ=1mm Objects=Box3 ProximitySizeFunction CurvatureSizeFunction OptimizePCBMesh} MeshRegion3{MeshMethod=MesherHD MeshRegionResolution=4 MinGapX=1mm MinGapY=1mm MinGapZ=1mm Objects=Box4 ProximitySizeFunction CurvatureSizeFunction OptimizePCBMesh}
  MeshOperations:
setups:
  Setup1: IcepakSteadyState Flow_Regime=Laminar Include_Temperature=true Include_Flow=true Include_Gravity Solution_Initialization_-_Z_Velocity=0.000980665m_per_sec Convergence_Criteria_-_Flow=0.001 Convergence_Criteria_-_Energy=1e-07 Convergence_Criteria_-_Discrete_Ordinates=1e-06 Radiation_Model="Discrete Ordinates Model" Flow_Iteration_Per_Radiation_Iteration=10 ThetaDivision=2 PhiDivision=2 ThetaPixels=2 PhiPixels=2 Under-relaxation_-_Pressure=0.7 Under-relaxation_-_Momentum=0.3 Under-relaxation_-_Temperature=1 Discretization_Scheme_-_Pressure=Standard Discretization_Scheme_-_Momentum=First Discretization_Scheme_-_Temperature=First Discretization_Scheme_-_Discrete_Ordinates=First Convergence_Criteria_-_Max_Iterations=10000
field plots:
  Temperature1: Temperature over Body1, Body1_7..Body1_11, Np3, Np5, Np6, Np2, Np8, Np4, Np7, Np1, Ns3, Ns5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 on Setup1 : SteadyState

design [Thermal]Flatwise_0.3_forcedair1 (Icepak, SteadyState TemperatureAndFlow, model units mm)
options: Default_Fluid_Material=air Default_Solid_Material=Al-Extruded Default_Surface_Material=Steel-oxidised-surface AmbientTemperature=25cel AmbientPressure=0n_per_meter_sq AmbientRadiationTemperature=25cel Gravity_Vector_CS_ID=Global Gravity_Vector_Axis=Z Positive=false SherlockExportDirectory=C:/Users/karlr/Documents/Ansoft/1kW_Final.aedtexport/[Thermal]8turns_3D_CoreLoss_FullInterleaved_Flatwise/ Altitude=0meter
geometry:
  Body1_6 [aluminum] = imported_body(D:\Karl,reverseengineer\Heatsink (forcedair).step)
  Body2 [silicon - Copy] = imported_body(D:\Karl,reverseengineer\Heatsink (forcedair).step)
  [Body1_6, Body2].move(-252.5mm, -210mm, 4mm)
  [Body1_6, Body2].move(195.5mm, 132.715mm, -120.75mm)
  [Body1_6, Body2].move(-14.281756mm, -22.715mm, -0.25mm)
  [Body1_6, Body2].move(0mm, 220mm, 0mm)
  [Body1_6, Body2].move(28.081756mm, -184.57mm, -9mm)
  Box2 [non-model] = box(corner=(-1.6986412e-12mm, -8.8mm, -5.5511151e-14mm), size=(38.6mm, 68.46mm, 18.6mm))
  Region [air] = region(percentage_offset=1000 on all sides)
  Fan1_1 = component(Fan1, Type=Fan Unit=mm ModelAs=3D Shape=Circular MovePlane=ZX Radius=62.5mm HubRadius=2mm CaseSize=125mm CaseHeight=25mm SheetID=43 BodyID=34 HubID=49 CaseID=6 FlowDirChoice=NormalPositive FlowType=Curve SwirlType=Magnitude SolidCaseMaterial=Al-Extruded SolidHubMaterial=Al-Extruded PassageMaterial=air DimUnits(m3_per_s, n_per_meter_sq) X(0, 0.12582765, 0.211920315, 0.3046357, 0.364238389, 0.437086066, 0.49668875, 0.56291371, 0.63576139, 0.72847678, 0.82781444, 0.90728483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) Y(19.46428667, 18.452381, 17.44047729, 16.13095345, 15.000001, 13.80952392, 12.61904934, 11.607142, 10.654764, 9.5833343, 8.6904778, 7.9761903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) Pressure_Loss_Curve{DimUnits(m_per_sec, n_per_meter_sq) X(0, 1, 2, 3) Y(1, 10, 100, 0)} IntakeTemp=AmbientTemp Swirl=0 OperatingRPM=0 HubPower=0W Magnitude=1)
  Fan1_Case [Al-Extruded] = part_of(Fan1_1)
  Fan1_Passage [air] = part_of(Fan1_1)
  Fan1_Surface = part_of(Fan1_1)
  Fan1_1.move(TranslateVectorX=19.299942mm TranslateVectorY=-64.57mm TranslateVectorZ=-63.5mm)
  Box3 [non-model] = box(corner=(-29.2mm, -24.57mm, -1mm), size=(97mm, 100mm, 1mm))
  Box4 [Al-Extruded, non-model] = box(corner=(81.8mm, 115.43mm, -1mm), size=(-125.00006mm, -205mm, -125mm))
  Fan1_Hub [Al-Extruded] = part_of(Fan1_1)
  Body1, Body1_7 [aluminum_real] = imported_body(D:\Karl,reverseengineer\core_assembled_flatwise.step)
  Body1_8 [ferrite - real2] = imported_body(D:\Karl,reverseengineer\core_assembled_flatwise.step)
  Body1_9, Body1_10 [aluminum_real] = imported_body(D:\Karl,reverseengineer\core_assembled_flatwise.step)
  Body1_11 [ferrite - real2] = imported_body(D:\Karl,reverseengineer\core_assembled_flatwise.step)
  Np3, Np5, Np6, Np2, Np8, Np4, Np7, Np1, Ns3, Ns5, Ns6, Ns2, Ns8, Ns4, Ns7, Ns1 [coppe_real] = imported_body(D:\Karl,reverseengineer\core_assembled_flatwise.step)
  plate_1, plate_2 [silicon_TIMreal] = imported_body(D:\Karl,reverseengineer\core_assembled_flatwise.step)
  group Heatsinkforcedair = Body1_6, Body2
  group core_togetherv4 = Body1, Body1_7, Body1_8
  group core_togetherv41 = Body1_9, Body1_10, Body1_11
  group Wire_face_flatwise_newv8 = Np3, Np5, Np6, Np2, Np8, Np4, Np7, Np1, Ns3, Ns5, Ns6, Ns2, Ns8, Ns4, Ns7, Ns1, plate_1, plate_2
boundaries and excitations:
  Opening1: Opening Faces=Region.face(-y) Temperature=AmbientTemp External_Rad._Temperature=AmbientRadTemp Inlet_Type=Velocity Static_Pressure=AmbientPressure X_Velocity=0m_per_sec Y_Velocity=0m_per_sec Z_Velocity=0m_per_sec
  Opening2: Opening Faces=Region.face(+y) Temperature=AmbientTemp External_Rad._Temperature=AmbientRadTemp Inlet_Type=Pressure Total_Pressure=AmbientPressure
  EMLoss1: EM Loss Objects=[Body1, Body1_7..Body1_11, Np1..Np8, Ns1..Ns8] LinkID=763 Project="This Project*" Product=ElectronicsDesktop Design=Flatwise_0.30_interleaved_new Params{freq_hz=28500Hz} ForceSourceToSolve PreservePartnerSoln PathRelativeTo=TargetProject Intrinsics(28.5kHz) LossMultiplier=1
  EMLoss2: EM Loss Objects=[Body1, Body1_7..Body1_11, Np3, Np5, Np6, Np2, Np8, Np4, Np7, Np1, Ns3, Ns5, Ns6, Ns2, Ns8, Ns4, Ns7, Ns1] LinkID=898 Project="This Project*" Product=ElectronicsDesktop Design=Edgewise_0.30_interleaved_new Params{freq_hz=28500Hz} ForceSourceToSolve PreservePartnerSoln PathRelativeTo=TargetProject Intrinsics(100kHz) LossMultiplier=1
mesh:
  MeshRegions:  Global{MeshMethod=MesherHD ComputeGap MeshRegionResolution=3 MinGapX=1mm MinGapY=1mm MinGapZ=1mm Objects=Region FacetLevel=5 ProximitySizeFunction CurvatureSizeFunction OptimizePCBMesh} MeshRegion1{MeshMethod=MesherHD MeshRegionResolution=4 MinGapX=1mm MinGapY=1mm MinGapZ=1mm Objects=Box2 ProximitySizeFunction CurvatureSizeFunction OptimizePCBMesh} MeshRegion2{MeshMethod=MesherHD MeshRegionResolution=4 MinGapX=1mm MinGapY=1mm MinGapZ=1mm Objects=Box3 ProximitySizeFunction CurvatureSizeFunction OptimizePCBMesh} MeshRegion3{MeshMethod=MesherHD MeshRegionResolution=4 MinGapX=1mm MinGapY=1mm MinGapZ=1mm Objects=Box4 ProximitySizeFunction CurvatureSizeFunction OptimizePCBMesh}
  MeshOperations:
setups:
  Setup1: IcepakSteadyState Flow_Regime=Laminar Include_Temperature=true Include_Flow=true Include_Gravity Solution_Initialization_-_Z_Velocity=0.000980665m_per_sec Convergence_Criteria_-_Flow=0.001 Convergence_Criteria_-_Energy=1e-07 Convergence_Criteria_-_Discrete_Ordinates=1e-06 Radiation_Model="Discrete Ordinates Model" Flow_Iteration_Per_Radiation_Iteration=10 ThetaDivision=2 PhiDivision=2 ThetaPixels=2 PhiPixels=2 Under-relaxation_-_Pressure=0.7 Under-relaxation_-_Momentum=0.3 Under-relaxation_-_Temperature=1 Discretization_Scheme_-_Pressure=Standard Discretization_Scheme_-_Momentum=First Discretization_Scheme_-_Temperature=First Discretization_Scheme_-_Discrete_Ordinates=First Convergence_Criteria_-_Max_Iterations=300

design [Thermal]Flatwise_0.3_forcedair_kapton (Icepak, SteadyState TemperatureAndFlow, model units mm)
options: Default_Fluid_Material=air Default_Solid_Material=Al-Extruded Default_Surface_Material=Steel-oxidised-surface AmbientTemperature=25cel AmbientPressure=0n_per_meter_sq AmbientRadiationTemperature=25cel Gravity_Vector_CS_ID=Global Gravity_Vector_Axis=Z Positive=false SherlockExportDirectory=C:/Users/karlr/Documents/Ansoft/1kW_Final.aedtexport/[Thermal]8turns_3D_CoreLoss_FullInterleaved_Flatwise/ Altitude=0meter
geometry:
  Body1_6 [aluminum] = imported_body(D:\Karl,reverseengineer\Heatsink (forcedair).step)
  Body2 [silicon - Copy] = imported_body(D:\Karl,reverseengineer\Heatsink (forcedair).step)
  [Body1_6, Body2].move(-252.5mm, -210mm, 4mm)
  [Body1_6, Body2].move(195.5mm, 132.715mm, -120.75mm)
  [Body1_6, Body2].move(-14.281756mm, -22.715mm, -0.25mm)
  [Body1_6, Body2].move(0mm, 220mm, 0mm)
  [Body1_6, Body2].move(28.081756mm, -184.57mm, -9mm)
  Box2 [non-model] = box(corner=(-1.6986412e-12mm, -8.8mm, -5.5511151e-14mm), size=(38.6mm, 68.46mm, 18.6mm))
  Region [air] = region(percentage_offset=1000 on all sides)
  Fan1_1 = component(Fan1, Type=Fan Unit=mm ModelAs=3D Shape=Circular MovePlane=ZX Radius=62.5mm HubRadius=2mm CaseSize=125mm CaseHeight=25mm SheetID=43 BodyID=34 HubID=49 CaseID=6 FlowDirChoice=NormalPositive FlowType=Curve SwirlType=Magnitude SolidCaseMaterial=Al-Extruded SolidHubMaterial=Al-Extruded PassageMaterial=air DimUnits(m3_per_s, n_per_meter_sq) X(0, 0.12582765, 0.211920315, 0.3046357, 0.364238389, 0.437086066, 0.49668875, 0.56291371, 0.63576139, 0.72847678, 0.82781444, 0.90728483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) Y(19.46428667, 18.452381, 17.44047729, 16.13095345, 15.000001, 13.80952392, 12.61904934, 11.607142, 10.654764, 9.5833343, 8.6904778, 7.9761903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) Pressure_Loss_Curve{DimUnits(m_per_sec, n_per_meter_sq) X(0, 1, 2, 3) Y(1, 10, 100, 0)} IntakeTemp=AmbientTemp Swirl=0 OperatingRPM=0 HubPower=0W Magnitude=1)
  Fan1_Case [Al-Extruded] = part_of(Fan1_1)
  Fan1_Passage [air] = part_of(Fan1_1)
  Fan1_Surface = part_of(Fan1_1)
  Fan1_1.move(TranslateVectorX=19.299942mm TranslateVectorY=-64.57mm TranslateVectorZ=-63.5mm)
  Box3 [non-model] = box(corner=(-29.2mm, -24.57mm, -1mm), size=(97mm, 100mm, 1mm))
  Box4 [Al-Extruded, non-model] = box(corner=(81.8mm, 115.43mm, -1mm), size=(-125.00006mm, -205mm, -125mm))
  Fan1_Hub [Al-Extruded] = part_of(Fan1_1)
  Body1, Body1_7 [aluminum_real] = imported_body(D:\Karl,reverseengineer\core_assembled_flatwise_kapton.step)
  Body1_8 [ferrite - real2] = imported_body(D:\Karl,reverseengineer\core_assembled_flatwise_kapton.step)
  Body1_9, Body1_10 [aluminum_real] = imported_body(D:\Karl,reverseengineer\core_assembled_flatwise_kapton.step)
  Body1_11 [ferrite - real2] = imported_body(D:\Karl,reverseengineer\core_assembled_flatwise_kapton.step)
  Np3, Np5, Np6, Np2, Np8, Np4, Np7, Np1, Ns3, Ns5, Ns6, Ns2, Ns8, Ns4, Ns7, Ns1 [coppe_real] = imported_body(D:\Karl,reverseengineer\core_assembled_flatwise_kapton.step)
  plate_1, plate_2 [silicon_TIMreal] = imported_body(D:\Karl,reverseengineer\core_assembled_flatwise_kapton.step)
  Body77, Body80, Body81, Body79, Body82, Body78, Body92, Body84, Body87, Body88, Body89, Body83, Body86, Body90, Body91, Body85 [kapton_real] = imported_body(D:\Karl,reverseengineer\core_assembled_flatwise_kapton.step)
  group Heatsinkforcedair = Body1_6, Body2
  group core_togetherv4 = Body1, Body1_7, Body1_8
  group core_togetherv41 = Body1_9, Body1_10, Body1_11
  group Wire_face_flatwise_newv3 = Np3, Np5, Np6, Np2, Np8, Np4, Np7, Np1, Ns3, Ns5, Ns6, Ns2, Ns8, Ns4, Ns7, Ns1, plate_1, plate_2, Body77, Body80, Body81, Body79, Body82, Body78, Body92, Body84, Body87, Body88, Body89, Body83, Body86, Body90, Body91, Body85
boundaries and excitations:
  Opening1: Opening Faces=Region.face(-y) Temperature=AmbientTemp External_Rad._Temperature=AmbientRadTemp Inlet_Type=Velocity Static_Pressure=AmbientPressure X_Velocity=0m_per_sec Y_Velocity=0m_per_sec Z_Velocity=0m_per_sec
  Opening2: Opening Faces=Region.face(+y) Temperature=AmbientTemp External_Rad._Temperature=AmbientRadTemp Inlet_Type=Pressure Total_Pressure=AmbientPressure
mesh:
  MeshRegions:  Global{MeshMethod=MesherHD ComputeGap MeshRegionResolution=5 MinGapX=1mm MinGapY=1mm MinGapZ=1mm Objects=Region FacetLevel=5 ProximitySizeFunction CurvatureSizeFunction OptimizePCBMesh} MeshRegion1{MeshMethod=MesherHD MeshRegionResolution=4 MinGapX=1mm MinGapY=1mm MinGapZ=1mm Objects=Box2 ProximitySizeFunction CurvatureSizeFunction OptimizePCBMesh} MeshRegion2{MeshMethod=MesherHD MeshRegionResolution=4 MinGapX=1mm MinGapY=1mm MinGapZ=1mm Objects=Box3 ProximitySizeFunction CurvatureSizeFunction OptimizePCBMesh} MeshRegion3{MeshMethod=MesherHD MeshRegionResolution=4 MinGapX=1mm MinGapY=1mm MinGapZ=1mm Objects=Box4 ProximitySizeFunction CurvatureSizeFunction OptimizePCBMesh}
  MeshOperations:
setups:
  Setup1: IcepakSteadyState Flow_Regime=Laminar Include_Temperature=true Include_Flow=true Include_Gravity Solution_Initialization_-_Z_Velocity=0.000980665m_per_sec Convergence_Criteria_-_Flow=0.001 Convergence_Criteria_-_Energy=1e-07 Convergence_Criteria_-_Discrete_Ordinates=1e-06 Radiation_Model="Discrete Ordinates Model" Flow_Iteration_Per_Radiation_Iteration=10 ThetaDivision=2 PhiDivision=2 ThetaPixels=2 PhiPixels=2 Under-relaxation_-_Pressure=0.7 Under-relaxation_-_Momentum=0.3 Under-relaxation_-_Temperature=1 Discretization_Scheme_-_Pressure=Standard Discretization_Scheme_-_Momentum=First Discretization_Scheme_-_Temperature=First Discretization_Scheme_-_Discrete_Ordinates=First Convergence_Criteria_-_Max_Iterations=10000

design [Thermal]Edgewise_0.3_natural_kaptononly (Icepak, SteadyState TemperatureAndFlow, model units mm)
options: Default_Fluid_Material=air Default_Solid_Material=Al-Extruded Default_Surface_Material=Steel-oxidised-surface AmbientTemperature=25cel AmbientPressure=0n_per_meter_sq AmbientRadiationTemperature=25cel Gravity_Vector_CS_ID=Global Gravity_Vector_Axis=Z Positive=false SherlockExportDirectory=C:/Users/karlr/Documents/Ansoft/1kW_Final.aedtexport/[Thermal]8turns_3D_CoreLoss_FullInterleaved_Flatwise/ Altitude=0meter
geometry:
  Region [air] = region(percentage_offset=1000 on all sides)
  Box1 [non-model] = box(corner=(-1.7041923e-12mm, -8.8mm, -5.5511151e-14mm), size=(38.6mm, 68.46mm, 18.6mm))
  Box2 [non-model] = box(corner=(-29.2mm, -24.57mm, -13mm), size=(97mm, 100mm, 1mm))
  Body1, Body1_1 [aluminum_real] = imported_body(D:\Karl,reverseengineer\core_assembled_flatwise_kaptonv2.step)
  Body1_2 [Acrylic Resin-JSME] = imported_body(D:\Karl,reverseengineer\core_assembled_flatwise_kaptonv2.step)
  Body1_3, Body1_4 [aluminum_real] = imported_body(D:\Karl,reverseengineer\core_assembled_flatwise_kaptonv2.step)
  Body1_5 [Acrylic Resin-JSME] = imported_body(D:\Karl,reverseengineer\core_assembled_flatwise_kaptonv2.step)
  plate_1, plate_2 [silicon_TIMreal] = imported_body(D:\Karl,reverseengineer\core_assembled_flatwise_kaptonv2.step)
  Body118, Body124, Body111, Body110, Body120, Body114, Body117, Body119, Body122, Body109, Body113, Body123, Body115, Body112, Body116, Body121 [kapton_real] = imported_body(D:\Karl,reverseengineer\core_assembled_flatwise_kaptonv2.step)
  Np1, Np3, Np5, Np7, Ns8, Ns6, Ns4, Ns2, Ns1, Ns3, Ns5, Ns7, Np8, Np6, Np4, Np2 [coppe_real] = imported_body(D:\Karl,reverseengineer\core_assembled_flatwise_kaptonv2.step)
  Box3 [non-model] = box(corner=(6.44mm, -7.86mm, 6.29mm), size=(25.72mm, 66.62mm, 6.12mm))
  group core_assembled_flatwise_kaptonv2 = Body1, Body1_1..Body1_5, plate_1, plate_2, Body118, Body124, Body111, Body110, Body120, Body114, Body117, Body119, Body122, Body109, Body113, Body123, Body115, Body112, Body116, Body121, Np1, Np3, Np5, Np7, Ns8, Ns6, Ns4, Ns2, Ns1, Ns3, Ns5, Ns7, Np8, Np6, Np4, Np2
boundaries and excitations:
  Opening1: Opening Faces=Region.face(-y) Temperature=AmbientTemp External_Rad._Temperature=AmbientRadTemp Inlet_Type=Pressure Total_Pressure=AmbientPressure
  Opening2: Opening Faces=Region.face(+y) Temperature=AmbientTemp External_Rad._Temperature=AmbientRadTemp Inlet_Type=Velocity Static_Pressure=AmbientPressure X_Velocity=0m_per_sec Y_Velocity=0m_per_sec Z_Velocity=0m_per_sec
  EMLoss1: EM Loss Objects=[Body1, Body1_1, Body1_3, Body1_4, Np1..Np8, Ns1..Ns8, Body1_2, Body1_5] LinkID=705 Project="This Project*" Product=ElectronicsDesktop Design=Flatwise_0.30_interleaved_new Params{freq_hz=28500Hz} ForceSourceToSolve PreservePartnerSoln PathRelativeTo=TargetProject Intrinsics(28.5kHz) LossMultiplier=1
mesh:
  MeshRegions:  Global{MeshMethod=MesherHD ComputeGap MeshRegionResolution=5 MinGapX=1mm MinGapY=1mm MinGapZ=1mm Objects=Region FacetLevel=5 ProximitySizeFunction CurvatureSizeFunction OptimizePCBMesh} MeshRegion1{MeshMethod=MesherHD UserSpecifiedSettings MaxElementSizeX=0.965mm MaxElementSizeY=1.7115mm MaxElementSizeZ=0.465mm MinElementsInGap=4 MinElementsOnEdge=2 MaxSizeRatio=2 EnableMLM EnforeMLMType=3D MaxLevels=0 BufferLayers=0 UniformMeshParametersType=Average 2DMLMType=2DMLM_None MinGapX=1mm MinGapY=0.05mm MinGapZ=1mm Objects=Box1 ProximitySizeFunction CurvatureSizeFunction OptimizePCBMesh} MeshRegion2{disabled MeshMethod=MesherHD MeshRegionResolution=4 MinGapX=1mm MinGapY=1mm MinGapZ=1mm Objects=Box2 ProximitySizeFunction CurvatureSizeFunction OptimizePCBMesh} MeshRegion3{MeshMethod=MesherHD MeshRegionResolution=4 MinGapX=1mm MinGapY=1mm MinGapZ=1mm Objects=Box3 ProximitySizeFunction CurvatureSizeFunction OptimizePCBMesh}
  MeshOperations:  MeshOperation1{disabled MaxLevel=3 MinLevel=2 Local_Mesh_Parameters_Enabled Objects=[Body109..Body124] Local_Mesh_Parameters_Type="CAD Local Mesh Parameters" X_count=100 Y_count=100 Z_count=100 Facet_Level=1}
setups:
  Setup1: IcepakSteadyState Flow_Regime=Laminar Include_Temperature=true Include_Flow=true Include_Gravity Solution_Initialization_-_Z_Velocity=0.000980665m_per_sec Convergence_Criteria_-_Flow=0.001 Convergence_Criteria_-_Energy=1e-07 Convergence_Criteria_-_Discrete_Ordinates=1e-06 Radiation_Model="Discrete Ordinates Model" Flow_Iteration_Per_Radiation_Iteration=10 ThetaDivision=2 PhiDivision=2 ThetaPixels=2 PhiPixels=2 Under-relaxation_-_Pressure=0.7 Under-relaxation_-_Momentum=0.3 Under-relaxation_-_Temperature=1 Discretization_Scheme_-_Pressure=Standard Discretization_Scheme_-_Momentum=First Discretization_Scheme_-_Temperature=First Discretization_Scheme_-_Discrete_Ordinates=First Convergence_Criteria_-_Max_Iterations=10000
field plots:
  Temperature1: Temperature over Body1, Body1_1..Body1_5, plate_1, plate_2, Body118, Body124, Body111, Body110, Body120, Body114, Body117, Body119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 on Setup1 : SteadyState
