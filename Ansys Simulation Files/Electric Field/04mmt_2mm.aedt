# Ansys Electronics Desktop project, version 2023.1
materials:
  air: permittivity=1.0006 permeability=1.0000004
  coppe_real: permeability=0.999991 conductivity=59880239.52
  ferrite - real2: core_loss_curve{25kHz (0, 0) (0.050633, 1) (0.0590114, 1.50406) (0.0691674, 2.34392) (0.0792528, 3.65275) (0.088772, 5.02746) (0.0939521, 6.11121) (0.1, 7.16954) (0.109499, 8.56175) (0.121957, 11.5767) (0.138164, 16.5092) (0.153013, 23.1293) (0.173347, 32.9841) (0.195272, 44.5991) (0.21382, 61.3838) (0.235462, 78.6962) (0.259294, 104.536) (0.280722, 138.862) (0.295422, 151.746)} core_loss_curve{100kHz (0, 0) (0.0263744, 1.03613) (0.0293752, 1.42608) (0.0332788, 2.03369) (0.0396755, 3.1693) (0.0449479, 4.44016) (0.0523856, 6.91954) (0.0628101, 11.373) (0.0753091, 20.068) (0.0882699, 32.4039) (0.103461, 49.6099) (0.118547, 74.6161) (0.142138, 118.363) (0.165658, 191.122) (0.184506, 245.025) (0.1975, 325.48) (0.215037, 409.937) (0.242235, 554.291) (0.26827, 762.898) (0.287163, 911.04)} core_loss_curve{200kHz (0, 0) (0.0153013, 1.07357) (0.0196383, 2.03369) (0.0260769, 4.28533) (0.0305648, 7.42858) (0.0396755, 14.0722) (0.0481134, 22.7224) (0.059347, 38.6962) (0.0757374, 74.6161) (0.0994345, 162.909) (0.110748, 216.401) (0.130546, 319.755) (0.147894, 472.47) (0.164721, 605.722) (0.183462, 848.612) (0.194168, 1013.4) (0.210213, 1167.99) (0.235462, 1607.55) (0.252045, 2024.69) (0.274425, 2333.54) (0.290439, 2939.06)} core_loss_curve{500kHz (0, 0) (0.0101716, 5.89811) (0.01199, 8.71505) (0.0149581, 13.5815) (0.0170423, 18.6929) (0.0202031, 30.1834) (0.0235462, 38.6962) (0.0266752, 55.1837) (0.0309135, 72.0142) (0.0356225, 99.1166) (0.0401281, 129.346) (0.0465037, 187.76) (0.0515018, 236.481) (0.0580159, 319.755) (0.067616, 447.974) (0.0761681, 574.318) (0.0892769, 776.557) (0.101141, 1068.81) (0.1199, 1524.21) (0.142138, 2292.49) (0.174333, 3327.81) (0.199753, 5186.04) (0.22248, 6531.74) (0.249202, 8373.92)} permittivity=12 permeability=3300 conductivity=0.25 core_loss_type="Power Ferrite" core_loss_cm=2.0420624 core_loss_x=1.4062949 core_loss_y=2.7267175 mass_density=4800 core_loss_equiv_cut_depth=0.001meter
  silicon_TIMreal: permittivity=7 conductivity=1e-11
  vacuum: permittivity=1

design 100kW (Maxwell 2D, Electrostatic, XY geometry, model units mm)
geometry:
  Rectangle1 [ferrite - real2] = rectangle(corner=(0mm, 0mm, 0mm), x_size=2*$Core_width+$l_TIM, y_size=2*$Core_Height+$l_g)
  Rectangle2 = rectangle(corner=($Core_width, $Core_width+$d_TIM, 0mm), x_size=$l_TIM, y_size=$h_wire)
  air_gap = rectangle(corner=(0mm, $Core_Height, 0mm), x_size=$Core_width, y_size=$l_g)
  Rectangle3 = rectangle(corner=($Core_width+$l_TIM, $Core_Height, 0mm), x_size=$Core_width, y_size=$l_g)
  Rectangle4 [silicon_TIMreal] = rectangle(corner=($Core_width, $Core_width, 0mm), x_size=$l_TIM, y_size=$d_TIM)
  Rectangle1.subtract(Rectangle2)
  Rectangle5 [silicon_TIMreal] = rectangle(corner=($Core_width, $Core_width+$d_TIM+$h_wire, 0mm), x_size=$l_TIM, y_size=$d_TIM)
  N_1 [coppe_real] = rectangle(corner=($Core_width+$d_clear, $Core_width+$d_TIM, 0mm), x_size=$w_wire, y_size=$h_wire)
  S_1 [coppe_real] = rectangle(corner=($Core_width+$d_clear+$w_wire*1+$d_inter*1, $d_TIM+$Core_width, 0mm), x_size=$w_wire, y_size=$h_wire)
  N_2 [coppe_real] = rectangle(corner=($Core_width+$d_clear+$w_wire*2+$d_inter*2, $d_TIM+$Core_width, 0mm), x_size=$w_wire, y_size=$h_wire)
  S_2 [coppe_real] = rectangle(corner=($Core_width+$d_clear+$w_wire*3+$d_inter*3, $d_TIM+$Core_width, 0mm), x_size=$w_wire, y_size=$h_wire)
  Rectangle1.subtract(air_gap)
  Rectangle1.subtract(Rectangle3)
  Rectangle4_1 = Rectangle4.copy()
  Rectangle5_1 = Rectangle5.copy()
  Rectangle1.subtract(Rectangle4_1, Rectangle5_1)
  Region [air] = region(percentage_offset: +X=50, -X=0, +Y=50, -Y=50, +Z=0, -Z=0)
  Rectangle6 [air] = rectangle(corner=(0mm, 0mm, 0mm), x_size=$l_TIM+2*$Core_width, y_size=$Core_Height*2+$l_g)
boundaries and excitations:
  Symmetry1: Symmetry Edges=Region.edge(at (0, 20.05, 0)) IsOdd=false
  Balloon1: Balloon Edges=Region.edge(at (23.7, 60.15, 0), at (47.4, 20.05, 0), at (23.7, -20.05, 0)) IsOfTypeVoltage=false
  Primary: Voltage Objects=[N_1, N_2] Value=3100V
  Secondary: Voltage Objects=[S_1, S_2] Value=0V
mesh:
  EdgeCut1: EdgeCutLayerMesh Objects=Rectangle6 Layer_Thickenss=0.05mm
  EdgeCut2: EdgeCutLayerMesh Objects=[N_1, N_2, S_1, S_2] Layer_Thickenss=0.05mm
  EdgeCut3: EdgeCutLayerMesh Objects=[Rectangle4, Rectangle5] Layer_Thickenss=0.05mm
  EdgeCut4: EdgeCutLayerMesh Objects=Rectangle1 Layer_Thickenss=0.05mm
setups:
  Setup1: Electrostatic MaximumPasses=20 MinimumPasses=10 MinimumConvergedPasses=1 PercentRefinement=70 PercentError=0.5 NonLinearResidual=0.001
field plots:
  Mag_E1: E over Rectangle6 on Setup1 : LastAdaptive
  Mag_E2: E over Rectangle4, Rectangle5 on Setup1 : LastAdaptive
  Mesh1: MeshPlots over Rectangle6 on Setup1 : LastAdaptive
  Mesh2: MeshPlots over Rectangle6, Region, N_1, N_2, S_1, S_2, Rectangle1, Rectangle4, Rectangle5 on Setup1 : LastAdaptive

design 10kW (Maxwell 2D, Electrostatic, XY geometry, model units mm)
geometry:
  Rectangle1 [ferrite - real2] = rectangle(corner=(0mm, 0mm, 0mm), x_size=2*$Core_width+$l_TIM, y_size=2*$Core_Height+$l_g)
  Rectangle2 = rectangle(corner=($Core_width, $Core_width+$d_TIM, 0mm), x_size=$l_TIM, y_size=$h_wire)
  air_gap = rectangle(corner=(0mm, $Core_Height, 0mm), x_size=$Core_width, y_size=$l_g)
  Rectangle3 = rectangle(corner=($Core_width+$l_TIM, $Core_Height, 0mm), x_size=$Core_width, y_size=$l_g)
  Rectangle4 [silicon_TIMreal] = rectangle(corner=($Core_width, $Core_width, 0mm), x_size=$l_TIM, y_size=$d_TIM)
  Rectangle1.subtract(Rectangle2)
  Rectangle5 [silicon_TIMreal] = rectangle(corner=($Core_width, $Core_width+$d_TIM+$h_wire, 0mm), x_size=$l_TIM, y_size=$d_TIM)
  N_1 [coppe_real] = rectangle(corner=($Core_width+$d_clear, $Core_width+$d_TIM, 0mm), x_size=$w_wire, y_size=$h_wire)
  S_1 [coppe_real] = rectangle(corner=($Core_width+$d_clear+$w_wire*1+$d_inter*1, $d_TIM+$Core_width, 0mm), x_size=$w_wire, y_size=$h_wire)
  N_2 [coppe_real] = rectangle(corner=($Core_width+$d_clear+$w_wire*2+$d_inter*2, $d_TIM+$Core_width, 0mm), x_size=$w_wire, y_size=$h_wire)
  S_2 [coppe_real] = rectangle(corner=($Core_width+$d_clear+$w_wire*3+$d_inter*3, $d_TIM+$Core_width, 0mm), x_size=$w_wire, y_size=$h_wire)
  Rectangle1.subtract(air_gap)
  Rectangle1.subtract(Rectangle3)
  Rectangle4_1 = Rectangle4.copy()
  Rectangle5_1 = Rectangle5.copy()
  Rectangle1.subtract(Rectangle4_1, Rectangle5_1)
  Region [air] = region(percentage_offset: +X=50, -X=0, +Y=50, -Y=50, +Z=0, -Z=0)
  Rectangle6 [air] = rectangle(corner=(0mm, 0mm, 0mm), x_size=$l_TIM+2*$Core_width, y_size=$Core_Height*2+$l_g)
boundaries and excitations:
  Symmetry1: Symmetry Edges=Region.edge(at (0, 20.05, 0)) IsOdd=false
  Balloon1: Balloon Edges=Region.edge(at (23.7, 60.15, 0), at (47.4, 20.05, 0), at (23.7, -20.05, 0)) IsOfTypeVoltage=false
  Primary: Voltage Objects=[N_1, N_2] Value=1000V
  Secondary: Voltage Objects=[S_1, S_2] Value=0V
mesh:
  EdgeCut1: EdgeCutLayerMesh Objects=Rectangle6 Layer_Thickenss=0.05mm
  EdgeCut2: EdgeCutLayerMesh Objects=[N_1, N_2, S_1, S_2] Layer_Thickenss=0.05mm
  EdgeCut3: EdgeCutLayerMesh Objects=[Rectangle4, Rectangle5] Layer_Thickenss=0.05mm
  EdgeCut4: EdgeCutLayerMesh Objects=Rectangle1 Layer_Thickenss=0.05mm
setups:
  Setup1: Electrostatic MaximumPasses=20 MinimumPasses=10 MinimumConvergedPasses=1 PercentRefinement=70 PercentError=0.5 NonLinearResidual=0.001
field plots:
  Mag_E1: E over Rectangle6 on Setup1 : LastAdaptive
  Mag_E2: E over Rectangle4, Rectangle5 on Setup1 : LastAdaptive
  Mesh1: MeshPlots over Rectangle6 on Setup1 : LastAdaptive
  Mesh2: MeshPlots over Rectangle6, Region, N_1, N_2, S_1, S_2, Rectangle1, Rectangle4, Rectangle5 on Setup1 : LastAdaptive
