# Ansys Electronics Desktop project, version 2023.1
project datasets:
  $f_Pcv: (94451.011, 10.239803) (100000, 11.257915) (111386.35, 13.607888) (122505.13, 15.87399) (133035.31, 18.517463) (139960.51, 20.118799) (151030.05, 22.919537) (165055.82, 26.110164) (176983.95, 29.394602) (185019.55, 31.56039) (190981.69, 33.486623) (199652.84, 35.953911) (212727.53, 40.476609) (223801.12, 45.031488) (236949.42, 50.098933) (247707.64, 54.431344) (257316.91, 58.441835) (265608.78, 62.747818) (279435.12, 68.986642) (292122.32, 74.952408) (299629.12, 79.526996) (311252.57, 85.38653) (323326.93, 90.597946) (333745.93, 96.127432) (342322.36, 100.79304) (353353.47, 106.94476) (362433.76, 112.13539) (374112.96, 117.57795) (383726.72, 124.75412) (396092.07, 133.94598) (408855.88, 142.12113) (424716.54, 152.59259) (435630.68, 165.78836) (443999.95, 173.835) (455409.62, 182.27219) (467112.5, 193.39685) (482164.9, 205.20049) (500869.42, 225.60295) (520299.54, 242.22533) (540483.41, 266.30906) (557900.14, 289.33869) (575878.12, 306.99797) (598218.04, 333.54627) (621424.58, 358.1219) (641449.59, 384.50825) (657933.22, 412.83874) (674840.44, 432.87613) (696586.75, 453.88604) (714487.26, 487.32828) (732847.78, 517.0715) (756463.33, 548.63005) (775902.52, 575.25815) (795841.25, 610.36801) (821486.73, 655.33981) (847958.61, 703.62512) (880853.29, 764.47259) (909238.23, 811.13083) (938537.85, 870.89479) (962655.89, 924.04832) (987393.71, 968.89758)
materials:
  aluminum: permeability=1.000021 conductivity=38000000
  copper: permeability=0.999991 conductivity=58000000
  ferrite - Copy (2): core_loss_curve{25kHz (0, 0) (0.050633, 1) (0.0590114, 1.50406) (0.0691674, 2.34392) (0.0792528, 3.65275) (0.088772, 5.02746) (0.0939521, 6.11121) (0.1, 7.16954) (0.109499, 8.56175) (0.121957, 11.5767) (0.138164, 16.5092) (0.153013, 23.1293) (0.173347, 32.9841) (0.195272, 44.5991) (0.21382, 61.3838) (0.235462, 78.6962) (0.259294, 104.536) (0.280722, 138.862) (0.295422, 151.746)} core_loss_curve{100kHz (0, 0) (0.0263744, 1.03613) (0.0293752, 1.42608) (0.0332788, 2.03369) (0.0396755, 3.1693) (0.0449479, 4.44016) (0.0523856, 6.91954) (0.0628101, 11.373) (0.0753091, 20.068) (0.0882699, 32.4039) (0.103461, 49.6099) (0.118547, 74.6161) (0.142138, 118.363) (0.165658, 191.122) (0.184506, 245.025) (0.1975, 325.48) (0.215037, 409.937) (0.242235, 554.291) (0.26827, 762.898) (0.287163, 911.04)} core_loss_curve{200kHz (0, 0) (0.0153013, 1.07357) (0.0196383, 2.03369) (0.0260769, 4.28533) (0.0305648, 7.42858) (0.0396755, 14.0722) (0.0481134, 22.7224) (0.059347, 38.6962) (0.0757374, 74.6161) (0.0994345, 162.909) (0.110748, 216.401) (0.130546, 319.755) (0.147894, 472.47) (0.164721, 605.722) (0.183462, 848.612) (0.194168, 1013.4) (0.210213, 1167.99) (0.235462, 1607.55) (0.252045, 2024.69) (0.274425, 2333.54) (0.290439, 2939.06)} core_loss_curve{500kHz (0, 0) (0.0101716, 5.89811) (0.01199, 8.71505) (0.0149581, 13.5815) (0.0170423, 18.6929) (0.0202031, 30.1834) (0.0235462, 38.6962) (0.0266752, 55.1837) (0.0309135, 72.0142) (0.0356225, 99.1166) (0.0401281, 129.346) (0.0465037, 187.76) (0.0515018, 236.481) (0.0580159, 319.755) (0.067616, 447.974) (0.0761681, 574.318) (0.0892769, 776.557) (0.101141, 1068.81) (0.1199, 1524.21) (0.142138, 2292.49) (0.174333, 3327.81) (0.199753, 5186.04) (0.22248, 6531.74) (0.249202, 8373.92)} permittivity=12 permeability=3400 conductivity=0.25 core_loss_type="Power Ferrite" core_loss_cm=0.062032234 core_loss_x=1.7066326 core_loss_y=2.5354555 mass_density=4800 core_loss_equiv_cut_depth=0.001meter
  silicon - Copy: permittivity=9
  vacuum: permittivity=1
  air: permittivity=1.0006 permeability=1.0000004
  Al-Extruded
  coppe_real: permeability=0.999991 conductivity=59880239.52
  ferrite - real: core_loss_curve{25kHz (0, 0) (0.050633, 1) (0.0590114, 1.50406) (0.0691674, 2.34392) (0.0792528, 3.65275) (0.088772, 5.02746) (0.0939521, 6.11121) (0.1, 7.16954) (0.109499, 8.56175) (0.121957, 11.5767) (0.138164, 16.5092) (0.153013, 23.1293) (0.173347, 32.9841) (0.195272, 44.5991) (0.21382, 61.3838) (0.235462, 78.6962) (0.259294, 104.536) (0.280722, 138.862) (0.295422, 151.746)} core_loss_curve{100kHz (0, 0) (0.0263744, 1.03613) (0.0293752, 1.42608) (0.0332788, 2.03369) (0.0396755, 3.1693) (0.0449479, 4.44016) (0.0523856, 6.91954) (0.0628101, 11.373) (0.0753091, 20.068) (0.0882699, 32.4039) (0.103461, 49.6099) (0.118547, 74.6161) (0.142138, 118.363) (0.165658, 191.122) (0.184506, 245.025) (0.1975, 325.48) (0.215037, 409.937) (0.242235, 554.291) (0.26827, 762.898) (0.287163, 911.04)} core_loss_curve{200kHz (0, 0) (0.0153013, 1.07357) (0.0196383, 2.03369) (0.0260769, 4.28533) (0.0305648, 7.42858) (0.0396755, 14.0722) (0.0481134, 22.7224) (0.059347, 38.6962) (0.0757374, 74.6161) (0.0994345, 162.909) (0.110748, 216.401) (0.130546, 319.755) (0.147894, 472.47) (0.164721, 605.722) (0.183462, 848.612) (0.194168, 1013.4) (0.210213, 1167.99) (0.235462, 1607.55) (0.252045, 2024.69) (0.274425, 2333.54) (0.290439, 2939.06)} core_loss_curve{500kHz (0, 0) (0.0101716, 5.89811) (0.01199, 8.71505) (0.0149581, 13.5815) (0.0170423, 18.6929) (0.0202031, 30.1834) (0.0235462, 38.6962) (0.0266752, 55.1837) (0.0309135, 72.0142) (0.0356225, 99.1166) (0.0401281, 129.346) (0.0465037, 187.76) (0.0515018, 236.481) (0.0580159, 319.755) (0.067616, 447.974) (0.0761681, 574.318) (0.0892769, 776.557) (0.101141, 1068.81) (0.1199, 1524.21) (0.142138, 2292.49) (0.174333, 3327.81) (0.199753, 5186.04) (0.22248, 6531.74) (0.249202, 8373.92)} permittivity=12 permeability=3300 conductivity=0.25 core_loss_type="Power Ferrite" core_loss_cm=2.0420624 core_loss_x=1.4062949 core_loss_y=2.7267175 mass_density=4800 core_loss_equiv_cut_depth=0.001meter
  aluminum_real: permeability=1.000021 conductivity=38000000
  silicon_TIMreal: permittivity=7 conductivity=1e-11
  ferrite - real2: core_loss_curve{25kHz (0, 0) (0.050633, 1) (0.0590114, 1.50406) (0.0691674, 2.34392) (0.0792528, 3.65275) (0.088772, 5.02746) (0.0939521, 6.11121) (0.1, 7.16954) (0.109499, 8.56175) (0.121957, 11.5767) (0.138164, 16.5092) (0.153013, 23.1293) (0.173347, 32.9841) (0.195272, 44.5991) (0.21382, 61.3838) (0.235462, 78.6962) (0.259294, 104.536) (0.280722, 138.862) (0.295422, 151.746)} core_loss_curve{100kHz (0, 0) (0.0263744, 1.03613) (0.0293752, 1.42608) (0.0332788, 2.03369) (0.0396755, 3.1693) (0.0449479, 4.44016) (0.0523856, 6.91954) (0.0628101, 11.373) (0.0753091, 20.068) (0.0882699, 32.4039) (0.103461, 49.6099) (0.118547, 74.6161) (0.142138, 118.363) (0.165658, 191.122) (0.184506, 245.025) (0.1975, 325.48) (0.215037, 409.937) (0.242235, 554.291) (0.26827, 762.898) (0.287163, 911.04)} core_loss_curve{200kHz (0, 0) (0.0153013, 1.07357) (0.0196383, 2.03369) (0.0260769, 4.28533) (0.0305648, 7.42858) (0.0396755, 14.0722) (0.0481134, 22.7224) (0.059347, 38.6962) (0.0757374, 74.6161) (0.0994345, 162.909) (0.110748, 216.401) (0.130546, 319.755) (0.147894, 472.47) (0.164721, 605.722) (0.183462, 848.612) (0.194168, 1013.4) (0.210213, 1167.99) (0.235462, 1607.55) (0.252045, 2024.69) (0.274425, 2333.54) (0.290439, 2939.06)} core_loss_curve{500kHz (0, 0) (0.0101716, 5.89811) (0.01199, 8.71505) (0.0149581, 13.5815) (0.0170423, 18.6929) (0.0202031, 30.1834) (0.0235462, 38.6962) (0.0266752, 55.1837) (0.0309135, 72.0142) (0.0356225, 99.1166) (0.0401281, 129.346) (0.0465037, 187.76) (0.0515018, 236.481) (0.0580159, 319.755) (0.067616, 447.974) (0.0761681, 574.318) (0.0892769, 776.557) (0.101141, 1068.81) (0.1199, 1524.21) (0.142138, 2292.49) (0.174333, 3327.81) (0.199753, 5186.04) (0.22248, 6531.74) (0.249202, 8373.92)} permittivity=12 permeability=3300 conductivity=0.25 core_loss_type="Power Ferrite" core_loss_cm=2.0420624 core_loss_x=1.4062949 core_loss_y=2.7267175 mass_density=4800 core_loss_equiv_cut_depth=0.001meter
  Material1
  ferrite - real - Copy: core_loss_curve{25kHz (0, 0) (0.050633, 1) (0.0590114, 1.50406) (0.0691674, 2.34392) (0.0792528, 3.65275) (0.088772, 5.02746) (0.0939521, 6.11121) (0.1, 7.16954) (0.109499, 8.56175) (0.121957, 11.5767) (0.138164, 16.5092) (0.153013, 23.1293) (0.173347, 32.9841) (0.195272, 44.5991) (0.21382, 61.3838) (0.235462, 78.6962) (0.259294, 104.536) (0.280722, 138.862) (0.295422, 151.746)} core_loss_curve{100kHz (0, 0) (0.0263744, 1.03613) (0.0293752, 1.42608) (0.0332788, 2.03369) (0.0396755, 3.1693) (0.0449479, 4.44016) (0.0523856, 6.91954) (0.0628101, 11.373) (0.0753091, 20.068) (0.0882699, 32.4039) (0.103461, 49.6099) (0.118547, 74.6161) (0.142138, 118.363) (0.165658, 191.122) (0.184506, 245.025) (0.1975, 325.48) (0.215037, 409.937) (0.242235, 554.291) (0.26827, 762.898) (0.287163, 911.04)} core_loss_curve{200kHz (0, 0) (0.0153013, 1.07357) (0.0196383, 2.03369) (0.0260769, 4.28533) (0.0305648, 7.42858) (0.0396755, 14.0722) (0.0481134, 22.7224) (0.059347, 38.6962) (0.0757374, 74.6161) (0.0994345, 162.909) (0.110748, 216.401) (0.130546, 319.755) (0.147894, 472.47) (0.164721, 605.722) (0.183462, 848.612) (0.194168, 1013.4) (0.210213, 1167.99) (0.235462, 1607.55) (0.252045, 2024.69) (0.274425, 2333.54) (0.290439, 2939.06)} core_loss_curve{500kHz (0, 0) (0.0101716, 5.89811) (0.01199, 8.71505) (0.0149581, 13.5815) (0.0170423, 18.6929) (0.0202031, 30.1834) (0.0235462, 38.6962) (0.0266752, 55.1837) (0.0309135, 72.0142) (0.0356225, 99.1166) (0.0401281, 129.346) (0.0465037, 187.76) (0.0515018, 236.481) (0.0580159, 319.755) (0.067616, 447.974) (0.0761681, 574.318) (0.0892769, 776.557) (0.101141, 1068.81) (0.1199, 1524.21) (0.142138, 2292.49) (0.174333, 3327.81) (0.199753, 5186.04) (0.22248, 6531.74) (0.249202, 8373.92)} permittivity=12 permeability=100 conductivity=0.25 core_loss_type="Power Ferrite" core_loss_cm=2.0420624 core_loss_x=1.4062949 core_loss_y=2.7267175 mass_density=4800 core_loss_equiv_cut_depth=0.001meter
  polyimide: permittivity=3.5 dielectric_loss_tangent=0.008
  kapton: permittivity=3.5 conductivity=1e-15 dielectric_loss_tangent=0.008
surface materials:
  Steel-oxidised-surface

design Flatwise_0.30_interleaved_full_old (Maxwell 3D, EddyCurrent, model units mm)
variables:
  freq_hz = 28500Hz
  volt_ac = 141/28500*Freq
geometry:
  Region [vacuum] = region(percentage_offset=0 on all sides)
  Np1..Np8, Ns1..Ns8 [copper] = imported_body(C:\Users\karlr\Documents\ICMaSS_sweeping\flatwise_0.1_0.3.step)
  plate_1, plate_2 [silicon - Copy] = imported_body(C:\Users\karlr\Documents\ICMaSS_sweeping\flatwise_0.1_0.3.step)
  Body1 [ferrite - Copy (2)] = imported_body(C:\Users\karlr\Documents\ICMaSS_sweeping\flatwise_0.1_0.3.step)
  Body1_1, Body1_2 [aluminum] = imported_body(C:\Users\karlr\Documents\ICMaSS_sweeping\flatwise_0.1_0.3.step)
  Body1_3 [ferrite - Copy (2)] = imported_body(C:\Users\karlr\Documents\ICMaSS_sweeping\flatwise_0.1_0.3.step)
  Body1_4, Body1_5 [aluminum] = imported_body(C:\Users\karlr\Documents\ICMaSS_sweeping\flatwise_0.1_0.3.step)
  Np1_Section1 = Np1.section(plane=ZX)
  Np2_Section1 = Np2.section(plane=ZX)
  Np3_Section1 [copper] = Np3.section(plane=ZX)
  Np4_Section1 [copper] = Np4.section(plane=ZX)
  Np5_Section1 [copper] = Np5.section(plane=ZX)
  Np6_Section1 [copper] = Np6.section(plane=ZX)
  Np7_Section1 [copper] = Np7.section(plane=ZX)
  Np8_Section1 [copper] = Np8.section(plane=ZX)
  Ns1_Section1 = Ns1.section(plane=ZX)
  Ns2_Section1 = Ns2.section(plane=ZX)
  Ns3_Section1 [copper] = Ns3.section(plane=ZX)
  Ns4_Section1 [copper] = Ns4.section(plane=ZX)
  Ns5_Section1 [copper] = Ns5.section(plane=ZX)
  Ns6_Section1 [copper] = Ns6.section(plane=ZX)
  Ns7_Section1 [copper] = Ns7.section(plane=ZX)
  Ns8_Section1 [copper] = Ns8.section(plane=ZX)
  Np1_Section1_Separate1 [copper] = Np1_Section1.separate_bodies()
  Np1_Section1.delete()
  Np2_Section1_Separate1 [copper] = Np2_Section1.separate_bodies()
  Np2_Section1.delete()
  Np3_Section1.separate_bodies()
  Np4_Section1.separate_bodies()
  Np5_Section1.separate_bodies()
  Np6_Section1.separate_bodies()
  Np7_Section1.separate_bodies()
  Np8_Section1.separate_bodies()
  Ns1_Section1_Separate1 [copper] = Ns1_Section1.separate_bodies()
  Ns1_Section1.delete()
  Ns2_Section1_Separate1 [copper] = Ns2_Section1.separate_bodies()
  Ns2_Section1.delete()
  Ns3_Section1.separate_bodies()
  Ns4_Section1.separate_bodies()
  Ns5_Section1.separate_bodies()
  Ns6_Section1.separate_bodies()
  Ns7_Section1.separate_bodies()
  Ns8_Section1.separate_bodies()
  Rectangle1 [non-model] = rectangle(corner=(36.6mm, 25.43mm, 1.6666608e-08mm), z_size=18.666667mm, x_size=-36.6mm)
  [Np1..Np8, Ns1..Ns8, plate_1, plate_2, Body1, Body1_1..Body1_5, Np3_Section1, Np4_Section1, Np5_Section1, Np6_Section1, Np7_Section1, Np8_Section1, Ns3_Section1, Ns4_Section1, Ns5_Section1, Ns6_Section1, Ns7_Section1, Ns8_Section1, Np1_Section1_Separate1, Np2_Section1_Separate1, Ns1_Section1_Separate1, Ns2_Section1_Separate1, Rectangle1].move(-18.3mm, -25.43mm, -0.38333333mm)
  [Np1..Np8, Ns1..Ns8, plate_1, plate_2, Body1, Body1_1..Body1_5, Np3_Section1, Np4_Section1, Np5_Section1, Np6_Section1, Np7_Section1, Np8_Section1, Ns3_Section1, Ns4_Section1, Ns5_Section1, Ns6_Section1, Ns7_Section1, Ns8_Section1, Np1_Section1_Separate1, Np2_Section1_Separate1, Ns1_Section1_Separate1, Ns2_Section1_Separate1, Rectangle1].move(-5mm, 0mm, -6.7583333mm)
  Rectangle2 [non-model] = rectangle(corner=(7.3mm, -32.73mm, 2.1916667mm), x_size=-24.6mm, y_size=65.46mm)
  group core_assembled_flatwise = Np1..Np8, Ns1..Ns8, plate_1, plate_2, Np3_Section1, Np4_Section1, Np5_Section1, Np6_Section1, Np7_Section1, Np8_Section1, Ns3_Section1, Ns4_Section1, Ns5_Section1, Ns6_Section1, Ns7_Section1, Ns8_Section1, Np1_Section1_Separate1, Np2_Section1_Separate1, Ns1_Section1_Separate1, Ns2_Section1_Separate1
  group core_together_1 = Body1, Body1_1, Body1_2
  group core_together = Body1_3, Body1_4, Body1_5
boundaries and excitations:
  Ns_1: Coil Terminal Objects=Ns1_Section1_Separate1 Conductor_number=1 Winding=Ns Point_out_of_terminal=true
  Ns_2: Coil Terminal Objects=Ns2_Section1_Separate1 Conductor_number=1 Winding=Ns Point_out_of_terminal=true
  Ns_3: Coil Terminal Objects=Ns3_Section1 Conductor_number=1 Winding=Ns Point_out_of_terminal=true
  Ns_4: Coil Terminal Objects=Ns4_Section1 Conductor_number=1 Winding=Ns Point_out_of_terminal=true
  Ns_5: Coil Terminal Objects=Ns5_Section1 Conductor_number=1 Winding=Ns Point_out_of_terminal=true
  Ns_6: Coil Terminal Objects=Ns6_Section1 Conductor_number=1 Winding=Ns Point_out_of_terminal=true
  Ns_7: Coil Terminal Objects=Ns7_Section1 Conductor_number=1 Winding=Ns Point_out_of_terminal=true
  Ns_8: Coil Terminal Objects=Ns8_Section1 Conductor_number=1 Winding=Ns Point_out_of_terminal=true
  Np_1: Coil Terminal Objects=Np1_Section1_Separate1 Conductor_number=1 Winding=Np Point_out_of_terminal=false
  Np_2: Coil Terminal Objects=Np2_Section1_Separate1 Conductor_number=1 Winding=Np Point_out_of_terminal=false
  Np_3: Coil Terminal Objects=Np3_Section1 Conductor_number=1 Winding=Np Point_out_of_terminal=false
  Np_4: Coil Terminal Objects=Np4_Section1 Conductor_number=1 Winding=Np Point_out_of_terminal=false
  Np_5: Coil Terminal Objects=Np5_Section1 Conductor_number=1 Winding=Np Point_out_of_terminal=false
  Np_6: Coil Terminal Objects=Np6_Section1 Conductor_number=1 Winding=Np Point_out_of_terminal=false
  Np_7: Coil Terminal Objects=Np7_Section1 Conductor_number=1 Winding=Np Point_out_of_terminal=false
  Np_8: Coil Terminal Objects=Np8_Section1 Conductor_number=1 Winding=Np Point_out_of_terminal=false
  Np: Winding Group Type=Voltage IsSolid=true Current=16.36A Resistance=0ohm Inductance=0nH Voltage=volt_ac ParallelBranchesNum=1 Phase=0rad
  Ns: Winding Group Type=Current IsSolid=true Current=1000*1.41/volt_ac*1.414 ParallelBranchesNum=1 Phase=0.1522rad
  core loss on: Body1, Body1_3
parameters:
  Matrix1: Matrix Np, Ns:
mesh:
  Length1: LengthBased Objects=[Body1, Body1_1..Body1_5] MaxLength=2mm
  SkinDepth1: SkinDepthBased Objects=[Np1..Np8, Ns1..Ns8, plate_1, plate_2] SkinDepth=0.020898162mm SurfTriMaxLength=1mm NumLayers=2
  initial mesh: GlobalSurfApproximation{CurvedSurfaceApproxChoice=UseSlider SliderMeshSettings=9} GlobalCurvilinear{Apply}
setups:
  Setup1: EddyCurrent MaximumPasses=20 MinimumPasses=2 MinimumConvergedPasses=1 PercentRefinement=30 PercentError=1 NonLinearResidual=0.0001 SmoothBHCurve Frequency=10MHz SweepRanges{0.1Hz to 1Hz, log, 1 per decade 1Hz to 1000Hz, log, 5 per decade 1000Hz to 10000Hz, log, 10 per decade 10000Hz to 100000Hz, log, 10 per decade 100000Hz to 1000000Hz, log, 10 per decade} SaveAllFields
field plots:
  Mag_B1: B over a plane on Setup1 : LastAdaptive at Freq=1MHz Phase=45deg
  Mesh1: MeshPlots in Np1..Np8, Ns1..Ns8 on Setup1 : LastAdaptive at Freq=1000000Hz Phase=0deg
  Mesh2: MeshPlots over a plane on Setup1 : LastAdaptive at Freq=10000000Hz Phase=0deg
  Mag_J1: J over a plane on Setup1 : LastAdaptive at Freq=25.1189kHz Phase=45deg
reports:
  L Table 1: Matrix1.L(Np,Np), Matrix1.L(Ns,Np), Matrix1.L(Np,Ns), Matrix1.L(Ns,Ns), Matrix1.R(Np,Np), Matrix1.R(Ns,Np), Matrix1.R(Np,Ns), Matrix1.R(Ns,Ns) vs Freq on Setup1 : LastAdaptive

design Flatwise_0.30_interleaved_fullmesh (Maxwell 3D, EddyCurrent, model units mm)
variables:
  freq_hz = 28500Hz
  volt_ac = 141/28500*Freq
geometry:
  Region [vacuum] = region(percentage_offset=0 on all sides)
  Np1..Np8, Ns1..Ns8 [coppe_real] = imported_body(C:\Users\karlr\Documents\ICMaSS_sweeping\flatwise_0.1_0.3.step)
  plate_1, plate_2 [silicon - Copy] = imported_body(C:\Users\karlr\Documents\ICMaSS_sweeping\flatwise_0.1_0.3.step)
  Body1 [ferrite - real] = imported_body(C:\Users\karlr\Documents\ICMaSS_sweeping\flatwise_0.1_0.3.step)
  Body1_1, Body1_2 [aluminum] = imported_body(C:\Users\karlr\Documents\ICMaSS_sweeping\flatwise_0.1_0.3.step)
  Body1_3 [ferrite - Copy (2)] = imported_body(C:\Users\karlr\Documents\ICMaSS_sweeping\flatwise_0.1_0.3.step)
  Body1_4, Body1_5 [aluminum] = imported_body(C:\Users\karlr\Documents\ICMaSS_sweeping\flatwise_0.1_0.3.step)
  Np1_Section1 = Np1.section(plane=ZX)
  Np2_Section1 = Np2.section(plane=ZX)
  Np3_Section1 [copper] = Np3.section(plane=ZX)
  Np4_Section1 [copper] = Np4.section(plane=ZX)
  Np5_Section1 [copper] = Np5.section(plane=ZX)
  Np6_Section1 [copper] = Np6.section(plane=ZX)
  Np7_Section1 [copper] = Np7.section(plane=ZX)
  Np8_Section1 [copper] = Np8.section(plane=ZX)
  Ns1_Section1 = Ns1.section(plane=ZX)
  Ns2_Section1 = Ns2.section(plane=ZX)
  Ns3_Section1 [copper] = Ns3.section(plane=ZX)
  Ns4_Section1 [copper] = Ns4.section(plane=ZX)
  Ns5_Section1 [copper] = Ns5.section(plane=ZX)
  Ns6_Section1 [copper] = Ns6.section(plane=ZX)
  Ns7_Section1 [copper] = Ns7.section(plane=ZX)
  Ns8_Section1 [copper] = Ns8.section(plane=ZX)
  Np1_Section1_Separate1 [copper] = Np1_Section1.separate_bodies()
  Np1_Section1.delete()
  Np2_Section1_Separate1 [copper] = Np2_Section1.separate_bodies()
  Np2_Section1.delete()
  Np3_Section1.separate_bodies()
  Np4_Section1.separate_bodies()
  Np5_Section1.separate_bodies()
  Np6_Section1.separate_bodies()
  Np7_Section1.separate_bodies()
  Np8_Section1.separate_bodies()
  Ns1_Section1_Separate1 [copper] = Ns1_Section1.separate_bodies()
  Ns1_Section1.delete()
  Ns2_Section1_Separate1 [copper] = Ns2_Section1.separate_bodies()
  Ns2_Section1.delete()
  Ns3_Section1.separate_bodies()
  Ns4_Section1.separate_bodies()
  Ns5_Section1.separate_bodies()
  Ns6_Section1.separate_bodies()
  Ns7_Section1.separate_bodies()
  Ns8_Section1.separate_bodies()
  Rectangle1 [non-model] = rectangle(corner=(36.6mm, 25.43mm, 1.6666608e-08mm), z_size=18.666667mm, x_size=-36.6mm)
  [Np1..Np8, Ns1..Ns8, plate_1, plate_2, Body1, Body1_1..Body1_5, Np3_Section1, Np4_Section1, Np5_Section1, Np6_Section1, Np7_Section1, Np8_Section1, Ns3_Section1, Ns4_Section1, Ns5_Section1, Ns6_Section1, Ns7_Section1, Ns8_Section1, Np1_Section1_Separate1, Np2_Section1_Separate1, Ns1_Section1_Separate1, Ns2_Section1_Separate1, Rectangle1].move(-18.3mm, -25.43mm, -0.38333333mm)
  [Np1..Np8, Ns1..Ns8, plate_1, plate_2, Body1, Body1_1..Body1_5, Np3_Section1, Np4_Section1, Np5_Section1, Np6_Section1, Np7_Section1, Np8_Section1, Ns3_Section1, Ns4_Section1, Ns5_Section1, Ns6_Section1, Ns7_Section1, Ns8_Section1, Np1_Section1_Separate1, Np2_Section1_Separate1, Ns1_Section1_Separate1, Ns2_Section1_Separate1, Rectangle1].move(-5mm, 0mm, -6.7583333mm)
  group core_assembled_flatwise = Np1..Np8, Ns1..Ns8, plate_1, plate_2, Np3_Section1, Np4_Section1, Np5_Section1, Np6_Section1, Np7_Section1, Np8_Section1, Ns3_Section1, Ns4_Section1, Ns5_Section1, Ns6_Section1, Ns7_Section1, Ns8_Section1, Np1_Section1_Separate1, Np2_Section1_Separate1, Ns1_Section1_Separate1, Ns2_Section1_Separate1
  group core_together_1 = Body1, Body1_1, Body1_2
  group core_together = Body1_3, Body1_4, Body1_5
boundaries and excitations:
  Ns_1: Coil Terminal Objects=Ns1_Section1_Separate1 Conductor_number=1 Winding=Ns Point_out_of_terminal=true
  Ns_2: Coil Terminal Objects=Ns2_Section1_Separate1 Conductor_number=1 Winding=Ns Point_out_of_terminal=true
  Ns_3: Coil Terminal Objects=Ns3_Section1 Conductor_number=1 Winding=Ns Point_out_of_terminal=true
  Ns_4: Coil Terminal Objects=Ns4_Section1 Conductor_number=1 Winding=Ns Point_out_of_terminal=true
  Ns_5: Coil Terminal Objects=Ns5_Section1 Conductor_number=1 Winding=Ns Point_out_of_terminal=true
  Ns_6: Coil Terminal Objects=Ns6_Section1 Conductor_number=1 Winding=Ns Point_out_of_terminal=true
  Ns_7: Coil Terminal Objects=Ns7_Section1 Conductor_number=1 Winding=Ns Point_out_of_terminal=true
  Ns_8: Coil Terminal Objects=Ns8_Section1 Conductor_number=1 Winding=Ns Point_out_of_terminal=true
  Np_1: Coil Terminal Objects=Np1_Section1_Separate1 Conductor_number=1 Winding=Np Point_out_of_terminal=false
  Np_2: Coil Terminal Objects=Np2_Section1_Separate1 Conductor_number=1 Winding=Np Point_out_of_terminal=false
  Np_3: Coil Terminal Objects=Np3_Section1 Conductor_number=1 Winding=Np Point_out_of_terminal=false
  Np_4: Coil Terminal Objects=Np4_Section1 Conductor_number=1 Winding=Np Point_out_of_terminal=false
  Np_5: Coil Terminal Objects=Np5_Section1 Conductor_number=1 Winding=Np Point_out_of_terminal=false
  Np_6: Coil Terminal Objects=Np6_Section1 Conductor_number=1 Winding=Np Point_out_of_terminal=false
  Np_7: Coil Terminal Objects=Np7_Section1 Conductor_number=1 Winding=Np Point_out_of_terminal=false
  Np_8: Coil Terminal Objects=Np8_Section1 Conductor_number=1 Winding=Np Point_out_of_terminal=false
  Np: Winding Group Type=Voltage IsSolid=true Current=16.36A Resistance=0ohm Inductance=0nH Voltage=volt_ac ParallelBranchesNum=1 Phase=0rad
  Ns: Winding Group Type=Current IsSolid=true Current=1000*1.41/volt_ac*1.414 ParallelBranchesNum=1 Phase=0.1522rad
  core loss on: Body1, Body1_3
parameters:
  Matrix1: Matrix Np, Ns:
mesh:
  Length1: LengthBased Objects=[Body1, Body1_1..Body1_5] MaxLength=2mm
  SkinDepth1: SkinDepthBased Objects=[Np1..Np8, Ns1..Ns8, plate_1, plate_2] SkinDepth=0.20567444mm SurfTriMaxLength=0.3mm NumLayers=2
  initial mesh: GlobalSurfApproximation{CurvedSurfaceApproxChoice=UseSlider SliderMeshSettings=9} GlobalCurvilinear{Apply}
setups:
  Setup1: EddyCurrent MaximumPasses=20 MinimumPasses=2 MinimumConvergedPasses=1 PercentRefinement=30 PercentError=1 NonLinearResidual=0.0001 SmoothBHCurve Frequency=100kHz SweepRanges{point 28500Hz} SaveAllFields
field plots:
  Mag_B1: B over a plane on Setup1 : LastAdaptive at Freq=28500Hz Phase=45deg
  Mesh1: MeshPlots in Np1..Np8, Ns1..Ns8 on Setup1 : LastAdaptive at Freq=28500Hz Phase=0deg
reports:
  L Table 1: Matrix1.L(Np,Np), Matrix1.L(Ns,Np), Matrix1.L(Np,Ns), Matrix1.L(Ns,Ns), Matrix1.R(Np,Np), Matrix1.R(Ns,Np), Matrix1.R(Np,Ns), Matrix1.R(Ns,Ns) vs Freq on Setup1 : LastAdaptive

design Edgewise_0.30_interleaved_new (Maxwell 3D, EddyCurrent, model units mm)
variables:
  freq_hz = 28500Hz
  volt_ac = 141/28500*Freq
geometry:
  Region [vacuum] = region(percentage_offset=0 on all sides)
  Body1 [ferrite - real] = imported_body(D:\Karl,reverseengineer\core_assembled_edgewise.step)
  Body1_1, Body1_2 [aluminum_real] = imported_body(D:\Karl,reverseengineer\core_assembled_edgewise.step)
  Body1_3 [ferrite - real] = imported_body(D:\Karl,reverseengineer\core_assembled_edgewise.step)
  Body1_4, Body1_5 [aluminum_real] = imported_body(D:\Karl,reverseengineer\core_assembled_edgewise.step)
  Np6, Np2, Np3, Np7, Np5, Np1, Np4, Np8, Ns6, Ns2, Ns3, Ns7, Ns5, Ns1, Ns4, Ns8 [coppe_real] = imported_body(D:\Karl,reverseengineer\core_assembled_edgewise.step)
  plate2, plate1 [silicon_TIMreal] = imported_body(D:\Karl,reverseengineer\core_assembled_edgewise.step)
  Np1_Section2 [coppe_real] = Np1.section(plane=ZX)
  Np2_Section2 [coppe_real] = Np2.section(plane=ZX)
  Np3_Section2 [coppe_real] = Np3.section(plane=ZX)
  Np4_Section2 [coppe_real] = Np4.section(plane=ZX)
  Np5_Section2 [coppe_real] = Np5.section(plane=ZX)
  Np6_Section2 [coppe_real] = Np6.section(plane=ZX)
  Np7_Section2 [coppe_real] = Np7.section(plane=ZX)
  Np8_Section2 [coppe_real] = Np8.section(plane=ZX)
  Ns1_Section2 [coppe_real] = Ns1.section(plane=ZX)
  Ns2_Section2 [coppe_real] = Ns2.section(plane=ZX)
  Ns3_Section2 [coppe_real] = Ns3.section(plane=ZX)
  Ns4_Section2 [coppe_real] = Ns4.section(plane=ZX)
  Ns5_Section2 [coppe_real] = Ns5.section(plane=ZX)
  Ns6_Section2 [coppe_real] = Ns6.section(plane=ZX)
  Ns7_Section2 [coppe_real] = Ns7.section(plane=ZX)
  Ns8_Section2 [coppe_real] = Ns8.section(plane=ZX)
  Np1_Section2.separate_bodies()
  Np2_Section2.separate_bodies()
  Np3_Section2.separate_bodies()
  Np4_Section2.separate_bodies()
  Np5_Section2.separate_bodies()
  Np6_Section2.separate_bodies()
  Np7_Section2.separate_bodies()
  Np8_Section2.separate_bodies()
  Ns1_Section2.separate_bodies()
  Ns2_Section2.separate_bodies()
  Ns3_Section2.separate_bodies()
  Ns4_Section2.separate_bodies()
  Ns5_Section2.separate_bodies()
  Ns6_Section2.separate_bodies()
  Ns7_Section2.separate_bodies()
  Ns8_Section2.separate_bodies()
  Rectangle1 [non-model] = rectangle(corner=(0mm, 25.43mm, 0mm), z_size=18.6mm, x_size=38.6mm)
  group core_togetherv4 = Body1, Body1_1, Body1_2
  group core_togetherv41 = Body1_3, Body1_4, Body1_5
  group Wire_face_edgewisaev15 = Np6, Np2, Np3, Np7, Np5, Np1, Np4, Np8, Ns6, Ns2, Ns3, Ns7, Ns5, Ns1, Ns4, Ns8, plate2, plate1, Np1_Section2, Np2_Section2, Np3_Section2, Np4_Section2, Np5_Section2, Np6_Section2, Np7_Section2, Np8_Section2, Ns1_Section2, Ns2_Section2, Ns3_Section2, Ns4_Section2, Ns5_Section2, Ns6_Section2, Ns7_Section2, Ns8_Section2
boundaries and excitations:
  CoilTerminal_1: Coil Terminal Objects=Np8_Section2 Conductor_number=1 Winding=Np Point_out_of_terminal=false
  CoilTerminal_2: Coil Terminal Objects=Np1_Section2 Conductor_number=1 Winding=Np Point_out_of_terminal=false
  CoilTerminal_3: Coil Terminal Objects=Np2_Section2 Conductor_number=1 Winding=Np Point_out_of_terminal=false
  CoilTerminal_4: Coil Terminal Objects=Np3_Section2 Conductor_number=1 Winding=Np Point_out_of_terminal=false
  CoilTerminal_5: Coil Terminal Objects=Np4_Section2 Conductor_number=1 Winding=Np Point_out_of_terminal=false
  CoilTerminal_6: Coil Terminal Objects=Np5_Section2 Conductor_number=1 Winding=Np Point_out_of_terminal=false
  CoilTerminal_7: Coil Terminal Objects=Np6_Section2 Conductor_number=1 Winding=Np Point_out_of_terminal=false
  CoilTerminal_8: Coil Terminal Objects=Np7_Section2 Conductor_number=1 Winding=Np Point_out_of_terminal=false
  CoilTerminal_9: Coil Terminal Objects=Ns1_Section2 Conductor_number=1 Winding=Ns Point_out_of_terminal=true
  CoilTerminal_10: Coil Terminal Objects=Ns2_Section2 Conductor_number=1 Winding=Ns Point_out_of_terminal=true
  CoilTerminal_11: Coil Terminal Objects=Ns3_Section2 Conductor_number=1 Winding=Ns Point_out_of_terminal=true
  CoilTerminal_12: Coil Terminal Objects=Ns4_Section2 Conductor_number=1 Winding=Ns Point_out_of_terminal=true
  CoilTerminal_13: Coil Terminal Objects=Ns5_Section2 Conductor_number=1 Winding=Ns Point_out_of_terminal=true
  CoilTerminal_14: Coil Terminal Objects=Ns6_Section2 Conductor_number=1 Winding=Ns Point_out_of_terminal=true
  CoilTerminal_15: Coil Terminal Objects=Ns7_Section2 Conductor_number=1 Winding=Ns Point_out_of_terminal=true
  CoilTerminal_16: Coil Terminal Objects=Ns8_Section2 Conductor_number=1 Winding=Ns Point_out_of_terminal=true
  Np: Winding Group Type=Voltage IsSolid=true Current=16.36A Resistance=0ohm Inductance=0nH Voltage=volt_ac ParallelBranchesNum=1 Phase=0rad
  Ns: Winding Group Type=Current IsSolid=true Current=1000*1.41/volt_ac*1.414 ParallelBranchesNum=1 Phase=0.1522rad
  eddy effects on: Body1_1, Body1_2, Body1_4, Body1_5, Np6, Np2, Np3, Np7, Np5, Np1, Np4, Np8, Ns6, Ns2, Ns3, Ns7, Ns5, Ns1, Ns4, Ns8
  core loss on: Body1, Body1_3
parameters:
  Matrix1: Matrix Np, Ns:
mesh:
  SkinDepth1: SkinDepthBased Objects=[Np1..Np8, Ns1..Ns8] SkinDepth=0.20567444mm SurfTriMaxLength=1mm NumLayers=2
  Length1: LengthBased Objects=[Body1_1, Body1_2, Body1, Body1_4, Body1_5, Body1_3, plate1, plate2] MaxLength=2mm
  initial mesh: GlobalSurfApproximation{CurvedSurfaceApproxChoice=UseSlider SliderMeshSettings=9} GlobalCurvilinear{Apply}
setups:
  Setup1: EddyCurrent MaximumPasses=20 MinimumPasses=4 MinimumConvergedPasses=1 PercentRefinement=30 PercentError=1 NonLinearResidual=0.0001 SmoothBHCurve Frequency=100kHz SweepRanges{point 28.5kHz} SaveAllFields
field plots:
  Mag_B1: B over a plane on Setup1 : LastAdaptive at Freq=28.5kHz Phase=90deg
  Mag_J1: J over a plane on Setup1 : LastAdaptive at Freq=28.5kHz Phase=45deg
reports:
  L Table 1: Matrix1.L(Np,Np), Matrix1.L(Ns,Np), Matrix1.L(Np,Ns), Matrix1.L(Ns,Ns), Matrix1.R(Np,Np), Matrix1.R(Ns,Np), Matrix1.R(Np,Ns), Matrix1.R(Ns,Ns) vs Freq on Setup1 : LastAdaptive

design Flatwise_0.30_interleaved_new (Maxwell 3D, EddyCurrent, model units mm)
variables:
  freq_hz = 28500Hz
  volt_ac = 141/28500*Freq
geometry:
  Body1, Body1_1 [aluminum_real] = imported_body(D:\Karl,reverseengineer\core_assembled_flatwise.step)
  Body1_2 [ferrite - real] = imported_body(D:\Karl,reverseengineer\core_assembled_flatwise.step)
  Body1_3, Body1_4 [aluminum_real] = imported_body(D:\Karl,reverseengineer\core_assembled_flatwise.step)
  Body1_5 [ferrite - real] = imported_body(D:\Karl,reverseengineer\core_assembled_flatwise.step)
  Np3, Np5, Np6, Np2, Np8, Np4, Np7, Np1, Ns3, Ns5, Ns6, Ns2, Ns8, Ns4, Ns7, Ns1 [coppe_real] = imported_body(D:\Karl,reverseengineer\core_assembled_flatwise.step)
  plate_1, plate_2 [silicon_TIMreal] = imported_body(D:\Karl,reverseengineer\core_assembled_flatwise.step)
  Region [vacuum] = region(percentage_offset=0 on all sides)
  Ns8_Section1 [coppe_real] = Ns8.section(plane=ZX)
  Np1_Section1 [coppe_real] = Np1.section(plane=ZX)
  Np2_Section1 [coppe_real] = Np2.section(plane=ZX)
  Np3_Section1 [coppe_real] = Np3.section(plane=ZX)
  Np4_Section1 [coppe_real] = Np4.section(plane=ZX)
  Np5_Section1 [coppe_real] = Np5.section(plane=ZX)
  Np6_Section1 [coppe_real] = Np6.section(plane=ZX)
  Np7_Section1 [coppe_real] = Np7.section(plane=ZX)
  Np8_Section1 [coppe_real] = Np8.section(plane=ZX)
  Ns1_Section1 [coppe_real] = Ns1.section(plane=ZX)
  Ns2_Section1 [coppe_real] = Ns2.section(plane=ZX)
  Ns3_Section1 [coppe_real] = Ns3.section(plane=ZX)
  Ns4_Section1 [coppe_real] = Ns4.section(plane=ZX)
  Ns5_Section1 [coppe_real] = Ns5.section(plane=ZX)
  Ns6_Section1 [coppe_real] = Ns6.section(plane=ZX)
  Ns7_Section1 [coppe_real] = Ns7.section(plane=ZX)
  Ns8_Section1.separate_bodies()
  Np1_Section1.separate_bodies()
  Np2_Section1.separate_bodies()
  Np3_Section1.separate_bodies()
  Np4_Section1.separate_bodies()
  Np5_Section1.separate_bodies()
  Np6_Section1.separate_bodies()
  Np7_Section1.separate_bodies()
  Np8_Section1.separate_bodies()
  Ns1_Section1.separate_bodies()
  Ns2_Section1.separate_bodies()
  Ns3_Section1.separate_bodies()
  Ns4_Section1.separate_bodies()
  Ns5_Section1.separate_bodies()
  Ns6_Section1.separate_bodies()
  Ns7_Section1.separate_bodies()
  group core_togetherv4 = Body1, Body1_1, Body1_2
  group core_togetherv41 = Body1_3, Body1_4, Body1_5
  group Wire_face_flatwise_newv8 = Np3, Np5, Np6, Np2, Np8, Np4, Np7, Np1, Ns3, Ns5, Ns6, Ns2, Ns8, Ns4, Ns7, Ns1, plate_1, plate_2, Ns8_Section1, Np1_Section1, Np2_Section1, Np3_Section1, Np4_Section1, Np5_Section1, Np6_Section1, Np7_Section1, Np8_Section1, Ns1_Section1, Ns2_Section1, Ns3_Section1, Ns4_Section1, Ns5_Section1, Ns6_Section1, Ns7_Section1
boundaries and excitations:
  CoilTerminal_1: Coil Terminal Objects=Np1_Section1 Conductor_number=1 Winding=Np Point_out_of_terminal=false
  CoilTerminal_2: Coil Terminal Objects=Np2_Section1 Conductor_number=1 Winding=Np Point_out_of_terminal=false
  CoilTerminal_3: Coil Terminal Objects=Np3_Section1 Conductor_number=1 Winding=Np Point_out_of_terminal=false
  CoilTerminal_4: Coil Terminal Objects=Np4_Section1 Conductor_number=1 Winding=Np Point_out_of_terminal=false
  CoilTerminal_5: Coil Terminal Objects=Np5_Section1 Conductor_number=1 Winding=Np Point_out_of_terminal=false
  CoilTerminal_6: Coil Terminal Objects=Np6_Section1 Conductor_number=1 Winding=Np Point_out_of_terminal=false
  CoilTerminal_7: Coil Terminal Objects=Np7_Section1 Conductor_number=1 Winding=Np Point_out_of_terminal=false
  CoilTerminal_8: Coil Terminal Objects=Np8_Section1 Conductor_number=1 Winding=Np Point_out_of_terminal=false
  CoilTerminal_9: Coil Terminal Objects=Ns1_Section1 Conductor_number=1 Winding=Ns Point_out_of_terminal=true
  CoilTerminal_10: Coil Terminal Objects=Ns2_Section1 Conductor_number=1 Winding=Ns Point_out_of_terminal=true
  CoilTerminal_11: Coil Terminal Objects=Ns3_Section1 Conductor_number=1 Winding=Ns Point_out_of_terminal=true
  CoilTerminal_12: Coil Terminal Objects=Ns4_Section1 Conductor_number=1 Winding=Ns Point_out_of_terminal=true
  CoilTerminal_13: Coil Terminal Objects=Ns5_Section1 Conductor_number=1 Winding=Ns Point_out_of_terminal=true
  CoilTerminal_14: Coil Terminal Objects=Ns6_Section1 Conductor_number=1 Winding=Ns Point_out_of_terminal=true
  CoilTerminal_15: Coil Terminal Objects=Ns7_Section1 Conductor_number=1 Winding=Ns Point_out_of_terminal=true
  CoilTerminal_16: Coil Terminal Objects=Ns8_Section1 Conductor_number=1 Winding=Ns Point_out_of_terminal=true
  Np: Winding Group Type=Voltage IsSolid=true Current=16.36A Resistance=0ohm Inductance=0nH Voltage=volt_ac ParallelBranchesNum=1 Phase=0rad
  Ns: Winding Group Type=Current IsSolid=true Current=1000*1.41/volt_ac*1.414 ParallelBranchesNum=1 Phase=0.1522rad
  eddy effects on: Body1, Body1_1, Body1_3, Body1_4, Np3, Np5, Np6, Np2, Np8, Np4, Np7, Np1, Ns3, Ns5, Ns6, Ns2, Ns8, Ns4, Ns7, Ns1
  core loss on: Body1_2, Body1_5
parameters:
  Matrix1: Matrix Np, Ns:
mesh:
  SkinDepth1: SkinDepthBased Objects=[Np1..Np8, Ns1..Ns8] SkinDepth=0.20567444mm SurfTriMaxLength=1mm NumLayers=2
  Length1: LengthBased Objects=[Body1, Body1_1..Body1_5, plate_1, plate_2] MaxLength=2mm
  initial mesh: GlobalSurfApproximation{CurvedSurfaceApproxChoice=UseSlider SliderMeshSettings=9} GlobalCurvilinear{Apply}
setups:
  Setup1: EddyCurrent MaximumPasses=20 MinimumPasses=4 MinimumConvergedPasses=1 PercentRefinement=30 PercentError=1 NonLinearResidual=0.0001 SmoothBHCurve Frequency=100kHz SweepRanges{point 28500Hz} SaveAllFields
reports:
  L Table 1: Matrix1.L(Np,Np), Matrix1.L(Ns,Np), Matrix1.L(Np,Ns), Matrix1.L(Ns,Ns), Matrix1.R(Np,Np), Matrix1.R(Ns,Np), Matrix1.R(Np,Ns), Matrix1.R(Ns,Ns) vs Freq on Setup1 : LastAdaptive

design Flatwise_0.30_interleaved_new1 (Maxwell 3D, EddyCurrent, model units mm)
variables:
  freq_hz = 28500Hz
  volt_ac = 141/28500*Freq
geometry:
  Body1, Body1_1 [aluminum_real] = imported_body(D:\Karl,reverseengineer\core_assembled_flatwise.step)
  Body1_2 [ferrite - real] = imported_body(D:\Karl,reverseengineer\core_assembled_flatwise.step)
  Body1_3, Body1_4 [aluminum_real] = imported_body(D:\Karl,reverseengineer\core_assembled_flatwise.step)
  Body1_5 [ferrite - real] = imported_body(D:\Karl,reverseengineer\core_assembled_flatwise.step)
  Np3, Np5, Np6, Np2, Np8, Np4, Np7, Np1, Ns3, Ns5, Ns6, Ns2, Ns8, Ns4, Ns7, Ns1 [coppe_real] = imported_body(D:\Karl,reverseengineer\core_assembled_flatwise.step)
  plate_1, plate_2 [silicon_TIMreal] = imported_body(D:\Karl,reverseengineer\core_assembled_flatwise.step)
  Region [vacuum] = region(percentage_offset=0 on all sides)
  Ns8_Section1 [coppe_real] = Ns8.section(plane=ZX)
  Np1_Section1 [coppe_real] = Np1.section(plane=ZX)
  Np2_Section1 [coppe_real] = Np2.section(plane=ZX)
  Np3_Section1 [coppe_real] = Np3.section(plane=ZX)
  Np4_Section1 [coppe_real] = Np4.section(plane=ZX)
  Np5_Section1 [coppe_real] = Np5.section(plane=ZX)
  Np6_Section1 [coppe_real] = Np6.section(plane=ZX)
  Np7_Section1 [coppe_real] = Np7.section(plane=ZX)
  Np8_Section1 [coppe_real] = Np8.section(plane=ZX)
  Ns1_Section1 [coppe_real] = Ns1.section(plane=ZX)
  Ns2_Section1 [coppe_real] = Ns2.section(plane=ZX)
  Ns3_Section1 [coppe_real] = Ns3.section(plane=ZX)
  Ns4_Section1 [coppe_real] = Ns4.section(plane=ZX)
  Ns5_Section1 [coppe_real] = Ns5.section(plane=ZX)
  Ns6_Section1 [coppe_real] = Ns6.section(plane=ZX)
  Ns7_Section1 [coppe_real] = Ns7.section(plane=ZX)
  Ns8_Section1.separate_bodies()
  Np1_Section1.separate_bodies()
  Np2_Section1.separate_bodies()
  Np3_Section1.separate_bodies()
  Np4_Section1.separate_bodies()
  Np5_Section1.separate_bodies()
  Np6_Section1.separate_bodies()
  Np7_Section1.separate_bodies()
  Np8_Section1.separate_bodies()
  Ns1_Section1.separate_bodies()
  Ns2_Section1.separate_bodies()
  Ns3_Section1.separate_bodies()
  Ns4_Section1.separate_bodies()
  Ns5_Section1.separate_bodies()
  Ns6_Section1.separate_bodies()
  Ns7_Section1.separate_bodies()
  [Body1, Body1_1..Body1_5, Np3, Np5, Np6, Np2, Np8, Np4, Np7, Np1, Ns3, Ns5, Ns6, Ns2, Ns8, Ns4, Ns7, Ns1, plate_1, plate_2, Ns8_Section1, Np1_Section1, Np2_Section1, Np3_Section1, Np4_Section1, Np5_Section1, Np6_Section1, Np7_Section1, Np8_Section1, Ns1_Section1, Ns2_Section1, Ns3_Section1, Ns4_Section1, Ns5_Section1, Ns6_Section1, Ns7_Section1].move(-28.7mm, -25.45mm, -13.7mm)
  [Body1, Body1_1..Body1_5, Np3, Np5, Np6, Np2, Np8, Np4, Np7, Np1, Ns3, Ns5, Ns6, Ns2, Ns8, Ns4, Ns7, Ns1, plate_1, plate_2, Ns8_Section1, Np1_Section1, Np2_Section1, Np3_Section1, Np4_Section1, Np5_Section1, Np6_Section1, Np7_Section1, Np8_Section1, Ns1_Section1, Ns2_Section1, Ns3_Section1, Ns4_Section1, Ns5_Section1, Ns6_Section1, Ns7_Section1].move(9.4mm, -25.45mm, 9.7178433mm)
  [Body1, Body1_1..Body1_5, Np3, Np5, Np6, Np2, Np8, Np4, Np7, Np1, Ns3, Ns5, Ns6, Ns2, Ns8, Ns4, Ns7, Ns1, plate_1, plate_2, Ns8_Section1, Np1_Section1, Np2_Section1, Np3_Section1, Np4_Section1, Np5_Section1, Np6_Section1, Np7_Section1, Np8_Section1, Ns1_Section1, Ns2_Section1, Ns3_Section1, Ns4_Section1, Ns5_Section1, Ns6_Section1, Ns7_Section1].move(0mm, 25.45mm, -5.4178433mm)
  group core_togetherv4 = Body1, Body1_1, Body1_2
  group core_togetherv41 = Body1_3, Body1_4, Body1_5
  group Wire_face_flatwise_newv8 = Np3, Np5, Np6, Np2, Np8, Np4, Np7, Np1, Ns3, Ns5, Ns6, Ns2, Ns8, Ns4, Ns7, Ns1, plate_1, plate_2, Ns8_Section1, Np1_Section1, Np2_Section1, Np3_Section1, Np4_Section1, Np5_Section1, Np6_Section1, Np7_Section1, Np8_Section1, Ns1_Section1, Ns2_Section1, Ns3_Section1, Ns4_Section1, Ns5_Section1, Ns6_Section1, Ns7_Section1
boundaries and excitations:
  CoilTerminal_1: Coil Terminal Objects=Np1_Section1 Conductor_number=1 Winding=Np Point_out_of_terminal=false
  CoilTerminal_2: Coil Terminal Objects=Np2_Section1 Conductor_number=1 Winding=Np Point_out_of_terminal=false
  CoilTerminal_3: Coil Terminal Objects=Np3_Section1 Conductor_number=1 Winding=Np Point_out_of_terminal=false
  CoilTerminal_4: Coil Terminal Objects=Np4_Section1 Conductor_number=1 Winding=Np Point_out_of_terminal=false
  CoilTerminal_5: Coil Terminal Objects=Np5_Section1 Conductor_number=1 Winding=Np Point_out_of_terminal=false
  CoilTerminal_6: Coil Terminal Objects=Np6_Section1 Conductor_number=1 Winding=Np Point_out_of_terminal=false
  CoilTerminal_7: Coil Terminal Objects=Np7_Section1 Conductor_number=1 Winding=Np Point_out_of_terminal=false
  CoilTerminal_8: Coil Terminal Objects=Np8_Section1 Conductor_number=1 Winding=Np Point_out_of_terminal=false
  CoilTerminal_9: Coil Terminal Objects=Ns1_Section1 Conductor_number=1 Winding=Ns Point_out_of_terminal=true
  CoilTerminal_10: Coil Terminal Objects=Ns2_Section1 Conductor_number=1 Winding=Ns Point_out_of_terminal=true
  CoilTerminal_11: Coil Terminal Objects=Ns3_Section1 Conductor_number=1 Winding=Ns Point_out_of_terminal=true
  CoilTerminal_12: Coil Terminal Objects=Ns4_Section1 Conductor_number=1 Winding=Ns Point_out_of_terminal=true
  CoilTerminal_13: Coil Terminal Objects=Ns5_Section1 Conductor_number=1 Winding=Ns Point_out_of_terminal=true
  CoilTerminal_14: Coil Terminal Objects=Ns6_Section1 Conductor_number=1 Winding=Ns Point_out_of_terminal=true
  CoilTerminal_15: Coil Terminal Objects=Ns7_Section1 Conductor_number=1 Winding=Ns Point_out_of_terminal=true
  CoilTerminal_16: Coil Terminal Objects=Ns8_Section1 Conductor_number=1 Winding=Ns Point_out_of_terminal=true
  Np: Winding Group Type=Voltage IsSolid=true Current=16.36A Resistance=0ohm Inductance=0nH Voltage=volt_ac ParallelBranchesNum=1 Phase=0rad
  Ns: Winding Group Type=Current IsSolid=true Current=1000*1.41/volt_ac*1.414 ParallelBranchesNum=1 Phase=0.1522rad
  eddy effects on: Body1, Body1_1, Body1_3, Body1_4, Np3, Np5, Np6, Np2, Np8, Np4, Np7, Np1, Ns3, Ns5, Ns6, Ns2, Ns8, Ns4, Ns7, Ns1
  core loss on: Body1_2, Body1_5
parameters:
  Matrix1: Matrix Np, Ns:
mesh:
  SkinDepth1: SkinDepthBased Objects=[Np1..Np8, Ns1..Ns8] SkinDepth=0.20567444mm SurfTriMaxLength=1mm NumLayers=2
  Length1: LengthBased Objects=[Body1, Body1_1..Body1_5, plate_1, plate_2] MaxLength=2mm
  initial mesh: GlobalSurfApproximation{CurvedSurfaceApproxChoice=UseSlider SliderMeshSettings=9} GlobalCurvilinear{Apply}
setups:
  Setup1: EddyCurrent MaximumPasses=20 MinimumPasses=4 MinimumConvergedPasses=1 PercentRefinement=30 PercentError=1 NonLinearResidual=0.0001 SmoothBHCurve Frequency=100kHz SweepRanges{point 28500Hz} SaveAllFields
reports:
  L Table 1: Matrix1.L(Np,Np), Matrix1.L(Ns,Np), Matrix1.L(Np,Ns), Matrix1.L(Ns,Ns), Matrix1.R(Np,Np), Matrix1.R(Ns,Np), Matrix1.R(Np,Ns), Matrix1.R(Ns,Ns) vs Freq on Setup1 : LastAdaptive

design Maxwell3DDesign1 (Maxwell 3D, Magnetostatic, model units mm)
geometry:
  Body109..Body124, Np1..Np8, Ns1..Ns8, plate_1, plate_2, Body1, Body1_1..Body1_5 = imported_body(C:\Users\karlr\Desktop\core_assembled_flatwise_kaptonv2.step)
  [Body109..Body124, Np1..Np8, Ns1..Ns8, plate_1, plate_2, Body1, Body1_1..Body1_5].move(0mm, -25.45mm, 0mm)
  [Body109..Body124, Np1..Np8, Ns1..Ns8, plate_1, plate_2, Body1, Body1_1..Body1_5].move(-19.3mm, 0mm, 0mm)
  group core_assembled_flatwise = Body109..Body124, Np1..Np8, Ns1..Ns8, plate_1, plate_2
  group core_together_1 = Body1, Body1_1, Body1_2
  group core_together = Body1_3, Body1_4, Body1_5
mesh:
  initial mesh: GlobalCurvilinear{Apply}

design Maxwell2DDesign4 (Maxwell 2D, Electrostatic, about Z geometry, model units mm)
geometry:
  Body1_2#36218, Body1_5#36398, Np3#36474, Np5#36526, Np6#36578, Np2#36630, Np8#36682, Np4#36734, Np7#36786, Np1#36838, Ns3#36890, Ns5#36942, Ns6#36994, Ns2#37046, Ns8#37098, Ns4#37150, Ns7#37202, Ns1#37254, plate_1#37306, plate_2#37358 = imported_body(D:\Karl,reverseengineer\core_assembled_flatwise.step)
  Region [vacuum] = region(percentage_offset=0 on all sides)
  [Body1_2#36218, Body1_5#36398, Np3#36474, Np5#36526, Np6#36578, Np2#36630, Np8#36682, Np4#36734, Np7#36786, Np1#36838, Ns3#36890, Ns5#36942, Ns6#36994, Ns2#37046, Ns8#37098, Ns4#37150, Ns7#37202, Ns1#37254, plate_1#37306, plate_2#37358].move(-28.7mm, -25.45mm, -13.7mm)
  [Body1_2#36218, Body1_5#36398, Np3#36474, Np5#36526, Np6#36578, Np2#36630, Np8#36682, Np4#36734, Np7#36786, Np1#36838, Ns3#36890, Ns5#36942, Ns6#36994, Ns2#37046, Ns8#37098, Ns4#37150, Ns7#37202, Ns1#37254, plate_1#37306, plate_2#37358].move(9.4mm, -25.45mm, 9.7178433mm)
  [Body1_2#36218, Body1_5#36398, Np3#36474, Np5#36526, Np6#36578, Np2#36630, Np8#36682, Np4#36734, Np7#36786, Np1#36838, Ns3#36890, Ns5#36942, Ns6#36994, Ns2#37046, Ns8#37098, Ns4#37150, Ns7#37202, Ns1#37254, plate_1#37306, plate_2#37358].move(0mm, 25.45mm, -5.4178433mm)
  Body1_2 [ferrite - real2] = Body1_2#36218.section(plane=ZX)
  Body1_2#36218.delete()
  Body1_5 [ferrite - real] = Body1_5#36398.section(plane=ZX)
  Body1_5#36398.delete()
  Np3 [coppe_real] = Np3#36474.section(plane=ZX)
  Np3#36474.delete()
  Np5 [coppe_real] = Np5#36526.section(plane=ZX)
  Np5#36526.delete()
  Np6 [coppe_real] = Np6#36578.section(plane=ZX)
  Np6#36578.delete()
  Np2 [coppe_real] = Np2#36630.section(plane=ZX)
  Np2#36630.delete()
  Np8 [coppe_real] = Np8#36682.section(plane=ZX)
  Np8#36682.delete()
  Np4 [coppe_real] = Np4#36734.section(plane=ZX)
  Np4#36734.delete()
  Np7 [coppe_real] = Np7#36786.section(plane=ZX)
  Np7#36786.delete()
  Np1 [coppe_real] = Np1#36838.section(plane=ZX)
  Np1#36838.delete()
  Ns3 [coppe_real] = Ns3#36890.section(plane=ZX)
  Ns3#36890.delete()
  Ns5 [coppe_real] = Ns5#36942.section(plane=ZX)
  Ns5#36942.delete()
  Ns6 [coppe_real] = Ns6#36994.section(plane=ZX)
  Ns6#36994.delete()
  Ns2 [coppe_real] = Ns2#37046.section(plane=ZX)
  Ns2#37046.delete()
  Ns8 [coppe_real] = Ns8#37098.section(plane=ZX)
  Ns8#37098.delete()
  Ns4 [coppe_real] = Ns4#37150.section(plane=ZX)
  Ns4#37150.delete()
  Ns7 [coppe_real] = Ns7#37202.section(plane=ZX)
  Ns7#37202.delete()
  Ns1 [coppe_real] = Ns1#37254.section(plane=ZX)
  Ns1#37254.delete()
  plate_1 [silicon_TIMreal] = plate_1#37306.section(plane=ZX)
  plate_1#37306.delete()
  plate_2 [silicon_TIMreal] = plate_2#37358.section(plane=ZX)
  plate_2#37358.delete()
  [Body1_2, Body1_5, Np3, Np5, Np6, Np2, Np8, Np4, Np7, Np1, Ns3, Ns5, Ns6, Ns2, Ns8, Ns4, Ns7, Ns1, plate_1, plate_2].move(19.3mm, 0mm, 9.4mm)
  group core_togetherv4 = Body1_2
  group core_togetherv41 = Body1_5
  group Wire_face_flatwise_newv8 = Np3, Np5, Np6, Np2, Np8, Np4, Np7, Np1, Ns3, Ns5, Ns6, Ns2, Ns8, Ns4, Ns7, Ns1, plate_1, plate_2
mesh:
  EdgeCut1: EdgeCutLayerMesh Objects=[Body1_5, Region, Body1_2, Np3, Np5, Np6, Np2, Np8, Np4, Np7, Np1, Ns3, Ns5, Ns6, Ns2, Ns8, Ns4, Ns7, Ns1, plate_1, plate_2] Layer_Thickenss=0.01mm
  initial mesh: GlobalSurfApproximation{CurvedSurfaceApproxChoice=UseSlider SliderMeshSettings=9}
setups:
  Setup1: Electrostatic MaximumPasses=20 MinimumPasses=5 MinimumConvergedPasses=1 PercentRefinement=30 PercentError=1 NonLinearResidual=0.001
field plots:
  Mesh1: MeshPlots over Region, Body1_2, Body1_5, Np3, Np5, Np6, Np2, Np8, Np4, Np7, Np1, Ns3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 on Setup1 : LastAdaptive

design E1_1kW (Maxwell 2D, Electrostatic, about Z geometry, model units mm)
geometry:
  Body1_2#36218, Body1_5#36398, Np3#36474, Np5#36526, Np6#36578, Np2#36630, Np8#36682, Np4#36734, Np7#36786, Np1#36838, Ns3#36890, Ns5#36942, Ns6#36994, Ns2#37046, Ns8#37098, Ns4#37150, Ns7#37202, Ns1#37254, plate_1#37306, plate_2#37358 = imported_body(D:\Karl,reverseengineer\core_assembled_flatwise.step)
  Region [air] = region(percentage_offset: +X=100, -X=0, +Y=0, -Y=0, +Z=100, -Z=100)
  [Body1_2#36218, Body1_5#36398, Np3#36474, Np5#36526, Np6#36578, Np2#36630, Np8#36682, Np4#36734, Np7#36786, Np1#36838, Ns3#36890, Ns5#36942, Ns6#36994, Ns2#37046, Ns8#37098, Ns4#37150, Ns7#37202, Ns1#37254, plate_1#37306, plate_2#37358].move(-28.7mm, -25.45mm, -13.7mm)
  [Body1_2#36218, Body1_5#36398, Np3#36474, Np5#36526, Np6#36578, Np2#36630, Np8#36682, Np4#36734, Np7#36786, Np1#36838, Ns3#36890, Ns5#36942, Ns6#36994, Ns2#37046, Ns8#37098, Ns4#37150, Ns7#37202, Ns1#37254, plate_1#37306, plate_2#37358].move(9.4mm, -25.45mm, 9.7178433mm)
  [Body1_2#36218, Body1_5#36398, Np3#36474, Np5#36526, Np6#36578, Np2#36630, Np8#36682, Np4#36734, Np7#36786, Np1#36838, Ns3#36890, Ns5#36942, Ns6#36994, Ns2#37046, Ns8#37098, Ns4#37150, Ns7#37202, Ns1#37254, plate_1#37306, plate_2#37358].move(0mm, 25.45mm, -5.4178433mm)
  Body1_2 [ferrite - real2] = Body1_2#36218.section(plane=ZX)
  Body1_2#36218.delete()
  Body1_5 [ferrite - real2] = Body1_5#36398.section(plane=ZX)
  Body1_5#36398.delete()
  Np3 [coppe_real] = Np3#36474.section(plane=ZX)
  Np3#36474.delete()
  Np5 [coppe_real] = Np5#36526.section(plane=ZX)
  Np5#36526.delete()
  Np6 [coppe_real] = Np6#36578.section(plane=ZX)
  Np6#36578.delete()
  Np2 [coppe_real] = Np2#36630.section(plane=ZX)
  Np2#36630.delete()
  Np8 [coppe_real] = Np8#36682.section(plane=ZX)
  Np8#36682.delete()
  Np4 [coppe_real] = Np4#36734.section(plane=ZX)
  Np4#36734.delete()
  Np7 [coppe_real] = Np7#36786.section(plane=ZX)
  Np7#36786.delete()
  Np1 [coppe_real] = Np1#36838.section(plane=ZX)
  Np1#36838.delete()
  Ns3 [coppe_real] = Ns3#36890.section(plane=ZX)
  Ns3#36890.delete()
  Ns5 [coppe_real] = Ns5#36942.section(plane=ZX)
  Ns5#36942.delete()
  Ns6 [coppe_real] = Ns6#36994.section(plane=ZX)
  Ns6#36994.delete()
  Ns2 [coppe_real] = Ns2#37046.section(plane=ZX)
  Ns2#37046.delete()
  Ns8 [coppe_real] = Ns8#37098.section(plane=ZX)
  Ns8#37098.delete()
  Ns4 [coppe_real] = Ns4#37150.section(plane=ZX)
  Ns4#37150.delete()
  Ns7 [coppe_real] = Ns7#37202.section(plane=ZX)
  Ns7#37202.delete()
  Ns1 [coppe_real] = Ns1#37254.section(plane=ZX)
  Ns1#37254.delete()
  plate_1 [silicon_TIMreal] = plate_1#37306.section(plane=ZX)
  plate_1#37306.delete()
  plate_2 [silicon_TIMreal] = plate_2#37358.section(plane=ZX)
  plate_2#37358.delete()
  [Body1_2, Body1_5, Np3, Np5, Np6, Np2, Np8, Np4, Np7, Np1, Ns3, Ns5, Ns6, Ns2, Ns8, Ns4, Ns7, Ns1, plate_1, plate_2].move(19.3mm, 0mm, 9.4mm)
  [Body1_2, Body1_5, Np3, Np5, Np6, Np2, Np8, Np4, Np7, Np1, Ns3, Ns5, Ns6, Ns2, Ns8, Ns4, Ns7, Ns1, plate_1, plate_2].move(-19.3mm, 0mm, 0mm)
  [Body1_2, Body1_5, Np3, Np5, Np6, Np2, Np8, Np4, Np7, Np1, Ns3, Ns5, Ns6, Ns2, Ns8, Ns4, Ns7, Ns1, plate_1, plate_2].move(0mm, 0mm, -9.35mm)
  [Body1_2, Body1_5, Np3, Np5, Np6, Np2, Np8, Np4, Np7, Np1, Ns3, Ns5, Ns6, Ns2, Ns8, Ns4, Ns7, Ns1, plate_1, plate_2].split(plane=YZ, keep=PositiveOnly)
  Rectangle1 [air] = rectangle(corner=(19.3mm, 0mm, -9.35mm), z_size=18.7mm, x_size=-19.3mm)
  group core_togetherv4 = Body1_2
  group core_togetherv41 = Body1_5
  group Wire_face_flatwise_newv8 = Np3, Np5, Np6, Np2, Np8, Np4, Np7, Np1, Ns3, Ns5, Ns6, Ns2, Ns8, Ns4, Ns7, Ns1, plate_1, plate_2
boundaries and excitations:
  Symmetry1: Symmetry Edges=Region.edge(at (0, 0, 0)) IsOdd=true
  Balloon1: Balloon Edges=Region.edge(at (19.3, 0, 28.05), at (38.6, 0, 0), at (19.3, 0, -28.05)) IsOfTypeVoltage=true
  Voltage1: Voltage Objects=[Np1..Np8] Value=300V
  Voltage2: Voltage Objects=[Ns1..Ns8] Value=0V
mesh:
  EdgeCut1: EdgeCutLayerMesh Objects=[Np1..Np8, Ns1..Ns8] Layer_Thickenss=0.05mm
  EdgeCut2: EdgeCutLayerMesh Objects=[plate_1, plate_2] Layer_Thickenss=0.05mm
  EdgeCut3: EdgeCutLayerMesh Objects=[Body1_2, Body1_5] Layer_Thickenss=0.05mm
  EdgeCut4: EdgeCutLayerMesh Objects=Rectangle1 Layer_Thickenss=0.05mm
  initial mesh: GlobalSurfApproximation{CurvedSurfaceApproxChoice=UseSlider SliderMeshSettings=9} GlobalModelRes{DefeatureLength=0.0001mm}
setups:
  Setup1: Electrostatic MaximumPasses=30 MinimumPasses=12 MinimumConvergedPasses=1 PercentRefinement=30 PercentError=0.3 NonLinearResidual=0.001
field plots:
  Mag_E1: E over Rectangle1 on Setup1 : LastAdaptive
  Mag_E2: E over plate_1, plate_2 on Setup1 : LastAdaptive

design Maxwell2DDesign6 (Maxwell 2D, EddyCurrent, about Z geometry, model units mm)
geometry:
  Body1_2#36218, Body1_5#36398, Np3#36474, Np5#36526, Np6#36578, Np2#36630, Np8#36682, Np4#36734, Np7#36786, Np1#36838, Ns3#36890, Ns5#36942, Ns6#36994, Ns2#37046, Ns8#37098, Ns4#37150, Ns7#37202, Ns1#37254, plate_1#37306, plate_2#37358 = imported_body(D:\Karl,reverseengineer\core_assembled_flatwise.step)
  Region [vacuum] = region(percentage_offset: +X=100, -X=0, +Y=0, -Y=0, +Z=100, -Z=100)
  [Body1_2#36218, Body1_5#36398, Np3#36474, Np5#36526, Np6#36578, Np2#36630, Np8#36682, Np4#36734, Np7#36786, Np1#36838, Ns3#36890, Ns5#36942, Ns6#36994, Ns2#37046, Ns8#37098, Ns4#37150, Ns7#37202, Ns1#37254, plate_1#37306, plate_2#37358].move(-28.7mm, -25.45mm, -13.7mm)
  [Body1_2#36218, Body1_5#36398, Np3#36474, Np5#36526, Np6#36578, Np2#36630, Np8#36682, Np4#36734, Np7#36786, Np1#36838, Ns3#36890, Ns5#36942, Ns6#36994, Ns2#37046, Ns8#37098, Ns4#37150, Ns7#37202, Ns1#37254, plate_1#37306, plate_2#37358].move(9.4mm, -25.45mm, 9.7178433mm)
  [Body1_2#36218, Body1_5#36398, Np3#36474, Np5#36526, Np6#36578, Np2#36630, Np8#36682, Np4#36734, Np7#36786, Np1#36838, Ns3#36890, Ns5#36942, Ns6#36994, Ns2#37046, Ns8#37098, Ns4#37150, Ns7#37202, Ns1#37254, plate_1#37306, plate_2#37358].move(0mm, 25.45mm, -5.4178433mm)
  Body1_2 [ferrite - real] = Body1_2#36218.section(plane=ZX)
  Body1_2#36218.delete()
  Body1_5 [ferrite - real] = Body1_5#36398.section(plane=ZX)
  Body1_5#36398.delete()
  Np3 [coppe_real] = Np3#36474.section(plane=ZX)
  Np3#36474.delete()
  Np5 [coppe_real] = Np5#36526.section(plane=ZX)
  Np5#36526.delete()
  Np6 [coppe_real] = Np6#36578.section(plane=ZX)
  Np6#36578.delete()
  Np2 [coppe_real] = Np2#36630.section(plane=ZX)
  Np2#36630.delete()
  Np8 [coppe_real] = Np8#36682.section(plane=ZX)
  Np8#36682.delete()
  Np4 [coppe_real] = Np4#36734.section(plane=ZX)
  Np4#36734.delete()
  Np7 [coppe_real] = Np7#36786.section(plane=ZX)
  Np7#36786.delete()
  Np1 [coppe_real] = Np1#36838.section(plane=ZX)
  Np1#36838.delete()
  Ns3 [coppe_real] = Ns3#36890.section(plane=ZX)
  Ns3#36890.delete()
  Ns5 [coppe_real] = Ns5#36942.section(plane=ZX)
  Ns5#36942.delete()
  Ns6 [coppe_real] = Ns6#36994.section(plane=ZX)
  Ns6#36994.delete()
  Ns2 [coppe_real] = Ns2#37046.section(plane=ZX)
  Ns2#37046.delete()
  Ns8 [coppe_real] = Ns8#37098.section(plane=ZX)
  Ns8#37098.delete()
  Ns4 [coppe_real] = Ns4#37150.section(plane=ZX)
  Ns4#37150.delete()
  Ns7 [coppe_real] = Ns7#37202.section(plane=ZX)
  Ns7#37202.delete()
  Ns1 [coppe_real] = Ns1#37254.section(plane=ZX)
  Ns1#37254.delete()
  plate_1 [silicon_TIMreal] = plate_1#37306.section(plane=ZX)
  plate_1#37306.delete()
  plate_2 [silicon_TIMreal] = plate_2#37358.section(plane=ZX)
  plate_2#37358.delete()
  [Body1_2, Body1_5, Np3, Np5, Np6, Np2, Np8, Np4, Np7, Np1, Ns3, Ns5, Ns6, Ns2, Ns8, Ns4, Ns7, Ns1, plate_1, plate_2].move(19.3mm, 0mm, 9.4mm)
  [Body1_2, Body1_5, Np3, Np5, Np6, Np2, Np8, Np4, Np7, Np1, Ns3, Ns5, Ns6, Ns2, Ns8, Ns4, Ns7, Ns1, plate_1, plate_2].move(-19.3mm, 0mm, 0mm)
  [Body1_2, Body1_5, Np3, Np5, Np6, Np2, Np8, Np4, Np7, Np1, Ns3, Ns5, Ns6, Ns2, Ns8, Ns4, Ns7, Ns1, plate_1, plate_2].move(0mm, 0mm, -9.35mm)
  [Body1_2, Body1_5, Np3, Np5, Np6, Np2, Np8, Np4, Np7, Np1, Ns3, Ns5, Ns6, Ns2, Ns8, Ns4, Ns7, Ns1, plate_1, plate_2].split(plane=YZ, keep=PositiveOnly)
  Rectangle1 [vacuum] = rectangle(corner=(19.3mm, 0mm, -9.35mm), z_size=18.7mm, x_size=-19.3mm)
  group core_togetherv4 = Body1_2
  group core_togetherv41 = Body1_5
  group Wire_face_flatwise_newv8 = Np3, Np5, Np6, Np2, Np8, Np4, Np7, Np1, Ns3, Ns5, Ns6, Ns2, Ns8, Ns4, Ns7, Ns1, plate_1, plate_2
boundaries and excitations:
  Symmetry1: Symmetry Edges=Region.edge(at (0, 0, 0)) IsOdd=true
  Balloon1: Balloon Edges=Region.edge(at (19.3, 0, 28.05), at (38.6, 0, 0), at (19.3, 0, -28.05))
  Np8: Coil Objects=Np8 Conductor_number=1 Winding=Winding1 PolarityType=Positive
  Np1: Coil Objects=Np1 Conductor_number=1 Winding=Winding1 PolarityType=Positive
  Np2: Coil Objects=Np2 Conductor_number=1 Winding=Winding1 PolarityType=Positive
  Np3: Coil Objects=Np3 Conductor_number=1 Winding=Winding1 PolarityType=Positive
  Np4: Coil Objects=Np4 Conductor_number=1 Winding=Winding1 PolarityType=Positive
  Np5: Coil Objects=Np5 Conductor_number=1 Winding=Winding1 PolarityType=Positive
  Np6: Coil Objects=Np6 Conductor_number=1 Winding=Winding1 PolarityType=Positive
  Np7: Coil Objects=Np7 Conductor_number=1 Winding=Winding1 PolarityType=Positive
  Ns1: Coil Objects=Ns1 Conductor_number=1 Winding=Winding2 PolarityType=Negative
  Ns2: Coil Objects=Ns2 Conductor_number=1 Winding=Winding2 PolarityType=Negative
  Ns3: Coil Objects=Ns3 Conductor_number=1 Winding=Winding2 PolarityType=Negative
  Ns4: Coil Objects=Ns4 Conductor_number=1 Winding=Winding2 PolarityType=Negative
  Ns5: Coil Objects=Ns5 Conductor_number=1 Winding=Winding2 PolarityType=Negative
  Ns6: Coil Objects=Ns6 Conductor_number=1 Winding=Winding2 PolarityType=Negative
  Ns7: Coil Objects=Ns7 Conductor_number=1 Winding=Winding2 PolarityType=Negative
  Ns8: Coil Objects=Ns8 Conductor_number=1 Winding=Winding2 PolarityType=Negative
  Winding1: Winding Group Type=Current IsSolid=true Current=16A ParallelBranchesNum=1 Phase=0deg
  Winding2: Winding Group Type=Current IsSolid=true Current=16A ParallelBranchesNum=1 Phase=0.157rad
parameters:
  Matrix1: Matrix Winding1, Winding2:
mesh:
  EdgeCut1: EdgeCutLayerMesh Objects=Rectangle1 Layer_Thickenss=0.1mm
  initial mesh: GlobalSurfApproximation{CurvedSurfaceApproxChoice=UseSlider SliderMeshSettings=9}
setups:
  Setup1: EddyCurrent MaximumPasses=20 MinimumPasses=5 MinimumConvergedPasses=1 PercentRefinement=30 PercentError=1 NonLinearResidual=0.0001 Frequency=60Hz
field plots:
  Mesh1: MeshPlots over Body1_2, Body1_5, Np3, Np5, Np6, Np2, Np8, Np4, Np7, Np1, Ns3, Ns5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 on Setup1 : LastAdaptive at Freq=60Hz Phase=0deg
  Mesh2: MeshPlots over Rectangle1 on Setup1 : LastAdaptive at Freq=60Hz Phase=0deg
  Mesh3: MeshPlots over Np3, Np5, Np6, Np2, Np8, Np4, Np7, Np1, Ns3, Ns5, Ns6, Ns2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 on Setup1 : LastAdaptive at Freq=60Hz Phase=0deg

design E1_1kW_0V (Maxwell 2D, Electrostatic, about Z geometry, model units mm)
geometry:
  Body1_2#36218, Body1_5#36398, Np3#36474, Np5#36526, Np6#36578, Np2#36630, Np8#36682, Np4#36734, Np7#36786, Np1#36838, Ns3#36890, Ns5#36942, Ns6#36994, Ns2#37046, Ns8#37098, Ns4#37150, Ns7#37202, Ns1#37254, plate_1#37306, plate_2#37358 = imported_body(D:\Karl,reverseengineer\core_assembled_flatwise.step)
  Region [air] = region(percentage_offset: +X=100, -X=0, +Y=0, -Y=0, +Z=100, -Z=100)
  [Body1_2#36218, Body1_5#36398, Np3#36474, Np5#36526, Np6#36578, Np2#36630, Np8#36682, Np4#36734, Np7#36786, Np1#36838, Ns3#36890, Ns5#36942, Ns6#36994, Ns2#37046, Ns8#37098, Ns4#37150, Ns7#37202, Ns1#37254, plate_1#37306, plate_2#37358].move(-28.7mm, -25.45mm, -13.7mm)
  [Body1_2#36218, Body1_5#36398, Np3#36474, Np5#36526, Np6#36578, Np2#36630, Np8#36682, Np4#36734, Np7#36786, Np1#36838, Ns3#36890, Ns5#36942, Ns6#36994, Ns2#37046, Ns8#37098, Ns4#37150, Ns7#37202, Ns1#37254, plate_1#37306, plate_2#37358].move(9.4mm, -25.45mm, 9.7178433mm)
  [Body1_2#36218, Body1_5#36398, Np3#36474, Np5#36526, Np6#36578, Np2#36630, Np8#36682, Np4#36734, Np7#36786, Np1#36838, Ns3#36890, Ns5#36942, Ns6#36994, Ns2#37046, Ns8#37098, Ns4#37150, Ns7#37202, Ns1#37254, plate_1#37306, plate_2#37358].move(0mm, 25.45mm, -5.4178433mm)
  Body1_2 [ferrite - real2] = Body1_2#36218.section(plane=ZX)
  Body1_2#36218.delete()
  Body1_5 [ferrite - real2] = Body1_5#36398.section(plane=ZX)
  Body1_5#36398.delete()
  Np3 [coppe_real] = Np3#36474.section(plane=ZX)
  Np3#36474.delete()
  Np5 [coppe_real] = Np5#36526.section(plane=ZX)
  Np5#36526.delete()
  Np6 [coppe_real] = Np6#36578.section(plane=ZX)
  Np6#36578.delete()
  Np2 [coppe_real] = Np2#36630.section(plane=ZX)
  Np2#36630.delete()
  Np8 [coppe_real] = Np8#36682.section(plane=ZX)
  Np8#36682.delete()
  Np4 [coppe_real] = Np4#36734.section(plane=ZX)
  Np4#36734.delete()
  Np7 [coppe_real] = Np7#36786.section(plane=ZX)
  Np7#36786.delete()
  Np1 [coppe_real] = Np1#36838.section(plane=ZX)
  Np1#36838.delete()
  Ns3 [coppe_real] = Ns3#36890.section(plane=ZX)
  Ns3#36890.delete()
  Ns5 [coppe_real] = Ns5#36942.section(plane=ZX)
  Ns5#36942.delete()
  Ns6 [coppe_real] = Ns6#36994.section(plane=ZX)
  Ns6#36994.delete()
  Ns2 [coppe_real] = Ns2#37046.section(plane=ZX)
  Ns2#37046.delete()
  Ns8 [coppe_real] = Ns8#37098.section(plane=ZX)
  Ns8#37098.delete()
  Ns4 [coppe_real] = Ns4#37150.section(plane=ZX)
  Ns4#37150.delete()
  Ns7 [coppe_real] = Ns7#37202.section(plane=ZX)
  Ns7#37202.delete()
  Ns1 [coppe_real] = Ns1#37254.section(plane=ZX)
  Ns1#37254.delete()
  plate_1 [silicon_TIMreal] = plate_1#37306.section(plane=ZX)
  plate_1#37306.delete()
  plate_2 [silicon_TIMreal] = plate_2#37358.section(plane=ZX)
  plate_2#37358.delete()
  [Body1_2, Body1_5, Np3, Np5, Np6, Np2, Np8, Np4, Np7, Np1, Ns3, Ns5, Ns6, Ns2, Ns8, Ns4, Ns7, Ns1, plate_1, plate_2].move(19.3mm, 0mm, 9.4mm)
  [Body1_2, Body1_5, Np3, Np5, Np6, Np2, Np8, Np4, Np7, Np1, Ns3, Ns5, Ns6, Ns2, Ns8, Ns4, Ns7, Ns1, plate_1, plate_2].move(-19.3mm, 0mm, 0mm)
  [Body1_2, Body1_5, Np3, Np5, Np6, Np2, Np8, Np4, Np7, Np1, Ns3, Ns5, Ns6, Ns2, Ns8, Ns4, Ns7, Ns1, plate_1, plate_2].move(0mm, 0mm, -9.35mm)
  [Body1_2, Body1_5, Np3, Np5, Np6, Np2, Np8, Np4, Np7, Np1, Ns3, Ns5, Ns6, Ns2, Ns8, Ns4, Ns7, Ns1, plate_1, plate_2].split(plane=YZ, keep=PositiveOnly)
  Rectangle1 [air] = rectangle(corner=(19.3mm, 0mm, -9.35mm), z_size=18.7mm, x_size=-19.3mm)
  group core_togetherv4 = Body1_2
  group core_togetherv41 = Body1_5
  group Wire_face_flatwise_newv8 = Np3, Np5, Np6, Np2, Np8, Np4, Np7, Np1, Ns3, Ns5, Ns6, Ns2, Ns8, Ns4, Ns7, Ns1, plate_1, plate_2
boundaries and excitations:
  Symmetry1: Symmetry Edges=Region.edge(at (0, 0, 0)) IsOdd=true
  Balloon1: Balloon Edges=Region.edge(at (19.3, 0, 28.05), at (38.6, 0, 0), at (19.3, 0, -28.05)) IsOfTypeVoltage=true
  Voltage1: Voltage Objects=[Np1..Np8] Value=300V
  Voltage2: Voltage Objects=[Ns1..Ns8] Value=0V
  Floating1: Floating Objects=[Body1_2, Body1_5] Value=0
mesh:
  EdgeCut1: EdgeCutLayerMesh Objects=[Np1..Np8, Ns1..Ns8] Layer_Thickenss=0.05mm
  EdgeCut2: EdgeCutLayerMesh Objects=[plate_1, plate_2] Layer_Thickenss=0.05mm
  EdgeCut3: EdgeCutLayerMesh Objects=[Body1_2, Body1_5] Layer_Thickenss=0.05mm
  EdgeCut4: EdgeCutLayerMesh Objects=Rectangle1 Layer_Thickenss=0.05mm
  initial mesh: GlobalSurfApproximation{CurvedSurfaceApproxChoice=UseSlider SliderMeshSettings=9} GlobalModelRes{DefeatureLength=0.0001mm}
setups:
  Setup1: Electrostatic MaximumPasses=30 MinimumPasses=12 MinimumConvergedPasses=1 PercentRefinement=30 PercentError=0.05 NonLinearResidual=0.001
field plots:
  Mag_E1: E over Rectangle1 on Setup1 : LastAdaptive
  Mag_E2: E over plate_1, plate_2 on Setup1 : LastAdaptive

design E1_1kW_withKapton (Maxwell 2D, Electrostatic, about Z geometry, model units mm)
geometry:
  Region [air] = region(percentage_offset: +X=100, -X=0, +Y=0, -Y=0, +Z=100, -Z=100)
  Rectangle1 [air] = rectangle(corner=(19.3mm, 0mm, -9.35mm), z_size=18.7mm, x_size=-19.3mm)
  Body125 = imported_body(C:\Users\karlr\Desktop\core_assembled_flatwise_kaptonv2.step)
  Body125.move(0mm, -25.45mm, 0mm)
  Body125.move(-19.3mm, 0mm, 0mm)
  Body109 [kapton] = Body125.section(plane=ZX)
  Body125.delete()
  Body109.split(plane=YZ, keep=PositiveOnly)
  Body109.move(0mm, 0mm, -9.35mm)
  Body126 = imported_body(C:\Users\karlr\Desktop\core_assembled_flatwise_kaptonv2.step)
  Body126.move(0mm, -25.45mm, 0mm)
  Body126.move(-19.3mm, 0mm, 0mm)
  Body110 [kapton] = Body126.section(plane=ZX)
  Body126.delete()
  Body110.split(plane=YZ, keep=PositiveOnly)
  Body110.move(0mm, 0mm, -9.35mm)
  Body127 = imported_body(C:\Users\karlr\Desktop\core_assembled_flatwise_kaptonv2.step)
  Body127.move(0mm, -25.45mm, 0mm)
  Body127.move(-19.3mm, 0mm, 0mm)
  Body111 [kapton] = Body127.section(plane=ZX)
  Body127.delete()
  Body111.split(plane=YZ, keep=PositiveOnly)
  Body111.move(0mm, 0mm, -9.35mm)
  Body128 = imported_body(C:\Users\karlr\Desktop\core_assembled_flatwise_kaptonv2.step)
  Body128.move(0mm, -25.45mm, 0mm)
  Body128.move(-19.3mm, 0mm, 0mm)
  Body112 [kapton] = Body128.section(plane=ZX)
  Body128.delete()
  Body112.split(plane=YZ, keep=PositiveOnly)
  Body112.move(0mm, 0mm, -9.35mm)
  Body129 = imported_body(C:\Users\karlr\Desktop\core_assembled_flatwise_kaptonv2.step)
  Body129.move(0mm, -25.45mm, 0mm)
  Body129.move(-19.3mm, 0mm, 0mm)
  Body113 [kapton] = Body129.section(plane=ZX)
  Body129.delete()
  Body113.split(plane=YZ, keep=PositiveOnly)
  Body113.move(0mm, 0mm, -9.35mm)
  Body130 = imported_body(C:\Users\karlr\Desktop\core_assembled_flatwise_kaptonv2.step)
  Body130.move(0mm, -25.45mm, 0mm)
  Body130.move(-19.3mm, 0mm, 0mm)
  Body114 [kapton] = Body130.section(plane=ZX)
  Body130.delete()
  Body114.split(plane=YZ, keep=PositiveOnly)
  Body114.move(0mm, 0mm, -9.35mm)
  Body131 = imported_body(C:\Users\karlr\Desktop\core_assembled_flatwise_kaptonv2.step)
  Body131.move(0mm, -25.45mm, 0mm)
  Body131.move(-19.3mm, 0mm, 0mm)
  Body115 [kapton] = Body131.section(plane=ZX)
  Body131.delete()
  Body115.split(plane=YZ, keep=PositiveOnly)
  Body115.move(0mm, 0mm, -9.35mm)
  Body132 = imported_body(C:\Users\karlr\Desktop\core_assembled_flatwise_kaptonv2.step)
  Body132.move(0mm, -25.45mm, 0mm)
  Body132.move(-19.3mm, 0mm, 0mm)
  Body116 [kapton] = Body132.section(plane=ZX)
  Body132.delete()
  Body116.split(plane=YZ, keep=PositiveOnly)
  Body116.move(0mm, 0mm, -9.35mm)
  Body133 = imported_body(C:\Users\karlr\Desktop\core_assembled_flatwise_kaptonv2.step)
  Body133.move(0mm, -25.45mm, 0mm)
  Body133.move(-19.3mm, 0mm, 0mm)
  Body117 [kapton] = Body133.section(plane=ZX)
  Body133.delete()
  Body117.split(plane=YZ, keep=PositiveOnly)
  Body117.move(0mm, 0mm, -9.35mm)
  Body134 = imported_body(C:\Users\karlr\Desktop\core_assembled_flatwise_kaptonv2.step)
  Body134.move(0mm, -25.45mm, 0mm)
  Body134.move(-19.3mm, 0mm, 0mm)
  Body118 [kapton] = Body134.section(plane=ZX)
  Body134.delete()
  Body118.split(plane=YZ, keep=PositiveOnly)
  Body118.move(0mm, 0mm, -9.35mm)
  Body135 = imported_body(C:\Users\karlr\Desktop\core_assembled_flatwise_kaptonv2.step)
  Body135.move(0mm, -25.45mm, 0mm)
  Body135.move(-19.3mm, 0mm, 0mm)
  Body119 [kapton] = Body135.section(plane=ZX)
  Body135.delete()
  Body119.split(plane=YZ, keep=PositiveOnly)
  Body119.move(0mm, 0mm, -9.35mm)
  Body136 = imported_body(C:\Users\karlr\Desktop\core_assembled_flatwise_kaptonv2.step)
  Body136.move(0mm, -25.45mm, 0mm)
  Body136.move(-19.3mm, 0mm, 0mm)
  Body120 [kapton] = Body136.section(plane=ZX)
  Body136.delete()
  Body120.split(plane=YZ, keep=PositiveOnly)
  Body120.move(0mm, 0mm, -9.35mm)
  Body137 = imported_body(C:\Users\karlr\Desktop\core_assembled_flatwise_kaptonv2.step)
  Body137.move(0mm, -25.45mm, 0mm)
  Body137.move(-19.3mm, 0mm, 0mm)
  Body121 [kapton] = Body137.section(plane=ZX)
  Body137.delete()
  Body121.split(plane=YZ, keep=PositiveOnly)
  Body121.move(0mm, 0mm, -9.35mm)
  Body138 = imported_body(C:\Users\karlr\Desktop\core_assembled_flatwise_kaptonv2.step)
  Body138.move(0mm, -25.45mm, 0mm)
  Body138.move(-19.3mm, 0mm, 0mm)
  Body122 [kapton] = Body138.section(plane=ZX)
  Body138.delete()
  Body122.split(plane=YZ, keep=PositiveOnly)
  Body122.move(0mm, 0mm, -9.35mm)
  Body139 = imported_body(C:\Users\karlr\Desktop\core_assembled_flatwise_kaptonv2.step)
  Body139.move(0mm, -25.45mm, 0mm)
  Body139.move(-19.3mm, 0mm, 0mm)
  Body123 [kapton] = Body139.section(plane=ZX)
  Body139.delete()
  Body123.split(plane=YZ, keep=PositiveOnly)
  Body123.move(0mm, 0mm, -9.35mm)
  Body140 = imported_body(C:\Users\karlr\Desktop\core_assembled_flatwise_kaptonv2.step)
  Body140.move(0mm, -25.45mm, 0mm)
  Body140.move(-19.3mm, 0mm, 0mm)
  Body124 [kapton] = Body140.section(plane=ZX)
  Body140.delete()
  Body124.split(plane=YZ, keep=PositiveOnly)
  Body124.move(0mm, 0mm, -9.35mm)
  Np9 = imported_body(C:\Users\karlr\Desktop\core_assembled_flatwise_kaptonv2.step)
  Np9.move(0mm, -25.45mm, 0mm)
  Np9.move(-19.3mm, 0mm, 0mm)
  Np1 [coppe_real] = Np9.section(plane=ZX)
  Np9.delete()
  Np1.split(plane=YZ, keep=PositiveOnly)
  Np1.move(0mm, 0mm, -9.35mm)
  Np10 = imported_body(C:\Users\karlr\Desktop\core_assembled_flatwise_kaptonv2.step)
  Np10.move(0mm, -25.45mm, 0mm)
  Np10.move(-19.3mm, 0mm, 0mm)
  Np2 [coppe_real] = Np10.section(plane=ZX)
  Np10.delete()
  Np2.split(plane=YZ, keep=PositiveOnly)
  Np2.move(0mm, 0mm, -9.35mm)
  Np11 = imported_body(C:\Users\karlr\Desktop\core_assembled_flatwise_kaptonv2.step)
  Np11.move(0mm, -25.45mm, 0mm)
  Np11.move(-19.3mm, 0mm, 0mm)
  Np3 [coppe_real] = Np11.section(plane=ZX)
  Np11.delete()
  Np3.split(plane=YZ, keep=PositiveOnly)
  Np3.move(0mm, 0mm, -9.35mm)
  Np12 = imported_body(C:\Users\karlr\Desktop\core_assembled_flatwise_kaptonv2.step)
  Np12.move(0mm, -25.45mm, 0mm)
  Np12.move(-19.3mm, 0mm, 0mm)
  Np4 [coppe_real] = Np12.section(plane=ZX)
  Np12.delete()
  Np4.split(plane=YZ, keep=PositiveOnly)
  Np4.move(0mm, 0mm, -9.35mm)
  Np13 = imported_body(C:\Users\karlr\Desktop\core_assembled_flatwise_kaptonv2.step)
  Np13.move(0mm, -25.45mm, 0mm)
  Np13.move(-19.3mm, 0mm, 0mm)
  Np5 [coppe_real] = Np13.section(plane=ZX)
  Np13.delete()
  Np5.split(plane=YZ, keep=PositiveOnly)
  Np5.move(0mm, 0mm, -9.35mm)
  Np14 = imported_body(C:\Users\karlr\Desktop\core_assembled_flatwise_kaptonv2.step)
  Np14.move(0mm, -25.45mm, 0mm)
  Np14.move(-19.3mm, 0mm, 0mm)
  Np6 [coppe_real] = Np14.section(plane=ZX)
  Np14.delete()
  Np6.split(plane=YZ, keep=PositiveOnly)
  Np6.move(0mm, 0mm, -9.35mm)
  Np15 = imported_body(C:\Users\karlr\Desktop\core_assembled_flatwise_kaptonv2.step)
  Np15.move(0mm, -25.45mm, 0mm)
  Np15.move(-19.3mm, 0mm, 0mm)
  Np7 [coppe_real] = Np15.section(plane=ZX)
  Np15.delete()
  Np7.split(plane=YZ, keep=PositiveOnly)
  Np7.move(0mm, 0mm, -9.35mm)
  Np16 = imported_body(C:\Users\karlr\Desktop\core_assembled_flatwise_kaptonv2.step)
  Np16.move(0mm, -25.45mm, 0mm)
  Np16.move(-19.3mm, 0mm, 0mm)
  Np8 [coppe_real] = Np16.section(plane=ZX)
  Np16.delete()
  Np8.split(plane=YZ, keep=PositiveOnly)
  Np8.move(0mm, 0mm, -9.35mm)
  Ns9 = imported_body(C:\Users\karlr\Desktop\core_assembled_flatwise_kaptonv2.step)
  Ns9.move(0mm, -25.45mm, 0mm)
  Ns9.move(-19.3mm, 0mm, 0mm)
  Ns1 [coppe_real] = Ns9.section(plane=ZX)
  Ns9.delete()
  Ns1.split(plane=YZ, keep=PositiveOnly)
  Ns1.move(0mm, 0mm, -9.35mm)
  Ns10 = imported_body(C:\Users\karlr\Desktop\core_assembled_flatwise_kaptonv2.step)
  Ns10.move(0mm, -25.45mm, 0mm)
  Ns10.move(-19.3mm, 0mm, 0mm)
  Ns2 [coppe_real] = Ns10.section(plane=ZX)
  Ns10.delete()
  Ns2.split(plane=YZ, keep=PositiveOnly)
  Ns2.move(0mm, 0mm, -9.35mm)
  Ns11 = imported_body(C:\Users\karlr\Desktop\core_assembled_flatwise_kaptonv2.step)
  Ns11.move(0mm, -25.45mm, 0mm)
  Ns11.move(-19.3mm, 0mm, 0mm)
  Ns3 [coppe_real] = Ns11.section(plane=ZX)
  Ns11.delete()
  Ns3.split(plane=YZ, keep=PositiveOnly)
  Ns3.move(0mm, 0mm, -9.35mm)
  Ns12 = imported_body(C:\Users\karlr\Desktop\core_assembled_flatwise_kaptonv2.step)
  Ns12.move(0mm, -25.45mm, 0mm)
  Ns12.move(-19.3mm, 0mm, 0mm)
  Ns4 [coppe_real] = Ns12.section(plane=ZX)
  Ns12.delete()
  Ns4.split(plane=YZ, keep=PositiveOnly)
  Ns4.move(0mm, 0mm, -9.35mm)
  Ns13 = imported_body(C:\Users\karlr\Desktop\core_assembled_flatwise_kaptonv2.step)
  Ns13.move(0mm, -25.45mm, 0mm)
  Ns13.move(-19.3mm, 0mm, 0mm)
  Ns5 [coppe_real] = Ns13.section(plane=ZX)
  Ns13.delete()
  Ns5.split(plane=YZ, keep=PositiveOnly)
  Ns5.move(0mm, 0mm, -9.35mm)
  Ns14 = imported_body(C:\Users\karlr\Desktop\core_assembled_flatwise_kaptonv2.step)
  Ns14.move(0mm, -25.45mm, 0mm)
  Ns14.move(-19.3mm, 0mm, 0mm)
  Ns6 [coppe_real] = Ns14.section(plane=ZX)
  Ns14.delete()
  Ns6.split(plane=YZ, keep=PositiveOnly)
  Ns6.move(0mm, 0mm, -9.35mm)
  Ns15 = imported_body(C:\Users\karlr\Desktop\core_assembled_flatwise_kaptonv2.step)
  Ns15.move(0mm, -25.45mm, 0mm)
  Ns15.move(-19.3mm, 0mm, 0mm)
  Ns7 [coppe_real] = Ns15.section(plane=ZX)
  Ns15.delete()
  Ns7.split(plane=YZ, keep=PositiveOnly)
  Ns7.move(0mm, 0mm, -9.35mm)
  Ns16 = imported_body(C:\Users\karlr\Desktop\core_assembled_flatwise_kaptonv2.step)
  Ns16.move(0mm, -25.45mm, 0mm)
  Ns16.move(-19.3mm, 0mm, 0mm)
  Ns8 [coppe_real] = Ns16.section(plane=ZX)
  Ns16.delete()
  Ns8.split(plane=YZ, keep=PositiveOnly)
  Ns8.move(0mm, 0mm, -9.35mm)
  plate_3 = imported_body(C:\Users\karlr\Desktop\core_assembled_flatwise_kaptonv2.step)
  plate_3.move(0mm, -25.45mm, 0mm)
  plate_3.move(-19.3mm, 0mm, 0mm)
  plate_1 [silicon_TIMreal] = plate_3.section(plane=ZX)
  plate_3.delete()
  plate_1.split(plane=YZ, keep=PositiveOnly)
  plate_1.move(0mm, 0mm, -9.35mm)
  plate_4 = imported_body(C:\Users\karlr\Desktop\core_assembled_flatwise_kaptonv2.step)
  plate_4.move(0mm, -25.45mm, 0mm)
  plate_4.move(-19.3mm, 0mm, 0mm)
  plate_2 [silicon_TIMreal] = plate_4.section(plane=ZX)
  plate_4.delete()
  plate_2.split(plane=YZ, keep=PositiveOnly)
  plate_2.move(0mm, 0mm, -9.35mm)
  Body1_6 = imported_body(C:\Users\karlr\Desktop\core_assembled_flatwise_kaptonv2.step)
  Body1_6.move(0mm, -25.45mm, 0mm)
  Body1_6.move(-19.3mm, 0mm, 0mm)
  Body1_2 [ferrite - real2] = Body1_6.section(plane=ZX)
  Body1_6.delete()
  Body1_2.split(plane=YZ, keep=PositiveOnly)
  Body1_2.move(0mm, 0mm, -9.35mm)
  Body1_7 = imported_body(C:\Users\karlr\Desktop\core_assembled_flatwise_kaptonv2.step)
  Body1_7.move(0mm, -25.45mm, 0mm)
  Body1_7.move(-19.3mm, 0mm, 0mm)
  Body1_5 [ferrite - real2] = Body1_7.section(plane=ZX)
  Body1_7.delete()
  Body1_5.split(plane=YZ, keep=PositiveOnly)
  Body1_5.move(0mm, 0mm, -9.35mm)
  group core_assembled_flatwise = Body109..Body124, Np1..Np8, Ns1..Ns8, plate_1, plate_2
  group core_together_1 = Body1_2
  group core_together = Body1_5
boundaries and excitations:
  Symmetry1: Symmetry Edges=Region.edge(at (0, 0, 0)) IsOdd=true
  Balloon1: Balloon Edges=Region.edge(at (19.3, 0, 28.05), at (38.6, 0, 0), at (19.3, 0, -28.05)) IsOfTypeVoltage=true
  Voltage1: Voltage Objects=[Np1..Np8] Value=300V
  Voltage2: Voltage Objects=[Ns8, Ns1..Ns7] Value=0V
mesh:
  EdgeCut4: EdgeCutLayerMesh Objects=Rectangle1 Layer_Thickenss=0.05mm
  EdgeCut5: EdgeCutLayerMesh Objects=[Body1_2, Body1_5] Layer_Thickenss=0.05mm
  EdgeCut6: EdgeCutLayerMesh Objects=[plate_1, plate_2] Layer_Thickenss=0.05mm
  EdgeCut7: EdgeCutLayerMesh Objects=[Ns8, Np1..Np8, Ns1..Ns7] Layer_Thickenss=0.05mm
  EdgeCut8: EdgeCutLayerMesh Objects=[Body109..Body124] Layer_Thickenss=0.005mm
  initial mesh: GlobalSurfApproximation{CurvedSurfaceApproxChoice=UseSlider SliderMeshSettings=9} GlobalModelRes{DefeatureLength=0.0001mm}
setups:
  Setup1: Electrostatic MaximumPasses=30 MinimumPasses=12 MinimumConvergedPasses=1 PercentRefinement=30 PercentError=0.3 NonLinearResidual=0.001
field plots:
  Mag_E1: E over plate_2, Body113, Ns8, Np8, Body112, Rectangle1 on Setup1 : LastAdaptive

design Maxwell2DDesign1 (Maxwell 2D, Magnetostatic, about Z geometry, model units mm)
geometry:
  Body109#8633, Body110#8863, Body111#9093, Body112#9323, Body113#9553, Body114#9783, Body115#10013, Body116#10243, Body117#10473, Body118#10703, Body119#10933, Body120#11163, Body121#11393, Body122#11623, Body123#11853, Body124#12083, Np1#12313, Np2#12429, Np3#12545, Np4#12661, Np5#12777, Np6#12893, Np7#13009, Np8#13125, Ns1#13241, Ns2#13357, Ns3#13473, Ns4#13589, Ns5#13705, Ns6#13821, Ns7#13937, Ns8#14053, plate_1#14169, plate_2#15533, Body1_2#17001, Body1_5#17181 = imported_body(C:\Users\karlr\Desktop\core_assembled_flatwise_kaptonv2.step)
  [Body109#8633, Body110#8863, Body111#9093, Body112#9323, Body113#9553, Body114#9783, Body115#10013, Body116#10243, Body117#10473, Body118#10703, Body119#10933, Body120#11163, Body121#11393, Body122#11623, Body123#11853, Body124#12083, Np1#12313, Np2#12429, Np3#12545, Np4#12661, Np5#12777, Np6#12893, Np7#13009, Np8#13125, Ns1#13241, Ns2#13357, Ns3#13473, Ns4#13589, Ns5#13705, Ns6#13821, Ns7#13937, Ns8#14053, plate_1#14169, plate_2#15533, Body1_2#17001, Body1_5#17181].move(0mm, -25.45mm, 0mm)
  [Body109#8633, Body110#8863, Body111#9093, Body112#9323, Body113#9553, Body114#9783, Body115#10013, Body116#10243, Body117#10473, Body118#10703, Body119#10933, Body120#11163, Body121#11393, Body122#11623, Body123#11853, Body124#12083, Np1#12313, Np2#12429, Np3#12545, Np4#12661, Np5#12777, Np6#12893, Np7#13009, Np8#13125, Ns1#13241, Ns2#13357, Ns3#13473, Ns4#13589, Ns5#13705, Ns6#13821, Ns7#13937, Ns8#14053, plate_1#14169, plate_2#15533, Body1_2#17001, Body1_5#17181].move(-19.3mm, 0mm, 0mm)
  Body109 = Body109#8633.section(plane=ZX)
  Body109#8633.delete()
  Body110 = Body110#8863.section(plane=ZX)
  Body110#8863.delete()
  Body111 = Body111#9093.section(plane=ZX)
  Body111#9093.delete()
  Body112 = Body112#9323.section(plane=ZX)
  Body112#9323.delete()
  Body113 = Body113#9553.section(plane=ZX)
  Body113#9553.delete()
  Body114 = Body114#9783.section(plane=ZX)
  Body114#9783.delete()
  Body115 = Body115#10013.section(plane=ZX)
  Body115#10013.delete()
  Body116 = Body116#10243.section(plane=ZX)
  Body116#10243.delete()
  Body117 = Body117#10473.section(plane=ZX)
  Body117#10473.delete()
  Body118 = Body118#10703.section(plane=ZX)
  Body118#10703.delete()
  Body119 = Body119#10933.section(plane=ZX)
  Body119#10933.delete()
  Body120 = Body120#11163.section(plane=ZX)
  Body120#11163.delete()
  Body121 = Body121#11393.section(plane=ZX)
  Body121#11393.delete()
  Body122 = Body122#11623.section(plane=ZX)
  Body122#11623.delete()
  Body123 = Body123#11853.section(plane=ZX)
  Body123#11853.delete()
  Body124 = Body124#12083.section(plane=ZX)
  Body124#12083.delete()
  Np1 = Np1#12313.section(plane=ZX)
  Np1#12313.delete()
  Np2 = Np2#12429.section(plane=ZX)
  Np2#12429.delete()
  Np3 = Np3#12545.section(plane=ZX)
  Np3#12545.delete()
  Np4 = Np4#12661.section(plane=ZX)
  Np4#12661.delete()
  Np5 = Np5#12777.section(plane=ZX)
  Np5#12777.delete()
  Np6 = Np6#12893.section(plane=ZX)
  Np6#12893.delete()
  Np7 = Np7#13009.section(plane=ZX)
  Np7#13009.delete()
  Np8 = Np8#13125.section(plane=ZX)
  Np8#13125.delete()
  Ns1 = Ns1#13241.section(plane=ZX)
  Ns1#13241.delete()
  Ns2 = Ns2#13357.section(plane=ZX)
  Ns2#13357.delete()
  Ns3 = Ns3#13473.section(plane=ZX)
  Ns3#13473.delete()
  Ns4 = Ns4#13589.section(plane=ZX)
  Ns4#13589.delete()
  Ns5 = Ns5#13705.section(plane=ZX)
  Ns5#13705.delete()
  Ns6 = Ns6#13821.section(plane=ZX)
  Ns6#13821.delete()
  Ns7 = Ns7#13937.section(plane=ZX)
  Ns7#13937.delete()
  Ns8 = Ns8#14053.section(plane=ZX)
  Ns8#14053.delete()
  plate_1 = plate_1#14169.section(plane=ZX)
  plate_1#14169.delete()
  plate_2 = plate_2#15533.section(plane=ZX)
  plate_2#15533.delete()
  Body1_2 = Body1_2#17001.section(plane=ZX)
  Body1_2#17001.delete()
  Body1_5 = Body1_5#17181.section(plane=ZX)
  Body1_5#17181.delete()
  [Body109..Body124, Np1..Np8, Ns1..Ns8, plate_1, plate_2, Body1_2, Body1_5].split(plane=YZ, keep=PositiveOnly)
  [Body109..Body124, Np1..Np8, Ns1..Ns8, plate_1, plate_2, Body1_2, Body1_5].move(0mm, 0mm, -9.35mm)
  group core_assembled_flatwise = Body109..Body124, Np1..Np8, Ns1..Ns8, plate_1, plate_2
  group core_together_1 = Body1_2
  group core_together = Body1_5
