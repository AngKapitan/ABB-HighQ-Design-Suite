# Ansys Electronics Desktop project, version 2023.1
materials:
  vacuum: permittivity=1
  air: permittivity=1.0006 permeability=1.0000004
  coppe_real: permeability=0.999991 conductivity=59880239.52
  ferrite - real2: core_loss_curve{25kHz (0, 0) (0.050633, 1) (0.0590114, 1.50406) (0.0691674, 2.34392) (0.0792528, 3.65275) (0.088772, 5.02746) (0.0939521, 6.11121) (0.1, 7.16954) (0.109499, 8.56175) (0.121957, 11.5767) (0.138164, 16.5092) (0.153013, 23.1293) (0.173347, 32.9841) (0.195272, 44.5991) (0.21382, 61.3838) (0.235462, 78.6962) (0.259294, 104.536) (0.280722, 138.862) (0.295422, 151.746)} core_loss_curve{100kHz (0, 0) (0.0263744, 1.03613) (0.0293752, 1.42608) (0.0332788, 2.03369) (0.0396755, 3.1693) (0.0449479, 4.44016) (0.0523856, 6.91954) (0.0628101, 11.373) (0.0753091, 20.068) (0.0882699, 32.4039) (0.103461, 49.6099) (0.118547, 74.6161) (0.142138, 118.363) (0.165658, 191.122) (0.184506, 245.025) (0.1975, 325.48) (0.215037, 409.937) (0.242235, 554.291) (0.26827, 762.898) (0.287163, 911.04)} core_loss_curve{200kHz (0, 0) (0.0153013, 1.07357) (0.0196383, 2.03369) (0.0260769, 4.28533) (0.0305648, 7.42858) (0.0396755, 14.0722) (0.0481134, 22.7224) (0.059347, 38.6962) (0.0757374, 74.6161) (0.0994345, 162.909) (0.110748, 216.401) (0.130546, 319.755) (0.147894, 472.47) (0.164721, 605.722) (0.183462, 848.612) (0.194168, 1013.4) (0.210213, 1167.99) (0.235462, 1607.55) (0.252045, 2024.69) (0.274425, 2333.54) (0.290439, 2939.06)} core_loss_curve{500kHz (0, 0) (0.0101716, 5.89811) (0.01199, 8.71505) (0.0149581, 13.5815) (0.0170423, 18.6929) (0.0202031, 30.1834) (0.0235462, 38.6962) (0.0266752, 55.1837) (0.0309135, 72.0142) (0.0356225, 99.1166) (0.0401281, 129.346) (0.0465037, 187.76) (0.0515018, 236.481) (0.0580159, 319.755) (0.067616, 447.974) (0.0761681, 574.318) (0.0892769, 776.557) (0.101141, 1068.81) (0.1199, 1524.21) (0.142138, 2292.49) (0.174333, 3327.81) (0.199753, 5186.04) (0.22248, 6531.74) (0.249202, 8373.92)} permittivity=12 permeability=3300 conductivity=0.25 core_loss_type="Power Ferrite" core_loss_cm=2.0420624 core_loss_x=1.4062949 core_loss_y=2.7267175 mass_density=4800 core_loss_equiv_cut_depth=0.001meter
  kapton: permittivity=3.5 conductivity=1e-15 dielectric_loss_tangent=0.008
  silicon_TIMreal: permittivity=7 conductivity=1e-11
  GE GETEK ML200/RG200 (tm): permittivity=3.9 dielectric_loss_tangent=0.012

design 100kW_2mm (Maxwell 2D, Electrostatic, XY geometry, model units mm)
geometry:
  Rectangle1 [ferrite - real2] = rectangle(corner=(0mm, 0mm, 0mm), x_size=2*$Core_width+$l_TIM, y_size=2*$Core_Height+$l_g)
  Rectangle2 = rectangle(corner=($Core_width, $Core_width+$d_TIM, 0mm), x_size=$l_TIM, y_size=$h_wire)
  air_gap = rectangle(corner=(0mm, $Core_Height, 0mm), x_size=$Core_width, y_size=$l_g)
  Rectangle3 = rectangle(corner=($Core_width+$l_TIM, $Core_Height, 0mm), x_size=$Core_width, y_size=$l_g)
  Rectangle4 [silicon_TIMreal] = rectangle(corner=($Core_width, $Core_width, 0mm), x_size=$l_TIM, y_size=$d_TIM)
  Rectangle1.subtract(Rectangle2)
  Rectangle5 [silicon_TIMreal] = rectangle(corner=($Core_width, $Core_width+$d_TIM+$h_wire, 0mm), x_size=$l_TIM, y_size=$d_TIM)
  N_1 [coppe_real] = rectangle(corner=($Core_width+$d_clear, $Core_width+$d_TIM, 0mm), x_size=$w_wire, y_size=$h_wire)
  S_1 [coppe_real] = rectangle(corner=($Core_width+$d_clear+$w_wire*1+$d_inter*1, $d_TIM+$Core_width, 0mm), x_size=$w_wire, y_size=$h_wire)
  N_2 [coppe_real] = rectangle(corner=($Core_width+$d_clear+$w_wire*2+$d_inter*2, $d_TIM+$Core_width, 0mm), x_size=$w_wire, y_size=$h_wire)
  S_2 [coppe_real] = rectangle(corner=($Core_width+$d_clear+$w_wire*3+$d_inter*3, $d_TIM+$Core_width, 0mm), x_size=$w_wire, y_size=$h_wire)
  Rectangle1.subtract(air_gap)
  Rectangle1.subtract(Rectangle3)
  Rectangle4_1 = Rectangle4.copy()
  Rectangle5_1 = Rectangle5.copy()
  Rectangle1.subtract(Rectangle4_1, Rectangle5_1)
  Region [air] = region(percentage_offset: +X=50, -X=0, +Y=50, -Y=50, +Z=0, -Z=0)
  Rectangle6 [air] = rectangle(corner=(0mm, 0mm, 0mm), x_size=$l_TIM+2*$Core_width, y_size=$Core_Height*2+$l_g)
boundaries and excitations:
  Symmetry1: Symmetry Edges=Region.edge(at (0, 20.05, 0)) IsOdd=false
  Balloon1: Balloon Edges=Region.edge(at (23.25, 60.15, 0), at (46.5, 20.05, 0), at (23.25, -20.05, 0)) IsOfTypeVoltage=false
  Primary: Voltage Objects=[N_1, N_2] Value=3100V
  Secondary: Voltage Objects=[S_1, S_2] Value=0V
mesh:
  EdgeCut1: EdgeCutLayerMesh Objects=Rectangle6 Layer_Thickenss=0.05mm
  EdgeCut2: EdgeCutLayerMesh Objects=[N_1, N_2, S_1, S_2] Layer_Thickenss=0.05mm
  EdgeCut3: EdgeCutLayerMesh Objects=[Rectangle4, Rectangle5] Layer_Thickenss=0.05mm
  EdgeCut4: EdgeCutLayerMesh Objects=Rectangle1 Layer_Thickenss=0.05mm
setups:
  Setup1: Electrostatic MaximumPasses=20 MinimumPasses=10 MinimumConvergedPasses=1 PercentRefinement=70 PercentError=0.5 NonLinearResidual=0.001
field plots:
  Mag_E1: E over Rectangle6 on Setup1 : LastAdaptive
  Mag_E2: E over Rectangle4, Rectangle5 on Setup1 : LastAdaptive
  Mesh1: MeshPlots over Rectangle6 on Setup1 : LastAdaptive
  Mesh2: MeshPlots over Rectangle6, Region, N_1, N_2, S_1, S_2, Rectangle1, Rectangle4, Rectangle5 on Setup1 : LastAdaptive

design E1_1kW_withKapton (Maxwell 2D, Electrostatic, about Z geometry, model units mm)
geometry:
  Region [air] = region(percentage_offset: +X=100, -X=0, +Y=0, -Y=0, +Z=100, -Z=100)
  Rectangle1 [air] = rectangle(corner=(19.3mm, 0mm, -9.35mm), z_size=18.7mm, x_size=-19.3mm)
  Body125 = imported_body(C:\Users\karlr\Desktop\core_assembled_flatwise_kaptonv2.step)
  Body125.move(0mm, -25.45mm, 0mm)
  Body125.move(-19.3mm, 0mm, 0mm)
  Body109 [kapton] = Body125.section(plane=ZX)
  Body125.delete()
  Body109.split(plane=YZ, keep=PositiveOnly)
  Body109.move(0mm, 0mm, -9.35mm)
  Body126 = imported_body(C:\Users\karlr\Desktop\core_assembled_flatwise_kaptonv2.step)
  Body126.move(0mm, -25.45mm, 0mm)
  Body126.move(-19.3mm, 0mm, 0mm)
  Body110 [kapton] = Body126.section(plane=ZX)
  Body126.delete()
  Body110.split(plane=YZ, keep=PositiveOnly)
  Body110.move(0mm, 0mm, -9.35mm)
  Body127 = imported_body(C:\Users\karlr\Desktop\core_assembled_flatwise_kaptonv2.step)
  Body127.move(0mm, -25.45mm, 0mm)
  Body127.move(-19.3mm, 0mm, 0mm)
  Body111 [kapton] = Body127.section(plane=ZX)
  Body127.delete()
  Body111.split(plane=YZ, keep=PositiveOnly)
  Body111.move(0mm, 0mm, -9.35mm)
  Body128 = imported_body(C:\Users\karlr\Desktop\core_assembled_flatwise_kaptonv2.step)
  Body128.move(0mm, -25.45mm, 0mm)
  Body128.move(-19.3mm, 0mm, 0mm)
  Body112 [kapton] = Body128.section(plane=ZX)
  Body128.delete()
  Body112.split(plane=YZ, keep=PositiveOnly)
  Body112.move(0mm, 0mm, -9.35mm)
  Body129 = imported_body(C:\Users\karlr\Desktop\core_assembled_flatwise_kaptonv2.step)
  Body129.move(0mm, -25.45mm, 0mm)
  Body129.move(-19.3mm, 0mm, 0mm)
  Body113 [kapton] = Body129.section(plane=ZX)
  Body129.delete()
  Body113.split(plane=YZ, keep=PositiveOnly)
  Body113.move(0mm, 0mm, -9.35mm)
  Body130 = imported_body(C:\Users\karlr\Desktop\core_assembled_flatwise_kaptonv2.step)
  Body130.move(0mm, -25.45mm, 0mm)
  Body130.move(-19.3mm, 0mm, 0mm)
  Body114 [kapton] = Body130.section(plane=ZX)
  Body130.delete()
  Body114.split(plane=YZ, keep=PositiveOnly)
  Body114.move(0mm, 0mm, -9.35mm)
  Body131 = imported_body(C:\Users\karlr\Desktop\core_assembled_flatwise_kaptonv2.step)
  Body131.move(0mm, -25.45mm, 0mm)
  Body131.move(-19.3mm, 0mm, 0mm)
  Body115 [kapton] = Body131.section(plane=ZX)
  Body131.delete()
  Body115.split(plane=YZ, keep=PositiveOnly)
  Body115.move(0mm, 0mm, -9.35mm)
  Body132 = imported_body(C:\Users\karlr\Desktop\core_assembled_flatwise_kaptonv2.step)
  Body132.move(0mm, -25.45mm, 0mm)
  Body132.move(-19.3mm, 0mm, 0mm)
  Body116 [kapton] = Body132.section(plane=ZX)
  Body132.delete()
  Body116.split(plane=YZ, keep=PositiveOnly)
  Body116.move(0mm, 0mm, -9.35mm)
  Body133 = imported_body(C:\Users\karlr\Desktop\core_assembled_flatwise_kaptonv2.step)
  Body133.move(0mm, -25.45mm, 0mm)
  Body133.move(-19.3mm, 0mm, 0mm)
  Body117 [kapton] = Body133.section(plane=ZX)
  Body133.delete()
  Body117.split(plane=YZ, keep=PositiveOnly)
  Body117.move(0mm, 0mm, -9.35mm)
  Body134 = imported_body(C:\Users\karlr\Desktop\core_assembled_flatwise_kaptonv2.step)
  Body134.move(0mm, -25.45mm, 0mm)
  Body134.move(-19.3mm, 0mm, 0mm)
  Body118 [kapton] = Body134.section(plane=ZX)
  Body134.delete()
  Body118.split(plane=YZ, keep=PositiveOnly)
  Body118.move(0mm, 0mm, -9.35mm)
  Body135 = imported_body(C:\Users\karlr\Desktop\core_assembled_flatwise_kaptonv2.step)
  Body135.move(0mm, -25.45mm, 0mm)
  Body135.move(-19.3mm, 0mm, 0mm)
  Body119 [kapton] = Body135.section(plane=ZX)
  Body135.delete()
  Body119.split(plane=YZ, keep=PositiveOnly)
  Body119.move(0mm, 0mm, -9.35mm)
  Body136 = imported_body(C:\Users\karlr\Desktop\core_assembled_flatwise_kaptonv2.step)
  Body136.move(0mm, -25.45mm, 0mm)
  Body136.move(-19.3mm, 0mm, 0mm)
  Body120 [kapton] = Body136.section(plane=ZX)
  Body136.delete()
  Body120.split(plane=YZ, keep=PositiveOnly)
  Body120.move(0mm, 0mm, -9.35mm)
  Body137 = imported_body(C:\Users\karlr\Desktop\core_assembled_flatwise_kaptonv2.step)
  Body137.move(0mm, -25.45mm, 0mm)
  Body137.move(-19.3mm, 0mm, 0mm)
  Body121 [kapton] = Body137.section(plane=ZX)
  Body137.delete()
  Body121.split(plane=YZ, keep=PositiveOnly)
  Body121.move(0mm, 0mm, -9.35mm)
  Body138 = imported_body(C:\Users\karlr\Desktop\core_assembled_flatwise_kaptonv2.step)
  Body138.move(0mm, -25.45mm, 0mm)
  Body138.move(-19.3mm, 0mm, 0mm)
  Body122 [kapton] = Body138.section(plane=ZX)
  Body138.delete()
  Body122.split(plane=YZ, keep=PositiveOnly)
  Body122.move(0mm, 0mm, -9.35mm)
  Body139 = imported_body(C:\Users\karlr\Desktop\core_assembled_flatwise_kaptonv2.step)
  Body139.move(0mm, -25.45mm, 0mm)
  Body139.move(-19.3mm, 0mm, 0mm)
  Body123 [kapton] = Body139.section(plane=ZX)
  Body139.delete()
  Body123.split(plane=YZ, keep=PositiveOnly)
  Body123.move(0mm, 0mm, -9.35mm)
  Body140 = imported_body(C:\Users\karlr\Desktop\core_assembled_flatwise_kaptonv2.step)
  Body140.move(0mm, -25.45mm, 0mm)
  Body140.move(-19.3mm, 0mm, 0mm)
  Body124 [kapton] = Body140.section(plane=ZX)
  Body140.delete()
  Body124.split(plane=YZ, keep=PositiveOnly)
  Body124.move(0mm, 0mm, -9.35mm)
  Np9 = imported_body(C:\Users\karlr\Desktop\core_assembled_flatwise_kaptonv2.step)
  Np9.move(0mm, -25.45mm, 0mm)
  Np9.move(-19.3mm, 0mm, 0mm)
  Np1 [coppe_real] = Np9.section(plane=ZX)
  Np9.delete()
  Np1.split(plane=YZ, keep=PositiveOnly)
  Np1.move(0mm, 0mm, -9.35mm)
  Np10 = imported_body(C:\Users\karlr\Desktop\core_assembled_flatwise_kaptonv2.step)
  Np10.move(0mm, -25.45mm, 0mm)
  Np10.move(-19.3mm, 0mm, 0mm)
  Np2 [coppe_real] = Np10.section(plane=ZX)
  Np10.delete()
  Np2.split(plane=YZ, keep=PositiveOnly)
  Np2.move(0mm, 0mm, -9.35mm)
  Np11 = imported_body(C:\Users\karlr\Desktop\core_assembled_flatwise_kaptonv2.step)
  Np11.move(0mm, -25.45mm, 0mm)
  Np11.move(-19.3mm, 0mm, 0mm)
  Np3 [coppe_real] = Np11.section(plane=ZX)
  Np11.delete()
  Np3.split(plane=YZ, keep=PositiveOnly)
  Np3.move(0mm, 0mm, -9.35mm)
  Np12 = imported_body(C:\Users\karlr\Desktop\core_assembled_flatwise_kaptonv2.step)
  Np12.move(0mm, -25.45mm, 0mm)
  Np12.move(-19.3mm, 0mm, 0mm)
  Np4 [coppe_real] = Np12.section(plane=ZX)
  Np12.delete()
  Np4.split(plane=YZ, keep=PositiveOnly)
  Np4.move(0mm, 0mm, -9.35mm)
  Np13 = imported_body(C:\Users\karlr\Desktop\core_assembled_flatwise_kaptonv2.step)
  Np13.move(0mm, -25.45mm, 0mm)
  Np13.move(-19.3mm, 0mm, 0mm)
  Np5 [coppe_real] = Np13.section(plane=ZX)
  Np13.delete()
  Np5.split(plane=YZ, keep=PositiveOnly)
  Np5.move(0mm, 0mm, -9.35mm)
  Np14 = imported_body(C:\Users\karlr\Desktop\core_assembled_flatwise_kaptonv2.step)
  Np14.move(0mm, -25.45mm, 0mm)
  Np14.move(-19.3mm, 0mm, 0mm)
  Np6 [coppe_real] = Np14.section(plane=ZX)
  Np14.delete()
  Np6.split(plane=YZ, keep=PositiveOnly)
  Np6.move(0mm, 0mm, -9.35mm)
  Np15 = imported_body(C:\Users\karlr\Desktop\core_assembled_flatwise_kaptonv2.step)
  Np15.move(0mm, -25.45mm, 0mm)
  Np15.move(-19.3mm, 0mm, 0mm)
  Np7 [coppe_real] = Np15.section(plane=ZX)
  Np15.delete()
  Np7.split(plane=YZ, keep=PositiveOnly)
  Np7.move(0mm, 0mm, -9.35mm)
  Np16 = imported_body(C:\Users\karlr\Desktop\core_assembled_flatwise_kaptonv2.step)
  Np16.move(0mm, -25.45mm, 0mm)
  Np16.move(-19.3mm, 0mm, 0mm)
  Np8 [coppe_real] = Np16.section(plane=ZX)
  Np16.delete()
  Np8.split(plane=YZ, keep=PositiveOnly)
  Np8.move(0mm, 0mm, -9.35mm)
  Ns9 = imported_body(C:\Users\karlr\Desktop\core_assembled_flatwise_kaptonv2.step)
  Ns9.move(0mm, -25.45mm, 0mm)
  Ns9.move(-19.3mm, 0mm, 0mm)
  Ns1 [coppe_real] = Ns9.section(plane=ZX)
  Ns9.delete()
  Ns1.split(plane=YZ, keep=PositiveOnly)
  Ns1.move(0mm, 0mm, -9.35mm)
  Ns10 = imported_body(C:\Users\karlr\Desktop\core_assembled_flatwise_kaptonv2.step)
  Ns10.move(0mm, -25.45mm, 0mm)
  Ns10.move(-19.3mm, 0mm, 0mm)
  Ns2 [coppe_real] = Ns10.section(plane=ZX)
  Ns10.delete()
  Ns2.split(plane=YZ, keep=PositiveOnly)
  Ns2.move(0mm, 0mm, -9.35mm)
  Ns11 = imported_body(C:\Users\karlr\Desktop\core_assembled_flatwise_kaptonv2.step)
  Ns11.move(0mm, -25.45mm, 0mm)
  Ns11.move(-19.3mm, 0mm, 0mm)
  Ns3 [coppe_real] = Ns11.section(plane=ZX)
  Ns11.delete()
  Ns3.split(plane=YZ, keep=PositiveOnly)
  Ns3.move(0mm, 0mm, -9.35mm)
  Ns12 = imported_body(C:\Users\karlr\Desktop\core_assembled_flatwise_kaptonv2.step)
  Ns12.move(0mm, -25.45mm, 0mm)
  Ns12.move(-19.3mm, 0mm, 0mm)
  Ns4 [coppe_real] = Ns12.section(plane=ZX)
  Ns12.delete()
  Ns4.split(plane=YZ, keep=PositiveOnly)
  Ns4.move(0mm, 0mm, -9.35mm)
  Ns13 = imported_body(C:\Users\karlr\Desktop\core_assembled_flatwise_kaptonv2.step)
  Ns13.move(0mm, -25.45mm, 0mm)
  Ns13.move(-19.3mm, 0mm, 0mm)
  Ns5 [coppe_real] = Ns13.section(plane=ZX)
  Ns13.delete()
  Ns5.split(plane=YZ, keep=PositiveOnly)
  Ns5.move(0mm, 0mm, -9.35mm)
  Ns14 = imported_body(C:\Users\karlr\Desktop\core_assembled_flatwise_kaptonv2.step)
  Ns14.move(0mm, -25.45mm, 0mm)
  Ns14.move(-19.3mm, 0mm, 0mm)
  Ns6 [coppe_real] = Ns14.section(plane=ZX)
  Ns14.delete()
  Ns6.split(plane=YZ, keep=PositiveOnly)
  Ns6.move(0mm, 0mm, -9.35mm)
  Ns15 = imported_body(C:\Users\karlr\Desktop\core_assembled_flatwise_kaptonv2.step)
  Ns15.move(0mm, -25.45mm, 0mm)
  Ns15.move(-19.3mm, 0mm, 0mm)
  Ns7 [coppe_real] = Ns15.section(plane=ZX)
  Ns15.delete()
  Ns7.split(plane=YZ, keep=PositiveOnly)
  Ns7.move(0mm, 0mm, -9.35mm)
  Ns16 = imported_body(C:\Users\karlr\Desktop\core_assembled_flatwise_kaptonv2.step)
  Ns16.move(0mm, -25.45mm, 0mm)
  Ns16.move(-19.3mm, 0mm, 0mm)
  Ns8 [coppe_real] = Ns16.section(plane=ZX)
  Ns16.delete()
  Ns8.split(plane=YZ, keep=PositiveOnly)
  Ns8.move(0mm, 0mm, -9.35mm)
  plate_3 = imported_body(C:\Users\karlr\Desktop\core_assembled_flatwise_kaptonv2.step)
  plate_3.move(0mm, -25.45mm, 0mm)
  plate_3.move(-19.3mm, 0mm, 0mm)
  plate_1 [silicon_TIMreal] = plate_3.section(plane=ZX)
  plate_3.delete()
  plate_1.split(plane=YZ, keep=PositiveOnly)
  plate_1.move(0mm, 0mm, -9.35mm)
  plate_4 = imported_body(C:\Users\karlr\Desktop\core_assembled_flatwise_kaptonv2.step)
  plate_4.move(0mm, -25.45mm, 0mm)
  plate_4.move(-19.3mm, 0mm, 0mm)
  plate_2 [silicon_TIMreal] = plate_4.section(plane=ZX)
  plate_4.delete()
  plate_2.split(plane=YZ, keep=PositiveOnly)
  plate_2.move(0mm, 0mm, -9.35mm)
  Body1_6 = imported_body(C:\Users\karlr\Desktop\core_assembled_flatwise_kaptonv2.step)
  Body1_6.move(0mm, -25.45mm, 0mm)
  Body1_6.move(-19.3mm, 0mm, 0mm)
  Body1_2 [ferrite - real2] = Body1_6.section(plane=ZX)
  Body1_6.delete()
  Body1_2.split(plane=YZ, keep=PositiveOnly)
  Body1_2.move(0mm, 0mm, -9.35mm)
  Body1_7 = imported_body(C:\Users\karlr\Desktop\core_assembled_flatwise_kaptonv2.step)
  Body1_7.move(0mm, -25.45mm, 0mm)
  Body1_7.move(-19.3mm, 0mm, 0mm)
  Body1_5 [ferrite - real2] = Body1_7.section(plane=ZX)
  Body1_7.delete()
  Body1_5.split(plane=YZ, keep=PositiveOnly)
  Body1_5.move(0mm, 0mm, -9.35mm)
  group core_assembled_flatwise = Body109..Body124, Np1..Np8, Ns1..Ns8, plate_1, plate_2
  group core_together_1 = Body1_2
  group core_together = Body1_5
boundaries and excitations:
  Symmetry1: Symmetry Edges=Region.edge(at (0, 0, 0)) IsOdd=true
  Balloon1: Balloon Edges=Region.edge(at (19.3, 0, 28.05), at (38.6, 0, 0), at (19.3, 0, -28.05)) IsOfTypeVoltage=true
  Voltage1: Voltage Objects=[Np1..Np8] Value=300V
  Voltage2: Voltage Objects=[Ns8, Ns1..Ns7] Value=0V
mesh:
  EdgeCut4: EdgeCutLayerMesh Objects=Rectangle1 Layer_Thickenss=0.05mm
  EdgeCut5: EdgeCutLayerMesh Objects=[Body1_2, Body1_5] Layer_Thickenss=0.05mm
  EdgeCut6: EdgeCutLayerMesh Objects=[plate_1, plate_2] Layer_Thickenss=0.05mm
  EdgeCut7: EdgeCutLayerMesh Objects=[Ns8, Np1..Np8, Ns1..Ns7] Layer_Thickenss=0.05mm
  EdgeCut8: EdgeCutLayerMesh Objects=[Body109..Body124] Layer_Thickenss=0.005mm
  initial mesh: GlobalSurfApproximation{CurvedSurfaceApproxChoice=UseSlider SliderMeshSettings=9} GlobalModelRes{DefeatureLength=0.0001mm}
setups:
  Setup1: Electrostatic MaximumPasses=30 MinimumPasses=12 MinimumConvergedPasses=1 PercentRefinement=30 PercentError=0.3 NonLinearResidual=0.001
field plots:
  Mag_E1: E over plate_2, Body113, Ns8, Np8, Body112, Rectangle1 on Setup1 : LastAdaptive

design 100kW_1.5mm (Maxwell 2D, Electrostatic, XY geometry, model units mm)
geometry:
  Rectangle1 [ferrite - real2] = rectangle(corner=(0mm, 0mm, 0mm), x_size=2*$Core_width+$l_TIM, y_size=2*$Core_Height+$l_g)
  Rectangle2 = rectangle(corner=($Core_width, $Core_width+$d_TIM, 0mm), x_size=$l_TIM, y_size=$h_wire)
  air_gap = rectangle(corner=(0mm, $Core_Height, 0mm), x_size=$Core_width, y_size=$l_g)
  Rectangle3 = rectangle(corner=($Core_width+$l_TIM, $Core_Height, 0mm), x_size=$Core_width, y_size=$l_g)
  Rectangle4 [silicon_TIMreal] = rectangle(corner=($Core_width, $Core_width, 0mm), x_size=$l_TIM, y_size=$d_TIM)
  Rectangle1.subtract(Rectangle2)
  Rectangle5 [silicon_TIMreal] = rectangle(corner=($Core_width, $Core_width+$d_TIM+$h_wire, 0mm), x_size=$l_TIM, y_size=$d_TIM)
  N_1 [coppe_real] = rectangle(corner=($Core_width+$d_clear, $Core_width+$d_TIM, 0mm), x_size=$w_wire, y_size=$h_wire)
  S_1 [coppe_real] = rectangle(corner=($Core_width+$d_clear+$w_wire*1+$d_inter*1, $d_TIM+$Core_width, 0mm), x_size=$w_wire, y_size=$h_wire)
  N_2 [coppe_real] = rectangle(corner=($Core_width+$d_clear+$w_wire*2+$d_inter*2, $d_TIM+$Core_width, 0mm), x_size=$w_wire, y_size=$h_wire)
  S_2 [coppe_real] = rectangle(corner=($Core_width+$d_clear+$w_wire*3+$d_inter*3, $d_TIM+$Core_width, 0mm), x_size=$w_wire, y_size=$h_wire)
  Rectangle1.subtract(air_gap)
  Rectangle1.subtract(Rectangle3)
  Rectangle4_1 = Rectangle4.copy()
  Rectangle5_1 = Rectangle5.copy()
  Rectangle1.subtract(Rectangle4_1, Rectangle5_1)
  Region [air] = region(percentage_offset: +X=50, -X=0, +Y=50, -Y=50, +Z=0, -Z=0)
  Rectangle6 [air] = rectangle(corner=(0mm, 0mm, 0mm), x_size=$l_TIM+2*$Core_width, y_size=$Core_Height*2+$l_g)
boundaries and excitations:
  Symmetry1: Symmetry Edges=Region.edge(at (0, 20.05, 0)) IsOdd=false
  Balloon1: Balloon Edges=Region.edge(at (23.25, 60.15, 0), at (46.5, 20.05, 0), at (23.25, -20.05, 0)) IsOfTypeVoltage=false
  Primary: Voltage Objects=[N_1, N_2] Value=3100V
  Secondary: Voltage Objects=[S_1, S_2] Value=0V
mesh:
  EdgeCut1: EdgeCutLayerMesh Objects=Rectangle6 Layer_Thickenss=0.05mm
  EdgeCut2: EdgeCutLayerMesh Objects=[N_1, N_2, S_1, S_2] Layer_Thickenss=0.05mm
  EdgeCut3: EdgeCutLayerMesh Objects=[Rectangle4, Rectangle5] Layer_Thickenss=0.05mm
  EdgeCut4: EdgeCutLayerMesh Objects=Rectangle1 Layer_Thickenss=0.05mm
setups:
  Setup1: Electrostatic MaximumPasses=20 MinimumPasses=10 MinimumConvergedPasses=1 PercentRefinement=70 PercentError=0.5 NonLinearResidual=0.001
field plots:
  Mag_E1: E over Rectangle6 on Setup1 : LastAdaptive
  Mag_E2: E over Rectangle4, Rectangle5 on Setup1 : LastAdaptive

design 10kW_1.5mm (Maxwell 2D, Electrostatic, XY geometry, model units mm)
geometry:
  Rectangle1 [ferrite - real2] = rectangle(corner=(0mm, 0mm, 0mm), x_size=2*$Core_width+$l_TIM, y_size=2*$Core_Height+$l_g)
  Rectangle2 = rectangle(corner=($Core_width, $Core_width+$d_TIM, 0mm), x_size=$l_TIM, y_size=$h_wire)
  air_gap = rectangle(corner=(0mm, $Core_Height, 0mm), x_size=$Core_width, y_size=$l_g)
  Rectangle3 = rectangle(corner=($Core_width+$l_TIM, $Core_Height, 0mm), x_size=$Core_width, y_size=$l_g)
  Rectangle4 [silicon_TIMreal] = rectangle(corner=($Core_width, $Core_width, 0mm), x_size=$l_TIM, y_size=$d_TIM)
  Rectangle1.subtract(Rectangle2)
  Rectangle5 [silicon_TIMreal] = rectangle(corner=($Core_width, $Core_width+$d_TIM+$h_wire, 0mm), x_size=$l_TIM, y_size=$d_TIM)
  N_1 [coppe_real] = rectangle(corner=($Core_width+$d_clear, $Core_width+$d_TIM, 0mm), x_size=$w_wire, y_size=$h_wire)
  S_1 [coppe_real] = rectangle(corner=($Core_width+$d_clear+$w_wire*1+$d_inter*1, $d_TIM+$Core_width, 0mm), x_size=$w_wire, y_size=$h_wire)
  N_2 [coppe_real] = rectangle(corner=($Core_width+$d_clear+$w_wire*2+$d_inter*2, $d_TIM+$Core_width, 0mm), x_size=$w_wire, y_size=$h_wire)
  S_2 [coppe_real] = rectangle(corner=($Core_width+$d_clear+$w_wire*3+$d_inter*3, $d_TIM+$Core_width, 0mm), x_size=$w_wire, y_size=$h_wire)
  Rectangle1.subtract(air_gap)
  Rectangle1.subtract(Rectangle3)
  Rectangle4_1 = Rectangle4.copy()
  Rectangle5_1 = Rectangle5.copy()
  Rectangle1.subtract(Rectangle4_1, Rectangle5_1)
  Region [air] = region(percentage_offset: +X=50, -X=0, +Y=50, -Y=50, +Z=0, -Z=0)
  Rectangle6 [air] = rectangle(corner=(0mm, 0mm, 0mm), x_size=$l_TIM+2*$Core_width, y_size=$Core_Height*2+$l_g)
boundaries and excitations:
  Symmetry1: Symmetry Edges=Region.edge(at (0, 20.05, 0)) IsOdd=false
  Balloon1: Balloon Edges=Region.edge(at (23.25, 60.15, 0), at (46.5, 20.05, 0), at (23.25, -20.05, 0)) IsOfTypeVoltage=false
  Primary: Voltage Objects=[N_1, N_2] Value=1000V
  Secondary: Voltage Objects=[S_1, S_2] Value=0V
mesh:
  EdgeCut1: EdgeCutLayerMesh Objects=Rectangle6 Layer_Thickenss=0.05mm
  EdgeCut2: EdgeCutLayerMesh Objects=[N_1, N_2, S_1, S_2] Layer_Thickenss=0.05mm
  EdgeCut3: EdgeCutLayerMesh Objects=[Rectangle4, Rectangle5] Layer_Thickenss=0.05mm
  EdgeCut4: EdgeCutLayerMesh Objects=Rectangle1 Layer_Thickenss=0.05mm
setups:
  Setup1: Electrostatic MaximumPasses=20 MinimumPasses=10 MinimumConvergedPasses=1 PercentRefinement=70 PercentError=0.5 NonLinearResidual=0.001
field plots:
  Mag_E1: E over Rectangle6 on Setup1 : LastAdaptive
  Mag_E2: E over Rectangle4, Rectangle5 on Setup1 : LastAdaptive

design 10kW_1.0mm (Maxwell 2D, Electrostatic, XY geometry, model units mm)
geometry:
  Rectangle1 [ferrite - real2] = rectangle(corner=(0mm, 0mm, 0mm), x_size=2*$Core_width+$l_TIM, y_size=2*$Core_Height+$l_g)
  Rectangle2 = rectangle(corner=($Core_width, $Core_width+$d_TIM, 0mm), x_size=$l_TIM, y_size=$h_wire)
  air_gap = rectangle(corner=(0mm, $Core_Height, 0mm), x_size=$Core_width, y_size=$l_g)
  Rectangle3 = rectangle(corner=($Core_width+$l_TIM, $Core_Height, 0mm), x_size=$Core_width, y_size=$l_g)
  Rectangle4 [silicon_TIMreal] = rectangle(corner=($Core_width, $Core_width, 0mm), x_size=$l_TIM, y_size=$d_TIM)
  Rectangle1.subtract(Rectangle2)
  Rectangle5 [silicon_TIMreal] = rectangle(corner=($Core_width, $Core_width+$d_TIM+$h_wire, 0mm), x_size=$l_TIM, y_size=$d_TIM)
  N_1 [coppe_real] = rectangle(corner=($Core_width+$d_clear, $Core_width+$d_TIM, 0mm), x_size=$w_wire, y_size=$h_wire)
  S_1 [coppe_real] = rectangle(corner=($Core_width+$d_clear+$w_wire*1+$d_inter*1, $d_TIM+$Core_width, 0mm), x_size=$w_wire, y_size=$h_wire)
  N_2 [coppe_real] = rectangle(corner=($Core_width+$d_clear+$w_wire*2+$d_inter*2, $d_TIM+$Core_width, 0mm), x_size=$w_wire, y_size=$h_wire)
  S_2 [coppe_real] = rectangle(corner=($Core_width+$d_clear+$w_wire*3+$d_inter*3, $d_TIM+$Core_width, 0mm), x_size=$w_wire, y_size=$h_wire)
  Rectangle1.subtract(air_gap)
  Rectangle1.subtract(Rectangle3)
  Rectangle4_1 = Rectangle4.copy()
  Rectangle5_1 = Rectangle5.copy()
  Rectangle1.subtract(Rectangle4_1, Rectangle5_1)
  Region [air] = region(percentage_offset: +X=50, -X=0, +Y=50, -Y=50, +Z=0, -Z=0)
  Rectangle6 [air] = rectangle(corner=(0mm, 0mm, 0mm), x_size=$l_TIM+2*$Core_width, y_size=$Core_Height*2+$l_g)
boundaries and excitations:
  Symmetry1: Symmetry Edges=Region.edge(at (0, 20.05, 0)) IsOdd=false
  Balloon1: Balloon Edges=Region.edge(at (23.25, 60.15, 0), at (46.5, 20.05, 0), at (23.25, -20.05, 0)) IsOfTypeVoltage=false
  Primary: Voltage Objects=[N_1, N_2] Value=1000V
  Secondary: Voltage Objects=[S_1, S_2] Value=0V
mesh:
  EdgeCut1: EdgeCutLayerMesh Objects=Rectangle6 Layer_Thickenss=0.05mm
  EdgeCut2: EdgeCutLayerMesh Objects=[N_1, N_2, S_1, S_2] Layer_Thickenss=0.05mm
  EdgeCut3: EdgeCutLayerMesh Objects=[Rectangle4, Rectangle5] Layer_Thickenss=0.05mm
  EdgeCut4: EdgeCutLayerMesh Objects=Rectangle1 Layer_Thickenss=0.05mm
setups:
  Setup1: Electrostatic MaximumPasses=20 MinimumPasses=10 MinimumConvergedPasses=1 PercentRefinement=70 PercentError=0.5 NonLinearResidual=0.001
field plots:
  Mag_E1: E over Rectangle6 on Setup1 : LastAdaptive
  Mag_E2: E over Rectangle4, Rectangle5 on Setup1 : LastAdaptive
