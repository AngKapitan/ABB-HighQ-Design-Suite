# Ansys Electronics Desktop project, version 2025.1
materials:
  FR4_epoxy: permittivity=4.4 dielectric_loss_tangent=0.02 thermal_conductivity=0.294 mass_density=1900 specific_heat=1150 youngs_modulus=11000000000 poissons_ratio=0.28 thermal_expansion_coefficient=1.5e-05
  aluminum: permeability=1.000021 conductivity=38000000 thermal_conductivity=237.5 mass_density=2689 specific_heat=951 youngs_modulus=69000000000 poissons_ratio=0.31 thermal_expansion_coefficient=2.33e-05
  copper: permeability=0.999991 conductivity=58000000 thermal_conductivity=400 mass_density=8933 specific_heat=385 youngs_modulus=120000000000 poissons_ratio=0.38 thermal_expansion_coefficient=1.77e-05
  ferrite: permittivity=12 permeability=2000 conductivity=0.01 thermal_conductivity=4 mass_density=4600 specific_heat=750 youngs_modulus=119000000000 thermal_expansion_coefficient=1e-05
  vacuum: permittivity=1
  Al-Extruded: thermal_conductivity=205 mass_density=2800 specific_heat=900 youngs_modulus=69000000000 poissons_ratio=0.33 thermal_expansion_coefficient=2.277e-06 thermal_material_type=Solid
  air: permittivity=1.0006 permeability=1.0000004 thermal_conductivity=0.0261 mass_density=1.1614 specific_heat=1005 thermal_expansion_coefficient=0.00333 thermal_material_type=Fluid diffusivity=2.88e-05 molecular_mass=0.028966 viscosity=1.84e-05 material_refractive_index=1.000293
  Material1: thermal_conductivity=170 mass_density=3260 specific_heat=740 thermal_expansion_coefficient=4.5e-06
surface materials:
  Steel-oxidised-surface: surface_emissivity=0.8

design 0.20_edgewise_3D (Maxwell 3D, EddyCurrent, model units mm)
geometry:
  Region [vacuum] = region(percentage_offset=0 on all sides)
  Np1, Np10, Np11, Np12, Np2..Np9, Ns1, Ns10, Ns11, Ns12, Ns2..Ns9 [copper] = imported_body(C:\Users\karlr\Documents\0.2_edgewise.step)
  plate_1, plate_2 [FR4_epoxy] = imported_body(C:\Users\karlr\Documents\0.2_edgewise.step)
  Body1 [ferrite] = imported_body(C:\Users\karlr\Documents\0.2_edgewise.step)
  Body1_1, Body1_2 [aluminum] = imported_body(C:\Users\karlr\Documents\0.2_edgewise.step)
  Body1_3 [ferrite] = imported_body(C:\Users\karlr\Documents\0.2_edgewise.step)
  Body1_4, Body1_5 [aluminum] = imported_body(C:\Users\karlr\Documents\0.2_edgewise.step)
  Np1_Section1 [copper] = Np1.section(plane=ZX)
  Np2_Section1 [copper] = Np2.section(plane=ZX)
  Np3_Section1 [copper] = Np3.section(plane=ZX)
  Np4_Section1 [copper] = Np4.section(plane=ZX)
  Np5_Section1 [copper] = Np5.section(plane=ZX)
  Np6_Section1 [copper] = Np6.section(plane=ZX)
  Np7_Section1 [copper] = Np7.section(plane=ZX)
  Np8_Section1 [copper] = Np8.section(plane=ZX)
  Np9_Section1 [copper] = Np9.section(plane=ZX)
  Np10_Section1 [copper] = Np10.section(plane=ZX)
  Np11_Section1 [copper] = Np11.section(plane=ZX)
  Np12_Section1 [copper] = Np12.section(plane=ZX)
  Ns1_Section1 [copper] = Ns1.section(plane=ZX)
  Ns2_Section1 [copper] = Ns2.section(plane=ZX)
  Ns3_Section1 [copper] = Ns3.section(plane=ZX)
  Ns4_Section1 [copper] = Ns4.section(plane=ZX)
  Ns5_Section1 [copper] = Ns5.section(plane=ZX)
  Ns6_Section1 [copper] = Ns6.section(plane=ZX)
  Ns7_Section1 [copper] = Ns7.section(plane=ZX)
  Ns8_Section1 [copper] = Ns8.section(plane=ZX)
  Ns9_Section1 [copper] = Ns9.section(plane=ZX)
  Ns10_Section1 [copper] = Ns10.section(plane=ZX)
  Ns11_Section1 [copper] = Ns11.section(plane=ZX)
  Ns12_Section1 [copper] = Ns12.section(plane=ZX)
  Np1_Section1.separate_bodies()
  Np2_Section1.separate_bodies()
  Np3_Section1.separate_bodies()
  Np4_Section1.separate_bodies()
  Np5_Section1.separate_bodies()
  Np6_Section1.separate_bodies()
  Np7_Section1.separate_bodies()
  Np8_Section1.separate_bodies()
  Np9_Section1.separate_bodies()
  Np10_Section1.separate_bodies()
  Np11_Section1.separate_bodies()
  Np12_Section1.separate_bodies()
  Ns1_Section1.separate_bodies()
  Ns2_Section1.separate_bodies()
  Ns3_Section1.separate_bodies()
  Ns4_Section1.separate_bodies()
  Ns5_Section1.separate_bodies()
  Ns6_Section1.separate_bodies()
  Ns7_Section1.separate_bodies()
  Ns8_Section1.separate_bodies()
  Ns9_Section1.separate_bodies()
  Ns10_Section1.separate_bodies()
  Ns11_Section1.separate_bodies()
  Ns12_Section1.separate_bodies()
  group core_assembled_edgewise = Np1, Np10, Np11, Np12, Np2..Np9, Ns1, Ns10, Ns11, Ns12, Ns2..Ns9, plate_1, plate_2, Np1_Section1, Np2_Section1, Np3_Section1, Np4_Section1, Np5_Section1, Np6_Section1, Np7_Section1, Np8_Section1, Np9_Section1, Np10_Section1, Np11_Section1, Np12_Section1, Ns1_Section1, Ns2_Section1, Ns3_Section1, Ns4_Section1, Ns5_Section1, Ns6_Section1, Ns7_Section1, Ns8_Section1, Ns9_Section1, Ns10_Section1, Ns11_Section1, Ns12_Section1
  group core_together_1 = Body1, Body1_1, Body1_2
  group core_together = Body1_3, Body1_4, Body1_5
boundaries and excitations:
  Np_1: Coil Terminal Objects=Np1_Section1 Conductor_number=1 Winding=Primary Point_out_of_terminal=false
  Np_2: Coil Terminal Objects=Np2_Section1 Conductor_number=1 Winding=Primary Point_out_of_terminal=false
  Np_3: Coil Terminal Objects=Np3_Section1 Conductor_number=1 Winding=Primary Point_out_of_terminal=false
  Np_4: Coil Terminal Objects=Np4_Section1 Conductor_number=1 Winding=Primary Point_out_of_terminal=false
  Np_5: Coil Terminal Objects=Np5_Section1 Conductor_number=1 Winding=Primary Point_out_of_terminal=false
  Np_6: Coil Terminal Objects=Np6_Section1 Conductor_number=1 Winding=Primary Point_out_of_terminal=false
  Np_7: Coil Terminal Objects=Np7_Section1 Conductor_number=1 Winding=Primary Point_out_of_terminal=false
  Np_8: Coil Terminal Objects=Np8_Section1 Conductor_number=1 Winding=Primary Point_out_of_terminal=false
  Np_9: Coil Terminal Objects=Np9_Section1 Conductor_number=1 Winding=Primary Point_out_of_terminal=false
  Np_10: Coil Terminal Objects=Np10_Section1 Conductor_number=1 Winding=Primary Point_out_of_terminal=false
  Np_11: Coil Terminal Objects=Np11_Section1 Conductor_number=1 Winding=Primary Point_out_of_terminal=false
  Np_12: Coil Terminal Objects=Np12_Section1 Conductor_number=1 Winding=Primary Point_out_of_terminal=false
  Ns_1: Coil Terminal Objects=Ns1_Section1 Conductor_number=1 Winding=Secondary Point_out_of_terminal=true
  Ns_2: Coil Terminal Objects=Ns2_Section1 Conductor_number=1 Winding=Secondary Point_out_of_terminal=true
  Ns_3: Coil Terminal Objects=Ns3_Section1 Conductor_number=1 Winding=Secondary Point_out_of_terminal=true
  Ns_4: Coil Terminal Objects=Ns4_Section1 Conductor_number=1 Winding=Secondary Point_out_of_terminal=true
  Ns_5: Coil Terminal Objects=Ns5_Section1 Conductor_number=1 Winding=Secondary Point_out_of_terminal=true
  Ns_6: Coil Terminal Objects=Ns6_Section1 Conductor_number=1 Winding=Secondary Point_out_of_terminal=true
  Ns_7: Coil Terminal Objects=Ns7_Section1 Conductor_number=1 Winding=Secondary Point_out_of_terminal=true
  Ns_8: Coil Terminal Objects=Ns8_Section1 Conductor_number=1 Winding=Secondary Point_out_of_terminal=true
  Ns_9: Coil Terminal Objects=Ns9_Section1 Conductor_number=1 Winding=Secondary Point_out_of_terminal=true
  Ns_10: Coil Terminal Objects=Ns10_Section1 Conductor_number=1 Winding=Secondary Point_out_of_terminal=true
  Ns_11: Coil Terminal Objects=Ns11_Section1 Conductor_number=1 Winding=Secondary Point_out_of_terminal=true
  Ns_12: Coil Terminal Objects=Ns12_Section1 Conductor_number=1 Winding=Secondary Point_out_of_terminal=true
  Primary: Winding Group Type=Current IsSolid=true Current=14.14A ParallelBranchesNum=1 Phase=0deg
  Secondary: Winding Group Type=Current IsSolid=true Current=14.14A ParallelBranchesNum=1 Phase=0deg
parameters:
  Matrix1: Matrix Primary, Secondary:
mesh:
  Length1: LengthBased Objects=[Np1..Np12, Ns1..Ns12, plate_1, plate_2] MaxLength=3mm
  Length2: LengthBased Objects=[Body1_1, Body1_2, Body1, Body1_3, Body1_5, Body1_4] MaxLength=3mm
  initial mesh: GlobalCurvilinear{Apply} MeshMethod=AnsoftClassic
setups:
  Setup1: EddyCurrent MaximumPasses=15 MinimumPasses=2 MinimumConvergedPasses=1 PercentRefinement=30 PercentError=3 NonLinearResidual=0.0001 Frequency=30000Hz LossAdaptiveCtrl=0.5

design 0.25_edgewise_3D (Maxwell 3D, EddyCurrent, model units mm)
geometry:
  Region [vacuum] = region(percentage_offset=0 on all sides)
  plate_1, plate_2 [FR4_epoxy] = imported_body(C:\Users\karlr\Documents\0.25_edgewise.step)
  Np1, Np10, Np11, Np12, Np2..Np9, Ns1, Ns10, Ns11, Ns12, Ns2..Ns9 [copper] = imported_body(C:\Users\karlr\Documents\0.25_edgewise.step)
  Body1 [ferrite] = imported_body(C:\Users\karlr\Documents\0.25_edgewise.step)
  Body1_1, Body1_2 [aluminum] = imported_body(C:\Users\karlr\Documents\0.25_edgewise.step)
  Body1_3 [ferrite] = imported_body(C:\Users\karlr\Documents\0.25_edgewise.step)
  Body1_4, Body1_5 [aluminum] = imported_body(C:\Users\karlr\Documents\0.25_edgewise.step)
  Np1_Section1 [copper] = Np1.section(plane=ZX)
  Np2_Section1 [copper] = Np2.section(plane=ZX)
  Np3_Section1 [copper] = Np3.section(plane=ZX)
  Np4_Section1 [copper] = Np4.section(plane=ZX)
  Np5_Section1 [copper] = Np5.section(plane=ZX)
  Np6_Section1 [copper] = Np6.section(plane=ZX)
  Np7_Section1 [copper] = Np7.section(plane=ZX)
  Np8_Section1 [copper] = Np8.section(plane=ZX)
  Np9_Section1 [copper] = Np9.section(plane=ZX)
  Np10_Section1 [copper] = Np10.section(plane=ZX)
  Np11_Section1 [copper] = Np11.section(plane=ZX)
  Np12_Section1 [copper] = Np12.section(plane=ZX)
  Ns1_Section1 [copper] = Ns1.section(plane=ZX)
  Ns2_Section1 [copper] = Ns2.section(plane=ZX)
  Ns3_Section1 [copper] = Ns3.section(plane=ZX)
  Ns4_Section1 [copper] = Ns4.section(plane=ZX)
  Ns5_Section1 [copper] = Ns5.section(plane=ZX)
  Ns6_Section1 [copper] = Ns6.section(plane=ZX)
  Ns7_Section1 [copper] = Ns7.section(plane=ZX)
  Ns8_Section1 [copper] = Ns8.section(plane=ZX)
  Ns9_Section1 [copper] = Ns9.section(plane=ZX)
  Ns10_Section1 [copper] = Ns10.section(plane=ZX)
  Ns11_Section1 [copper] = Ns11.section(plane=ZX)
  Ns12_Section1 [copper] = Ns12.section(plane=ZX)
  Np1_Section1.separate_bodies()
  Np2_Section1.separate_bodies()
  Np3_Section1.separate_bodies()
  Np4_Section1.separate_bodies()
  Np5_Section1.separate_bodies()
  Np6_Section1.separate_bodies()
  Np7_Section1.separate_bodies()
  Np8_Section1.separate_bodies()
  Np9_Section1.separate_bodies()
  Np10_Section1.separate_bodies()
  Np11_Section1.separate_bodies()
  Np12_Section1.separate_bodies()
  Ns1_Section1.separate_bodies()
  Ns2_Section1.separate_bodies()
  Ns3_Section1.separate_bodies()
  Ns4_Section1.separate_bodies()
  Ns5_Section1.separate_bodies()
  Ns6_Section1.separate_bodies()
  Ns7_Section1.separate_bodies()
  Ns8_Section1.separate_bodies()
  Ns9_Section1.separate_bodies()
  Ns10_Section1.separate_bodies()
  Ns11_Section1.separate_bodies()
  Ns12_Section1.separate_bodies()
  group core_assembled_edgewise = plate_1, plate_2, Np1, Np10, Np11, Np12, Np2..Np9, Ns1, Ns10, Ns11, Ns12, Ns2..Ns9, Np1_Section1, Np2_Section1, Np3_Section1, Np4_Section1, Np5_Section1, Np6_Section1, Np7_Section1, Np8_Section1, Np9_Section1, Np10_Section1, Np11_Section1, Np12_Section1, Ns1_Section1, Ns2_Section1, Ns3_Section1, Ns4_Section1, Ns5_Section1, Ns6_Section1, Ns7_Section1, Ns8_Section1, Ns9_Section1, Ns10_Section1, Ns11_Section1, Ns12_Section1
  group core_together_1 = Body1, Body1_1, Body1_2
  group core_together = Body1_3, Body1_4, Body1_5
boundaries and excitations:
  Np_1: Coil Terminal Objects=Np1_Section1 Conductor_number=1 Winding=Primary Point_out_of_terminal=false
  Np_2: Coil Terminal Objects=Np2_Section1 Conductor_number=1 Winding=Primary Point_out_of_terminal=false
  Np_3: Coil Terminal Objects=Np3_Section1 Conductor_number=1 Winding=Primary Point_out_of_terminal=false
  Np_4: Coil Terminal Objects=Np4_Section1 Conductor_number=1 Winding=Primary Point_out_of_terminal=false
  Np_5: Coil Terminal Objects=Np5_Section1 Conductor_number=1 Winding=Primary Point_out_of_terminal=false
  Np_6: Coil Terminal Objects=Np6_Section1 Conductor_number=1 Winding=Primary Point_out_of_terminal=false
  Np_7: Coil Terminal Objects=Np7_Section1 Conductor_number=1 Winding=Primary Point_out_of_terminal=false
  Np_8: Coil Terminal Objects=Np8_Section1 Conductor_number=1 Winding=Primary Point_out_of_terminal=false
  Np_9: Coil Terminal Objects=Np9_Section1 Conductor_number=1 Winding=Primary Point_out_of_terminal=false
  Np_10: Coil Terminal Objects=Np10_Section1 Conductor_number=1 Winding=Primary Point_out_of_terminal=false
  Np_11: Coil Terminal Objects=Np11_Section1 Conductor_number=1 Winding=Primary Point_out_of_terminal=false
  Np_12: Coil Terminal Objects=Np12_Section1 Conductor_number=1 Winding=Primary Point_out_of_terminal=false
  Ns_1: Coil Terminal Objects=Ns1_Section1 Conductor_number=1 Winding=Secondary Point_out_of_terminal=true
  Ns_2: Coil Terminal Objects=Ns2_Section1 Conductor_number=1 Winding=Secondary Point_out_of_terminal=true
  Ns_3: Coil Terminal Objects=Ns3_Section1 Conductor_number=1 Winding=Secondary Point_out_of_terminal=true
  Ns_4: Coil Terminal Objects=Ns4_Section1 Conductor_number=1 Winding=Secondary Point_out_of_terminal=true
  Ns_5: Coil Terminal Objects=Ns5_Section1 Conductor_number=1 Winding=Secondary Point_out_of_terminal=true
  Ns_6: Coil Terminal Objects=Ns6_Section1 Conductor_number=1 Winding=Secondary Point_out_of_terminal=true
  Ns_7: Coil Terminal Objects=Ns7_Section1 Conductor_number=1 Winding=Secondary Point_out_of_terminal=true
  Ns_8: Coil Terminal Objects=Ns8_Section1 Conductor_number=1 Winding=Secondary Point_out_of_terminal=true
  Ns_9: Coil Terminal Objects=Ns9_Section1 Conductor_number=1 Winding=Secondary Point_out_of_terminal=true
  Ns_10: Coil Terminal Objects=Ns10_Section1 Conductor_number=1 Winding=Secondary Point_out_of_terminal=true
  Ns_11: Coil Terminal Objects=Ns11_Section1 Conductor_number=1 Winding=Secondary Point_out_of_terminal=true
  Ns_12: Coil Terminal Objects=Ns12_Section1 Conductor_number=1 Winding=Secondary Point_out_of_terminal=true
  Primary: Winding Group Type=Current IsSolid=true Current=14.14A ParallelBranchesNum=1 Phase=0deg
  Secondary: Winding Group Type=Current IsSolid=true Current=14.14A ParallelBranchesNum=1 Phase=0deg
parameters:
  Matrix1: Matrix Primary, Secondary:
mesh:
  Length1: LengthBased Objects=[Np1..Np12, Ns1..Ns12, plate_1, plate_2] MaxLength=3mm
  Length2: LengthBased Objects=[Body1_4, Body1_5, Body1_3, Body1_1, Body1_2, Body1] MaxLength=3mm
  initial mesh: GlobalCurvilinear{Apply} MeshMethod=AnsoftClassic
setups:
  Setup1: EddyCurrent MaximumPasses=15 MinimumPasses=2 MinimumConvergedPasses=1 PercentRefinement=30 PercentError=3 NonLinearResidual=0.0001 Frequency=30000Hz LossAdaptiveCtrl=0.5

design 0.30_edgewise_3D (Maxwell 3D, EddyCurrent, model units mm)
geometry:
  Region [vacuum] = region(percentage_offset=0 on all sides)
  plate_1, plate_2 [FR4_epoxy] = imported_body(C:\Users\karlr\Documents\0.3_edgewise.step)
  Np1, Np10, Np11, Np12, Np2..Np9, Ns1, Ns10, Ns11, Ns12, Ns2..Ns9 [copper] = imported_body(C:\Users\karlr\Documents\0.3_edgewise.step)
  Body1 [ferrite] = imported_body(C:\Users\karlr\Documents\0.3_edgewise.step)
  Body1_1, Body1_2 [aluminum] = imported_body(C:\Users\karlr\Documents\0.3_edgewise.step)
  Body1_3 [ferrite] = imported_body(C:\Users\karlr\Documents\0.3_edgewise.step)
  Body1_4, Body1_5 [aluminum] = imported_body(C:\Users\karlr\Documents\0.3_edgewise.step)
  Np1_Section1 [copper] = Np1.section(plane=ZX)
  Np2_Section1 [copper] = Np2.section(plane=ZX)
  Np3_Section1 [copper] = Np3.section(plane=ZX)
  Np4_Section1 [copper] = Np4.section(plane=ZX)
  Np5_Section1 [copper] = Np5.section(plane=ZX)
  Np6_Section1 [copper] = Np6.section(plane=ZX)
  Np7_Section1 [copper] = Np7.section(plane=ZX)
  Np8_Section1 [copper] = Np8.section(plane=ZX)
  Np9_Section1 [copper] = Np9.section(plane=ZX)
  Np10_Section1 [copper] = Np10.section(plane=ZX)
  Np11_Section1 [copper] = Np11.section(plane=ZX)
  Np12_Section1 [copper] = Np12.section(plane=ZX)
  Ns1_Section1 [copper] = Ns1.section(plane=ZX)
  Ns2_Section1 [copper] = Ns2.section(plane=ZX)
  Ns3_Section1 [copper] = Ns3.section(plane=ZX)
  Ns4_Section1 [copper] = Ns4.section(plane=ZX)
  Ns5_Section1 [copper] = Ns5.section(plane=ZX)
  Ns6_Section1 [copper] = Ns6.section(plane=ZX)
  Ns7_Section1 [copper] = Ns7.section(plane=ZX)
  Ns8_Section1 [copper] = Ns8.section(plane=ZX)
  Ns9_Section1 [copper] = Ns9.section(plane=ZX)
  Ns10_Section1 [copper] = Ns10.section(plane=ZX)
  Ns11_Section1 [copper] = Ns11.section(plane=ZX)
  Ns12_Section1 [copper] = Ns12.section(plane=ZX)
  Np1_Section1.separate_bodies()
  Np2_Section1.separate_bodies()
  Np3_Section1.separate_bodies()
  Np4_Section1.separate_bodies()
  Np5_Section1.separate_bodies()
  Np6_Section1.separate_bodies()
  Np7_Section1.separate_bodies()
  Np8_Section1.separate_bodies()
  Np9_Section1.separate_bodies()
  Np10_Section1.separate_bodies()
  Np11_Section1.separate_bodies()
  Np12_Section1.separate_bodies()
  Ns1_Section1.separate_bodies()
  Ns2_Section1.separate_bodies()
  Ns3_Section1.separate_bodies()
  Ns4_Section1.separate_bodies()
  Ns5_Section1.separate_bodies()
  Ns6_Section1.separate_bodies()
  Ns7_Section1.separate_bodies()
  Ns8_Section1.separate_bodies()
  Ns9_Section1.separate_bodies()
  Ns10_Section1.separate_bodies()
  Ns11_Section1.separate_bodies()
  Ns12_Section1.separate_bodies()
  Rectangle1 [non-model] = rectangle(corner=(39.8mm, 7.09649239mm, 0mm), z_size=20mm, x_size=-39.8mm)
  Rectangle2 [non-model] = rectangle(corner=(5.2mm, 23.89298478mm, 10.05mm), x_size=29.8mm, y_size=-33.89298478mm)
  group core_assembled_edgewise = plate_1, plate_2, Np1, Np10, Np11, Np12, Np2..Np9, Ns1, Ns10, Ns11, Ns12, Ns2..Ns9, Np1_Section1, Np2_Section1, Np3_Section1, Np4_Section1, Np5_Section1, Np6_Section1, Np7_Section1, Np8_Section1, Np9_Section1, Np10_Section1, Np11_Section1, Np12_Section1, Ns1_Section1, Ns2_Section1, Ns3_Section1, Ns4_Section1, Ns5_Section1, Ns6_Section1, Ns7_Section1, Ns8_Section1, Ns9_Section1, Ns10_Section1, Ns11_Section1, Ns12_Section1
  group core_together_1 = Body1, Body1_1, Body1_2
  group core_together = Body1_3, Body1_4, Body1_5
boundaries and excitations:
  Np_1: Coil Terminal Objects=Np1_Section1 Conductor_number=1 Winding=Primary Point_out_of_terminal=false
  Np_2: Coil Terminal Objects=Np2_Section1 Conductor_number=1 Winding=Primary Point_out_of_terminal=false
  Np_3: Coil Terminal Objects=Np3_Section1 Conductor_number=1 Winding=Primary Point_out_of_terminal=false
  Np_4: Coil Terminal Objects=Np4_Section1 Conductor_number=1 Winding=Primary Point_out_of_terminal=false
  Np_5: Coil Terminal Objects=Np5_Section1 Conductor_number=1 Winding=Primary Point_out_of_terminal=false
  Np_6: Coil Terminal Objects=Np6_Section1 Conductor_number=1 Winding=Primary Point_out_of_terminal=false
  Np_7: Coil Terminal Objects=Np7_Section1 Conductor_number=1 Winding=Primary Point_out_of_terminal=false
  Np_8: Coil Terminal Objects=Np8_Section1 Conductor_number=1 Winding=Primary Point_out_of_terminal=false
  Np_9: Coil Terminal Objects=Np9_Section1 Conductor_number=1 Winding=Primary Point_out_of_terminal=false
  Np_10: Coil Terminal Objects=Np10_Section1 Conductor_number=1 Winding=Primary Point_out_of_terminal=false
  Np_11: Coil Terminal Objects=Np11_Section1 Conductor_number=1 Winding=Primary Point_out_of_terminal=false
  Np_12: Coil Terminal Objects=Np12_Section1 Conductor_number=1 Winding=Primary Point_out_of_terminal=false
  Ns_1: Coil Terminal Objects=Ns1_Section1 Conductor_number=1 Winding=Secondary Point_out_of_terminal=true
  Ns_2: Coil Terminal Objects=Ns2_Section1 Conductor_number=1 Winding=Secondary Point_out_of_terminal=true
  Ns_3: Coil Terminal Objects=Ns3_Section1 Conductor_number=1 Winding=Secondary Point_out_of_terminal=true
  Ns_4: Coil Terminal Objects=Ns4_Section1 Conductor_number=1 Winding=Secondary Point_out_of_terminal=true
  Ns_5: Coil Terminal Objects=Ns5_Section1 Conductor_number=1 Winding=Secondary Point_out_of_terminal=true
  Ns_6: Coil Terminal Objects=Ns6_Section1 Conductor_number=1 Winding=Secondary Point_out_of_terminal=true
  Ns_7: Coil Terminal Objects=Ns7_Section1 Conductor_number=1 Winding=Secondary Point_out_of_terminal=true
  Ns_8: Coil Terminal Objects=Ns8_Section1 Conductor_number=1 Winding=Secondary Point_out_of_terminal=true
  Ns_9: Coil Terminal Objects=Ns9_Section1 Conductor_number=1 Winding=Secondary Point_out_of_terminal=true
  Ns_10: Coil Terminal Objects=Ns10_Section1 Conductor_number=1 Winding=Secondary Point_out_of_terminal=true
  Ns_11: Coil Terminal Objects=Ns11_Section1 Conductor_number=1 Winding=Secondary Point_out_of_terminal=true
  Ns_12: Coil Terminal Objects=Ns12_Section1 Conductor_number=1 Winding=Secondary Point_out_of_terminal=true
  Primary: Winding Group Type=Current IsSolid=true Current=14.14A ParallelBranchesNum=1 Phase=0deg
  Secondary: Winding Group Type=Current IsSolid=true Current=14.14A ParallelBranchesNum=1 Phase=0deg
parameters:
  Matrix1: Matrix Primary, Secondary:
mesh:
  Length1: LengthBased Objects=[Np1..Np12, Ns1..Ns12, plate_1, plate_2] MaxLength=3mm
  Length2: LengthBased Objects=[Body1_4, Body1_5, Body1_3, Body1_1, Body1_2, Body1] MaxLength=3mm
  initial mesh: GlobalSurfApproximation{CurvedSurfaceApproxChoice=UseSlider SliderMeshSettings=9} GlobalCurvilinear{Apply} MeshMethod=AnsoftClassic
setups:
  Setup1: EddyCurrent MaximumPasses=15 MinimumPasses=2 MinimumConvergedPasses=1 PercentRefinement=30 PercentError=3 NonLinearResidual=0.0001 Frequency=30000Hz LossAdaptiveCtrl=0.5
field plots:
  Mag_J1: J over a plane on Setup1 : LastAdaptive at Freq=30000Hz Phase=20deg
  Mag_J2: J over a plane on Setup1 : LastAdaptive at Freq=30000Hz Phase=0deg

design 0.35_edgewise_3D (Maxwell 3D, EddyCurrent, model units mm)
geometry:
  Region [vacuum] = region(percentage_offset=0 on all sides)
  plate_1, plate_2 [FR4_epoxy] = imported_body(C:\Users\karlr\Documents\0.35_edgewise.step)
  Np1, Np10, Np11, Np12, Np2..Np9, Ns1, Ns10, Ns11, Ns12, Ns2..Ns9 [copper] = imported_body(C:\Users\karlr\Documents\0.35_edgewise.step)
  Body1 [ferrite] = imported_body(C:\Users\karlr\Documents\0.35_edgewise.step)
  Body1_1, Body1_2 [aluminum] = imported_body(C:\Users\karlr\Documents\0.35_edgewise.step)
  Body1_3 [ferrite] = imported_body(C:\Users\karlr\Documents\0.35_edgewise.step)
  Body1_4, Body1_5 [aluminum] = imported_body(C:\Users\karlr\Documents\0.35_edgewise.step)
  Np1_Section1 [copper] = Np1.section(plane=ZX)
  Np2_Section1 [copper] = Np2.section(plane=ZX)
  Np3_Section1 [copper] = Np3.section(plane=ZX)
  Np4_Section1 [copper] = Np4.section(plane=ZX)
  Np5_Section1 [copper] = Np5.section(plane=ZX)
  Np6_Section1 [copper] = Np6.section(plane=ZX)
  Np7_Section1 [copper] = Np7.section(plane=ZX)
  Np8_Section1 [copper] = Np8.section(plane=ZX)
  Np9_Section1 [copper] = Np9.section(plane=ZX)
  Np10_Section1 [copper] = Np10.section(plane=ZX)
  Np11_Section1 [copper] = Np11.section(plane=ZX)
  Np12_Section1 [copper] = Np12.section(plane=ZX)
  Ns1_Section1 [copper] = Ns1.section(plane=ZX)
  Ns2_Section1 [copper] = Ns2.section(plane=ZX)
  Ns3_Section1 [copper] = Ns3.section(plane=ZX)
  Ns4_Section1 [copper] = Ns4.section(plane=ZX)
  Ns5_Section1 [copper] = Ns5.section(plane=ZX)
  Ns6_Section1 [copper] = Ns6.section(plane=ZX)
  Ns7_Section1 [copper] = Ns7.section(plane=ZX)
  Ns8_Section1 [copper] = Ns8.section(plane=ZX)
  Ns9_Section1 [copper] = Ns9.section(plane=ZX)
  Ns10_Section1 [copper] = Ns10.section(plane=ZX)
  Ns11_Section1 [copper] = Ns11.section(plane=ZX)
  Ns12_Section1 [copper] = Ns12.section(plane=ZX)
  Np1_Section1.separate_bodies()
  Np2_Section1.separate_bodies()
  Np3_Section1.separate_bodies()
  Np4_Section1.separate_bodies()
  Np5_Section1.separate_bodies()
  Np6_Section1.separate_bodies()
  Np7_Section1.separate_bodies()
  Np8_Section1.separate_bodies()
  Np9_Section1.separate_bodies()
  Np10_Section1.separate_bodies()
  Np11_Section1.separate_bodies()
  Np12_Section1.separate_bodies()
  Ns1_Section1.separate_bodies()
  Ns2_Section1.separate_bodies()
  Ns3_Section1.separate_bodies()
  Ns4_Section1.separate_bodies()
  Ns5_Section1.separate_bodies()
  Ns6_Section1.separate_bodies()
  Ns7_Section1.separate_bodies()
  Ns8_Section1.separate_bodies()
  Ns9_Section1.separate_bodies()
  Ns10_Section1.separate_bodies()
  Ns11_Section1.separate_bodies()
  Ns12_Section1.separate_bodies()
  group core_assembled_edgewise = plate_1, plate_2, Np1, Np10, Np11, Np12, Np2..Np9, Ns1, Ns10, Ns11, Ns12, Ns2..Ns9, Np1_Section1, Np2_Section1, Np3_Section1, Np4_Section1, Np5_Section1, Np6_Section1, Np7_Section1, Np8_Section1, Np9_Section1, Np10_Section1, Np11_Section1, Np12_Section1, Ns1_Section1, Ns2_Section1, Ns3_Section1, Ns4_Section1, Ns5_Section1, Ns6_Section1, Ns7_Section1, Ns8_Section1, Ns9_Section1, Ns10_Section1, Ns11_Section1, Ns12_Section1
  group core_together_1 = Body1, Body1_1, Body1_2
  group core_together = Body1_3, Body1_4, Body1_5
boundaries and excitations:
  Np_1: Coil Terminal Objects=Np1_Section1 Conductor_number=1 Winding=Primary Point_out_of_terminal=false
  Np_2: Coil Terminal Objects=Np2_Section1 Conductor_number=1 Winding=Primary Point_out_of_terminal=false
  Np_3: Coil Terminal Objects=Np3_Section1 Conductor_number=1 Winding=Primary Point_out_of_terminal=false
  Np_4: Coil Terminal Objects=Np4_Section1 Conductor_number=1 Winding=Primary Point_out_of_terminal=false
  Np_5: Coil Terminal Objects=Np5_Section1 Conductor_number=1 Winding=Primary Point_out_of_terminal=false
  Np_6: Coil Terminal Objects=Np6_Section1 Conductor_number=1 Winding=Primary Point_out_of_terminal=false
  Np_7: Coil Terminal Objects=Np7_Section1 Conductor_number=1 Winding=Primary Point_out_of_terminal=false
  Np_8: Coil Terminal Objects=Np8_Section1 Conductor_number=1 Winding=Primary Point_out_of_terminal=false
  Np_9: Coil Terminal Objects=Np9_Section1 Conductor_number=1 Winding=Primary Point_out_of_terminal=false
  Np_10: Coil Terminal Objects=Np10_Section1 Conductor_number=1 Winding=Primary Point_out_of_terminal=false
  Np_11: Coil Terminal Objects=Np11_Section1 Conductor_number=1 Winding=Primary Point_out_of_terminal=false
  Np_12: Coil Terminal Objects=Np12_Section1 Conductor_number=1 Winding=Primary Point_out_of_terminal=false
  Ns_1: Coil Terminal Objects=Ns1_Section1 Conductor_number=1 Winding=Secondary Point_out_of_terminal=true
  Ns_2: Coil Terminal Objects=Ns2_Section1 Conductor_number=1 Winding=Secondary Point_out_of_terminal=true
  Ns_3: Coil Terminal Objects=Ns3_Section1 Conductor_number=1 Winding=Secondary Point_out_of_terminal=true
  Ns_4: Coil Terminal Objects=Ns4_Section1 Conductor_number=1 Winding=Secondary Point_out_of_terminal=true
  Ns_5: Coil Terminal Objects=Ns5_Section1 Conductor_number=1 Winding=Secondary Point_out_of_terminal=true
  Ns_6: Coil Terminal Objects=Ns6_Section1 Conductor_number=1 Winding=Secondary Point_out_of_terminal=true
  Ns_7: Coil Terminal Objects=Ns7_Section1 Conductor_number=1 Winding=Secondary Point_out_of_terminal=true
  Ns_8: Coil Terminal Objects=Ns8_Section1 Conductor_number=1 Winding=Secondary Point_out_of_terminal=true
  Ns_9: Coil Terminal Objects=Ns9_Section1 Conductor_number=1 Winding=Secondary Point_out_of_terminal=true
  Ns_10: Coil Terminal Objects=Ns10_Section1 Conductor_number=1 Winding=Secondary Point_out_of_terminal=true
  Ns_11: Coil Terminal Objects=Ns11_Section1 Conductor_number=1 Winding=Secondary Point_out_of_terminal=true
  Ns_12: Coil Terminal Objects=Ns12_Section1 Conductor_number=1 Winding=Secondary Point_out_of_terminal=true
  Primary: Winding Group Type=Current IsSolid=true Current=14.14A ParallelBranchesNum=1 Phase=0deg
  Secondary: Winding Group Type=Current IsSolid=true Current=14.14A ParallelBranchesNum=1 Phase=0deg
parameters:
  Matrix1: Matrix Primary, Secondary:
mesh:
  Length1: LengthBased Objects=[Np1..Np12, Ns1..Ns12, plate_1, plate_2] MaxLength=3mm
  Length2: LengthBased Objects=[Body1_4, Body1_5, Body1_3, Body1_1, Body1_2, Body1] MaxLength=3mm
  initial mesh: GlobalCurvilinear{Apply} MeshMethod=AnsoftClassic
setups:
  Setup1: EddyCurrent MaximumPasses=15 MinimumPasses=2 MinimumConvergedPasses=1 PercentRefinement=30 PercentError=3 NonLinearResidual=0.0001 Frequency=30000Hz LossAdaptiveCtrl=0.5

design 0.40_edgewise_3D (Maxwell 3D, EddyCurrent, model units mm)
geometry:
  Region [vacuum] = region(percentage_offset=0 on all sides)
  plate_1, plate_2 [FR4_epoxy] = imported_body(C:\Users\karlr\Documents\0.4_edgewise.step)
  Np1, Np10, Np11, Np12, Np2..Np9, Ns1, Ns10, Ns11, Ns12, Ns2..Ns9 [copper] = imported_body(C:\Users\karlr\Documents\0.4_edgewise.step)
  Body1 [ferrite] = imported_body(C:\Users\karlr\Documents\0.4_edgewise.step)
  Body1_1, Body1_2 [aluminum] = imported_body(C:\Users\karlr\Documents\0.4_edgewise.step)
  Body1_3 [ferrite] = imported_body(C:\Users\karlr\Documents\0.4_edgewise.step)
  Body1_4, Body1_5 [aluminum] = imported_body(C:\Users\karlr\Documents\0.4_edgewise.step)
  Ns12_Section1 [copper] = Ns12.section(plane=ZX)
  Np1_Section1 [copper] = Np1.section(plane=ZX)
  Np2_Section1 [copper] = Np2.section(plane=ZX)
  Np3_Section1 [copper] = Np3.section(plane=ZX)
  Np4_Section1 [copper] = Np4.section(plane=ZX)
  Np5_Section1 [copper] = Np5.section(plane=ZX)
  Np6_Section1 [copper] = Np6.section(plane=ZX)
  Np7_Section1 [copper] = Np7.section(plane=ZX)
  Np8_Section1 [copper] = Np8.section(plane=ZX)
  Np9_Section1 [copper] = Np9.section(plane=ZX)
  Np10_Section1 [copper] = Np10.section(plane=ZX)
  Np11_Section1 [copper] = Np11.section(plane=ZX)
  Np12_Section1 [copper] = Np12.section(plane=ZX)
  Ns1_Section1 [copper] = Ns1.section(plane=ZX)
  Ns2_Section1 [copper] = Ns2.section(plane=ZX)
  Ns3_Section1 [copper] = Ns3.section(plane=ZX)
  Ns4_Section1 [copper] = Ns4.section(plane=ZX)
  Ns5_Section1 [copper] = Ns5.section(plane=ZX)
  Ns6_Section1 [copper] = Ns6.section(plane=ZX)
  Ns7_Section1 [copper] = Ns7.section(plane=ZX)
  Ns8_Section1 [copper] = Ns8.section(plane=ZX)
  Ns9_Section1 [copper] = Ns9.section(plane=ZX)
  Ns10_Section1 [copper] = Ns10.section(plane=ZX)
  Ns11_Section1 [copper] = Ns11.section(plane=ZX)
  Ns12_Section1.separate_bodies()
  Np1_Section1.separate_bodies()
  Np2_Section1.separate_bodies()
  Np3_Section1.separate_bodies()
  Np4_Section1.separate_bodies()
  Np5_Section1.separate_bodies()
  Np6_Section1.separate_bodies()
  Np7_Section1.separate_bodies()
  Np8_Section1.separate_bodies()
  Np9_Section1.separate_bodies()
  Np10_Section1.separate_bodies()
  Np11_Section1.separate_bodies()
  Np12_Section1.separate_bodies()
  Ns1_Section1.separate_bodies()
  Ns2_Section1.separate_bodies()
  Ns3_Section1.separate_bodies()
  Ns4_Section1.separate_bodies()
  Ns5_Section1.separate_bodies()
  Ns6_Section1.separate_bodies()
  Ns7_Section1.separate_bodies()
  Ns8_Section1.separate_bodies()
  Ns9_Section1.separate_bodies()
  Ns10_Section1.separate_bodies()
  Ns11_Section1.separate_bodies()
  group core_assembled_edgewise = plate_1, plate_2, Np1, Np10, Np11, Np12, Np2..Np9, Ns1, Ns10, Ns11, Ns12, Ns2..Ns9, Ns12_Section1, Np1_Section1, Np2_Section1, Np3_Section1, Np4_Section1, Np5_Section1, Np6_Section1, Np7_Section1, Np8_Section1, Np9_Section1, Np10_Section1, Np11_Section1, Np12_Section1, Ns1_Section1, Ns2_Section1, Ns3_Section1, Ns4_Section1, Ns5_Section1, Ns6_Section1, Ns7_Section1, Ns8_Section1, Ns9_Section1, Ns10_Section1, Ns11_Section1
  group core_together_1 = Body1, Body1_1, Body1_2
  group core_together = Body1_3, Body1_4, Body1_5
boundaries and excitations:
  Np_1: Coil Terminal Objects=Np1_Section1 Conductor_number=1 Winding=Primary Point_out_of_terminal=false
  Np_2: Coil Terminal Objects=Np2_Section1 Conductor_number=1 Winding=Primary Point_out_of_terminal=false
  Np_3: Coil Terminal Objects=Np3_Section1 Conductor_number=1 Winding=Primary Point_out_of_terminal=false
  Np_4: Coil Terminal Objects=Np4_Section1 Conductor_number=1 Winding=Primary Point_out_of_terminal=false
  Np_5: Coil Terminal Objects=Np5_Section1 Conductor_number=1 Winding=Primary Point_out_of_terminal=false
  Np_6: Coil Terminal Objects=Np6_Section1 Conductor_number=1 Winding=Primary Point_out_of_terminal=false
  Np_7: Coil Terminal Objects=Np7_Section1 Conductor_number=1 Winding=Primary Point_out_of_terminal=false
  Np_8: Coil Terminal Objects=Np8_Section1 Conductor_number=1 Winding=Primary Point_out_of_terminal=false
  Np_9: Coil Terminal Objects=Np9_Section1 Conductor_number=1 Winding=Primary Point_out_of_terminal=false
  Np_10: Coil Terminal Objects=Np10_Section1 Conductor_number=1 Winding=Primary Point_out_of_terminal=false
  Np_11: Coil Terminal Objects=Np11_Section1 Conductor_number=1 Winding=Primary Point_out_of_terminal=false
  Np_12: Coil Terminal Objects=Np12_Section1 Conductor_number=1 Winding=Primary Point_out_of_terminal=false
  Ns_1: Coil Terminal Objects=Ns1_Section1 Conductor_number=1 Winding=Secondary Point_out_of_terminal=true
  Ns_2: Coil Terminal Objects=Ns2_Section1 Conductor_number=1 Winding=Secondary Point_out_of_terminal=true
  Ns_3: Coil Terminal Objects=Ns3_Section1 Conductor_number=1 Winding=Secondary Point_out_of_terminal=true
  Ns_4: Coil Terminal Objects=Ns4_Section1 Conductor_number=1 Winding=Secondary Point_out_of_terminal=true
  Ns_5: Coil Terminal Objects=Ns5_Section1 Conductor_number=1 Winding=Secondary Point_out_of_terminal=true
  Ns_6: Coil Terminal Objects=Ns6_Section1 Conductor_number=1 Winding=Secondary Point_out_of_terminal=true
  Ns_7: Coil Terminal Objects=Ns7_Section1 Conductor_number=1 Winding=Secondary Point_out_of_terminal=true
  Ns_8: Coil Terminal Objects=Ns8_Section1 Conductor_number=1 Winding=Secondary Point_out_of_terminal=true
  Ns_9: Coil Terminal Objects=Ns9_Section1 Conductor_number=1 Winding=Secondary Point_out_of_terminal=true
  Ns_10: Coil Terminal Objects=Ns10_Section1 Conductor_number=1 Winding=Secondary Point_out_of_terminal=true
  Ns_11: Coil Terminal Objects=Ns11_Section1 Conductor_number=1 Winding=Secondary Point_out_of_terminal=true
  Ns_12: Coil Terminal Objects=Ns12_Section1 Conductor_number=1 Winding=Secondary Point_out_of_terminal=true
  Primary: Winding Group Type=Current IsSolid=true Current=14.14A ParallelBranchesNum=1 Phase=0deg
  Secondary: Winding Group Type=Current IsSolid=true Current=14.14A ParallelBranchesNum=1 Phase=0deg
parameters:
  Matrix1: Matrix Primary, Secondary:
mesh:
  Length1: LengthBased Objects=[Np1..Np12, Ns1..Ns12, plate_1, plate_2] MaxLength=3mm
  Length2: LengthBased Objects=[Body1, Body1_2, Body1_1, Body1_3, Body1_5, Body1_4] MaxLength=3mm
  initial mesh: GlobalCurvilinear{Apply} MeshMethod=AnsoftClassic
setups:
  Setup1: EddyCurrent MaximumPasses=15 MinimumPasses=2 MinimumConvergedPasses=1 PercentRefinement=30 PercentError=3 NonLinearResidual=0.0001 Frequency=30000Hz LossAdaptiveCtrl=0.5

design 0.30_edgewise_3D_DC (Maxwell 3D, Magnetostatic, model units mm)
geometry:
  Region [vacuum] = region(percentage_offset=0 on all sides)
  plate_1, plate_2 [FR4_epoxy] = imported_body(C:\Users\karlr\Documents\0.3_edgewise.step)
  Np1, Np10, Np11, Np12, Np2..Np9, Ns1, Ns10, Ns11, Ns12, Ns2..Ns9 [copper] = imported_body(C:\Users\karlr\Documents\0.3_edgewise.step)
  Body1 [ferrite] = imported_body(C:\Users\karlr\Documents\0.3_edgewise.step)
  Body1_1, Body1_2 [aluminum] = imported_body(C:\Users\karlr\Documents\0.3_edgewise.step)
  Body1_3 [ferrite] = imported_body(C:\Users\karlr\Documents\0.3_edgewise.step)
  Body1_4, Body1_5 [aluminum] = imported_body(C:\Users\karlr\Documents\0.3_edgewise.step)
  Np1_Section1 [copper] = Np1.section(plane=ZX)
  Np2_Section1 [copper] = Np2.section(plane=ZX)
  Np3_Section1 [copper] = Np3.section(plane=ZX)
  Np4_Section1 [copper] = Np4.section(plane=ZX)
  Np5_Section1 [copper] = Np5.section(plane=ZX)
  Np6_Section1 [copper] = Np6.section(plane=ZX)
  Np7_Section1 [copper] = Np7.section(plane=ZX)
  Np8_Section1 [copper] = Np8.section(plane=ZX)
  Np9_Section1 [copper] = Np9.section(plane=ZX)
  Np10_Section1 [copper] = Np10.section(plane=ZX)
  Np11_Section1 [copper] = Np11.section(plane=ZX)
  Np12_Section1 [copper] = Np12.section(plane=ZX)
  Ns1_Section1 [copper] = Ns1.section(plane=ZX)
  Ns2_Section1 [copper] = Ns2.section(plane=ZX)
  Ns3_Section1 [copper] = Ns3.section(plane=ZX)
  Ns4_Section1 [copper] = Ns4.section(plane=ZX)
  Ns5_Section1 [copper] = Ns5.section(plane=ZX)
  Ns6_Section1 [copper] = Ns6.section(plane=ZX)
  Ns7_Section1 [copper] = Ns7.section(plane=ZX)
  Ns8_Section1 [copper] = Ns8.section(plane=ZX)
  Ns9_Section1 [copper] = Ns9.section(plane=ZX)
  Ns10_Section1 [copper] = Ns10.section(plane=ZX)
  Ns11_Section1 [copper] = Ns11.section(plane=ZX)
  Ns12_Section1 [copper] = Ns12.section(plane=ZX)
  Np1_Section1.separate_bodies()
  Np2_Section1.separate_bodies()
  Np3_Section1.separate_bodies()
  Np4_Section1.separate_bodies()
  Np5_Section1.separate_bodies()
  Np6_Section1.separate_bodies()
  Np7_Section1.separate_bodies()
  Np8_Section1.separate_bodies()
  Np9_Section1.separate_bodies()
  Np10_Section1.separate_bodies()
  Np11_Section1.separate_bodies()
  Np12_Section1.separate_bodies()
  Ns1_Section1.separate_bodies()
  Ns2_Section1.separate_bodies()
  Ns3_Section1.separate_bodies()
  Ns4_Section1.separate_bodies()
  Ns5_Section1.separate_bodies()
  Ns6_Section1.separate_bodies()
  Ns7_Section1.separate_bodies()
  Ns8_Section1.separate_bodies()
  Ns9_Section1.separate_bodies()
  Ns10_Section1.separate_bodies()
  Ns11_Section1.separate_bodies()
  Ns12_Section1.separate_bodies()
  Rectangle1 [non-model] = rectangle(corner=(5.2mm, -9.7mm, 10.05mm), x_size=29.4mm, y_size=33.592985mm)
  group core_assembled_edgewise = plate_1, plate_2, Np1, Np10, Np11, Np12, Np2..Np9, Ns1, Ns10, Ns11, Ns12, Ns2..Ns9, Np1_Section1, Np2_Section1, Np3_Section1, Np4_Section1, Np5_Section1, Np6_Section1, Np7_Section1, Np8_Section1, Np9_Section1, Np10_Section1, Np11_Section1, Np12_Section1, Ns1_Section1, Ns2_Section1, Ns3_Section1, Ns4_Section1, Ns5_Section1, Ns6_Section1, Ns7_Section1, Ns8_Section1, Ns9_Section1, Ns10_Section1, Ns11_Section1, Ns12_Section1
  group core_together_1 = Body1, Body1_1, Body1_2
  group core_together = Body1_3, Body1_4, Body1_5
boundaries and excitations:
  Np_1: Coil Terminal Objects=Np1_Section1 Conductor_number=1 Winding=Primary Point_out_of_terminal=false
  Np_2: Coil Terminal Objects=Np2_Section1 Conductor_number=1 Winding=Primary Point_out_of_terminal=false
  Np_3: Coil Terminal Objects=Np3_Section1 Conductor_number=1 Winding=Primary Point_out_of_terminal=false
  Np_4: Coil Terminal Objects=Np4_Section1 Conductor_number=1 Winding=Primary Point_out_of_terminal=false
  Np_5: Coil Terminal Objects=Np5_Section1 Conductor_number=1 Winding=Primary Point_out_of_terminal=false
  Np_6: Coil Terminal Objects=Np6_Section1 Conductor_number=1 Winding=Primary Point_out_of_terminal=false
  Np_7: Coil Terminal Objects=Np7_Section1 Conductor_number=1 Winding=Primary Point_out_of_terminal=false
  Np_8: Coil Terminal Objects=Np8_Section1 Conductor_number=1 Winding=Primary Point_out_of_terminal=false
  Np_9: Coil Terminal Objects=Np9_Section1 Conductor_number=1 Winding=Primary Point_out_of_terminal=false
  Np_10: Coil Terminal Objects=Np10_Section1 Conductor_number=1 Winding=Primary Point_out_of_terminal=false
  Np_11: Coil Terminal Objects=Np11_Section1 Conductor_number=1 Winding=Primary Point_out_of_terminal=false
  Np_12: Coil Terminal Objects=Np12_Section1 Conductor_number=1 Winding=Primary Point_out_of_terminal=false
  Ns_1: Coil Terminal Objects=Ns1_Section1 Conductor_number=1 Winding=Secondary Point_out_of_terminal=true
  Ns_2: Coil Terminal Objects=Ns2_Section1 Conductor_number=1 Winding=Secondary Point_out_of_terminal=true
  Ns_3: Coil Terminal Objects=Ns3_Section1 Conductor_number=1 Winding=Secondary Point_out_of_terminal=true
  Ns_4: Coil Terminal Objects=Ns4_Section1 Conductor_number=1 Winding=Secondary Point_out_of_terminal=true
  Ns_5: Coil Terminal Objects=Ns5_Section1 Conductor_number=1 Winding=Secondary Point_out_of_terminal=true
  Ns_6: Coil Terminal Objects=Ns6_Section1 Conductor_number=1 Winding=Secondary Point_out_of_terminal=true
  Ns_7: Coil Terminal Objects=Ns7_Section1 Conductor_number=1 Winding=Secondary Point_out_of_terminal=true
  Ns_8: Coil Terminal Objects=Ns8_Section1 Conductor_number=1 Winding=Secondary Point_out_of_terminal=true
  Ns_9: Coil Terminal Objects=Ns9_Section1 Conductor_number=1 Winding=Secondary Point_out_of_terminal=true
  Ns_10: Coil Terminal Objects=Ns10_Section1 Conductor_number=1 Winding=Secondary Point_out_of_terminal=true
  Ns_11: Coil Terminal Objects=Ns11_Section1 Conductor_number=1 Winding=Secondary Point_out_of_terminal=true
  Ns_12: Coil Terminal Objects=Ns12_Section1 Conductor_number=1 Winding=Secondary Point_out_of_terminal=true
  Primary: Winding Group Type=Current IsSolid=true Current=14.142A ParallelBranchesNum=1
  Secondary: Winding Group Type=Current IsSolid=true Current=13.942A ParallelBranchesNum=1
parameters:
  Matrix1: Matrix Primary, Secondary: NumberOfTurns=1
mesh:
  Length1: LengthBased Objects=[Np1..Np12, Ns1..Ns12, plate_1, plate_2] MaxLength=3mm
  Length2: LengthBased Objects=[Body1_4, Body1_5, Body1_3, Body1_1, Body1_2, Body1] MaxLength=3mm
  initial mesh: GlobalCurvilinear{Apply} MeshMethod=AnsoftClassic
setups:
  Setup1: Magnetostatic MaximumPasses=10 MinimumPasses=2 MinimumConvergedPasses=1 PercentRefinement=30 PercentError=1 NonLinearResidual=0.001
field plots:
  Mag_J1: J over a plane on Setup1 : LastAdaptive

design 0.20_edgewise_3D_DC (Maxwell 3D, Magnetostatic, model units mm)
geometry:
  Region [vacuum] = region(percentage_offset=0 on all sides)
  Np1, Np10, Np11, Np12, Np2..Np9, Ns1, Ns10, Ns11, Ns12, Ns2..Ns9 [copper] = imported_body(C:\Users\karlr\Documents\0.2_edgewise.step)
  plate_1, plate_2 [FR4_epoxy] = imported_body(C:\Users\karlr\Documents\0.2_edgewise.step)
  Body1 [ferrite] = imported_body(C:\Users\karlr\Documents\0.2_edgewise.step)
  Body1_1, Body1_2 [aluminum] = imported_body(C:\Users\karlr\Documents\0.2_edgewise.step)
  Body1_3 [ferrite] = imported_body(C:\Users\karlr\Documents\0.2_edgewise.step)
  Body1_4, Body1_5 [aluminum] = imported_body(C:\Users\karlr\Documents\0.2_edgewise.step)
  Np1_Section1 [copper] = Np1.section(plane=ZX)
  Np2_Section1 [copper] = Np2.section(plane=ZX)
  Np3_Section1 [copper] = Np3.section(plane=ZX)
  Np4_Section1 [copper] = Np4.section(plane=ZX)
  Np5_Section1 [copper] = Np5.section(plane=ZX)
  Np6_Section1 [copper] = Np6.section(plane=ZX)
  Np7_Section1 [copper] = Np7.section(plane=ZX)
  Np8_Section1 [copper] = Np8.section(plane=ZX)
  Np9_Section1 [copper] = Np9.section(plane=ZX)
  Np10_Section1 [copper] = Np10.section(plane=ZX)
  Np11_Section1 [copper] = Np11.section(plane=ZX)
  Np12_Section1 [copper] = Np12.section(plane=ZX)
  Ns1_Section1 [copper] = Ns1.section(plane=ZX)
  Ns2_Section1 [copper] = Ns2.section(plane=ZX)
  Ns3_Section1 [copper] = Ns3.section(plane=ZX)
  Ns4_Section1 [copper] = Ns4.section(plane=ZX)
  Ns5_Section1 [copper] = Ns5.section(plane=ZX)
  Ns6_Section1 [copper] = Ns6.section(plane=ZX)
  Ns7_Section1 [copper] = Ns7.section(plane=ZX)
  Ns8_Section1 [copper] = Ns8.section(plane=ZX)
  Ns9_Section1 [copper] = Ns9.section(plane=ZX)
  Ns10_Section1 [copper] = Ns10.section(plane=ZX)
  Ns11_Section1 [copper] = Ns11.section(plane=ZX)
  Ns12_Section1 [copper] = Ns12.section(plane=ZX)
  Np1_Section1.separate_bodies()
  Np2_Section1.separate_bodies()
  Np3_Section1.separate_bodies()
  Np4_Section1.separate_bodies()
  Np5_Section1.separate_bodies()
  Np6_Section1.separate_bodies()
  Np7_Section1.separate_bodies()
  Np8_Section1.separate_bodies()
  Np9_Section1.separate_bodies()
  Np10_Section1.separate_bodies()
  Np11_Section1.separate_bodies()
  Np12_Section1.separate_bodies()
  Ns1_Section1.separate_bodies()
  Ns2_Section1.separate_bodies()
  Ns3_Section1.separate_bodies()
  Ns4_Section1.separate_bodies()
  Ns5_Section1.separate_bodies()
  Ns6_Section1.separate_bodies()
  Ns7_Section1.separate_bodies()
  Ns8_Section1.separate_bodies()
  Ns9_Section1.separate_bodies()
  Ns10_Section1.separate_bodies()
  Ns11_Section1.separate_bodies()
  Ns12_Section1.separate_bodies()
  group core_assembled_edgewise = Np1, Np10, Np11, Np12, Np2..Np9, Ns1, Ns10, Ns11, Ns12, Ns2..Ns9, plate_1, plate_2, Np1_Section1, Np2_Section1, Np3_Section1, Np4_Section1, Np5_Section1, Np6_Section1, Np7_Section1, Np8_Section1, Np9_Section1, Np10_Section1, Np11_Section1, Np12_Section1, Ns1_Section1, Ns2_Section1, Ns3_Section1, Ns4_Section1, Ns5_Section1, Ns6_Section1, Ns7_Section1, Ns8_Section1, Ns9_Section1, Ns10_Section1, Ns11_Section1, Ns12_Section1
  group core_together_1 = Body1, Body1_1, Body1_2
  group core_together = Body1_3, Body1_4, Body1_5
boundaries and excitations:
  Np_1: Coil Terminal Objects=Np1_Section1 Conductor_number=1 Winding=Primary Point_out_of_terminal=false
  Np_2: Coil Terminal Objects=Np2_Section1 Conductor_number=1 Winding=Primary Point_out_of_terminal=false
  Np_3: Coil Terminal Objects=Np3_Section1 Conductor_number=1 Winding=Primary Point_out_of_terminal=false
  Np_4: Coil Terminal Objects=Np4_Section1 Conductor_number=1 Winding=Primary Point_out_of_terminal=false
  Np_5: Coil Terminal Objects=Np5_Section1 Conductor_number=1 Winding=Primary Point_out_of_terminal=false
  Np_6: Coil Terminal Objects=Np6_Section1 Conductor_number=1 Winding=Primary Point_out_of_terminal=false
  Np_7: Coil Terminal Objects=Np7_Section1 Conductor_number=1 Winding=Primary Point_out_of_terminal=false
  Np_8: Coil Terminal Objects=Np8_Section1 Conductor_number=1 Winding=Primary Point_out_of_terminal=false
  Np_9: Coil Terminal Objects=Np9_Section1 Conductor_number=1 Winding=Primary Point_out_of_terminal=false
  Np_10: Coil Terminal Objects=Np10_Section1 Conductor_number=1 Winding=Primary Point_out_of_terminal=false
  Np_11: Coil Terminal Objects=Np11_Section1 Conductor_number=1 Winding=Primary Point_out_of_terminal=false
  Np_12: Coil Terminal Objects=Np12_Section1 Conductor_number=1 Winding=Primary Point_out_of_terminal=false
  Ns_1: Coil Terminal Objects=Ns1_Section1 Conductor_number=1 Winding=Secondary Point_out_of_terminal=true
  Ns_2: Coil Terminal Objects=Ns2_Section1 Conductor_number=1 Winding=Secondary Point_out_of_terminal=true
  Ns_3: Coil Terminal Objects=Ns3_Section1 Conductor_number=1 Winding=Secondary Point_out_of_terminal=true
  Ns_4: Coil Terminal Objects=Ns4_Section1 Conductor_number=1 Winding=Secondary Point_out_of_terminal=true
  Ns_5: Coil Terminal Objects=Ns5_Section1 Conductor_number=1 Winding=Secondary Point_out_of_terminal=true
  Ns_6: Coil Terminal Objects=Ns6_Section1 Conductor_number=1 Winding=Secondary Point_out_of_terminal=true
  Ns_7: Coil Terminal Objects=Ns7_Section1 Conductor_number=1 Winding=Secondary Point_out_of_terminal=true
  Ns_8: Coil Terminal Objects=Ns8_Section1 Conductor_number=1 Winding=Secondary Point_out_of_terminal=true
  Ns_9: Coil Terminal Objects=Ns9_Section1 Conductor_number=1 Winding=Secondary Point_out_of_terminal=true
  Ns_10: Coil Terminal Objects=Ns10_Section1 Conductor_number=1 Winding=Secondary Point_out_of_terminal=true
  Ns_11: Coil Terminal Objects=Ns11_Section1 Conductor_number=1 Winding=Secondary Point_out_of_terminal=true
  Ns_12: Coil Terminal Objects=Ns12_Section1 Conductor_number=1 Winding=Secondary Point_out_of_terminal=true
  Primary: Winding Group Type=Current IsSolid=true Current=20A ParallelBranchesNum=1
  Secondary: Winding Group Type=Current IsSolid=true Current=0mA ParallelBranchesNum=1
parameters:
  Matrix1: Matrix Primary, Secondary: NumberOfTurns=1
mesh:
  Length1: LengthBased Objects=[Np1..Np12, Ns1..Ns12, plate_1, plate_2] MaxLength=3mm
  Length2: LengthBased Objects=[Body1_1, Body1_2, Body1, Body1_3, Body1_5, Body1_4] MaxLength=3mm
  initial mesh: GlobalCurvilinear{Apply} MeshMethod=AnsoftClassic
setups:
  Setup1: Magnetostatic MaximumPasses=10 MinimumPasses=2 MinimumConvergedPasses=1 PercentRefinement=30 PercentError=1 NonLinearResidual=0.001

design 0.25_edgewise_3D_DC (Maxwell 3D, Magnetostatic, model units mm)
geometry:
  Region [vacuum] = region(percentage_offset=0 on all sides)
  plate_1, plate_2 [FR4_epoxy] = imported_body(C:\Users\karlr\Documents\0.25_edgewise.step)
  Np1, Np10, Np11, Np12, Np2..Np9, Ns1, Ns10, Ns11, Ns12, Ns2..Ns9 [copper] = imported_body(C:\Users\karlr\Documents\0.25_edgewise.step)
  Body1 [ferrite] = imported_body(C:\Users\karlr\Documents\0.25_edgewise.step)
  Body1_1, Body1_2 [aluminum] = imported_body(C:\Users\karlr\Documents\0.25_edgewise.step)
  Body1_3 [ferrite] = imported_body(C:\Users\karlr\Documents\0.25_edgewise.step)
  Body1_4, Body1_5 [aluminum] = imported_body(C:\Users\karlr\Documents\0.25_edgewise.step)
  Np1_Section1 [copper] = Np1.section(plane=ZX)
  Np2_Section1 [copper] = Np2.section(plane=ZX)
  Np3_Section1 [copper] = Np3.section(plane=ZX)
  Np4_Section1 [copper] = Np4.section(plane=ZX)
  Np5_Section1 [copper] = Np5.section(plane=ZX)
  Np6_Section1 [copper] = Np6.section(plane=ZX)
  Np7_Section1 [copper] = Np7.section(plane=ZX)
  Np8_Section1 [copper] = Np8.section(plane=ZX)
  Np9_Section1 [copper] = Np9.section(plane=ZX)
  Np10_Section1 [copper] = Np10.section(plane=ZX)
  Np11_Section1 [copper] = Np11.section(plane=ZX)
  Np12_Section1 [copper] = Np12.section(plane=ZX)
  Ns1_Section1 [copper] = Ns1.section(plane=ZX)
  Ns2_Section1 [copper] = Ns2.section(plane=ZX)
  Ns3_Section1 [copper] = Ns3.section(plane=ZX)
  Ns4_Section1 [copper] = Ns4.section(plane=ZX)
  Ns5_Section1 [copper] = Ns5.section(plane=ZX)
  Ns6_Section1 [copper] = Ns6.section(plane=ZX)
  Ns7_Section1 [copper] = Ns7.section(plane=ZX)
  Ns8_Section1 [copper] = Ns8.section(plane=ZX)
  Ns9_Section1 [copper] = Ns9.section(plane=ZX)
  Ns10_Section1 [copper] = Ns10.section(plane=ZX)
  Ns11_Section1 [copper] = Ns11.section(plane=ZX)
  Ns12_Section1 [copper] = Ns12.section(plane=ZX)
  Np1_Section1.separate_bodies()
  Np2_Section1.separate_bodies()
  Np3_Section1.separate_bodies()
  Np4_Section1.separate_bodies()
  Np5_Section1.separate_bodies()
  Np6_Section1.separate_bodies()
  Np7_Section1.separate_bodies()
  Np8_Section1.separate_bodies()
  Np9_Section1.separate_bodies()
  Np10_Section1.separate_bodies()
  Np11_Section1.separate_bodies()
  Np12_Section1.separate_bodies()
  Ns1_Section1.separate_bodies()
  Ns2_Section1.separate_bodies()
  Ns3_Section1.separate_bodies()
  Ns4_Section1.separate_bodies()
  Ns5_Section1.separate_bodies()
  Ns6_Section1.separate_bodies()
  Ns7_Section1.separate_bodies()
  Ns8_Section1.separate_bodies()
  Ns9_Section1.separate_bodies()
  Ns10_Section1.separate_bodies()
  Ns11_Section1.separate_bodies()
  Ns12_Section1.separate_bodies()
  group core_assembled_edgewise = plate_1, plate_2, Np1, Np10, Np11, Np12, Np2..Np9, Ns1, Ns10, Ns11, Ns12, Ns2..Ns9, Np1_Section1, Np2_Section1, Np3_Section1, Np4_Section1, Np5_Section1, Np6_Section1, Np7_Section1, Np8_Section1, Np9_Section1, Np10_Section1, Np11_Section1, Np12_Section1, Ns1_Section1, Ns2_Section1, Ns3_Section1, Ns4_Section1, Ns5_Section1, Ns6_Section1, Ns7_Section1, Ns8_Section1, Ns9_Section1, Ns10_Section1, Ns11_Section1, Ns12_Section1
  group core_together_1 = Body1, Body1_1, Body1_2
  group core_together = Body1_3, Body1_4, Body1_5
boundaries and excitations:
  Np_1: Coil Terminal Objects=Np1_Section1 Conductor_number=1 Winding=Primary Point_out_of_terminal=false
  Np_2: Coil Terminal Objects=Np2_Section1 Conductor_number=1 Winding=Primary Point_out_of_terminal=false
  Np_3: Coil Terminal Objects=Np3_Section1 Conductor_number=1 Winding=Primary Point_out_of_terminal=false
  Np_4: Coil Terminal Objects=Np4_Section1 Conductor_number=1 Winding=Primary Point_out_of_terminal=false
  Np_5: Coil Terminal Objects=Np5_Section1 Conductor_number=1 Winding=Primary Point_out_of_terminal=false
  Np_6: Coil Terminal Objects=Np6_Section1 Conductor_number=1 Winding=Primary Point_out_of_terminal=false
  Np_7: Coil Terminal Objects=Np7_Section1 Conductor_number=1 Winding=Primary Point_out_of_terminal=false
  Np_8: Coil Terminal Objects=Np8_Section1 Conductor_number=1 Winding=Primary Point_out_of_terminal=false
  Np_9: Coil Terminal Objects=Np9_Section1 Conductor_number=1 Winding=Primary Point_out_of_terminal=false
  Np_10: Coil Terminal Objects=Np10_Section1 Conductor_number=1 Winding=Primary Point_out_of_terminal=false
  Np_11: Coil Terminal Objects=Np11_Section1 Conductor_number=1 Winding=Primary Point_out_of_terminal=false
  Np_12: Coil Terminal Objects=Np12_Section1 Conductor_number=1 Winding=Primary Point_out_of_terminal=false
  Ns_1: Coil Terminal Objects=Ns1_Section1 Conductor_number=1 Winding=Secondary Point_out_of_terminal=true
  Ns_2: Coil Terminal Objects=Ns2_Section1 Conductor_number=1 Winding=Secondary Point_out_of_terminal=true
  Ns_3: Coil Terminal Objects=Ns3_Section1 Conductor_number=1 Winding=Secondary Point_out_of_terminal=true
  Ns_4: Coil Terminal Objects=Ns4_Section1 Conductor_number=1 Winding=Secondary Point_out_of_terminal=true
  Ns_5: Coil Terminal Objects=Ns5_Section1 Conductor_number=1 Winding=Secondary Point_out_of_terminal=true
  Ns_6: Coil Terminal Objects=Ns6_Section1 Conductor_number=1 Winding=Secondary Point_out_of_terminal=true
  Ns_7: Coil Terminal Objects=Ns7_Section1 Conductor_number=1 Winding=Secondary Point_out_of_terminal=true
  Ns_8: Coil Terminal Objects=Ns8_Section1 Conductor_number=1 Winding=Secondary Point_out_of_terminal=true
  Ns_9: Coil Terminal Objects=Ns9_Section1 Conductor_number=1 Winding=Secondary Point_out_of_terminal=true
  Ns_10: Coil Terminal Objects=Ns10_Section1 Conductor_number=1 Winding=Secondary Point_out_of_terminal=true
  Ns_11: Coil Terminal Objects=Ns11_Section1 Conductor_number=1 Winding=Secondary Point_out_of_terminal=true
  Ns_12: Coil Terminal Objects=Ns12_Section1 Conductor_number=1 Winding=Secondary Point_out_of_terminal=true
  Primary: Winding Group Type=Current IsSolid=true Current=20A ParallelBranchesNum=1
  Secondary: Winding Group Type=Current IsSolid=true Current=0mA ParallelBranchesNum=1
parameters:
  Matrix1: Matrix Primary, Secondary: NumberOfTurns=1
mesh:
  Length1: LengthBased Objects=[Np1..Np12, Ns1..Ns12, plate_1, plate_2] MaxLength=3mm
  Length2: LengthBased Objects=[Body1_4, Body1_5, Body1_3, Body1_1, Body1_2, Body1] MaxLength=3mm
  initial mesh: GlobalCurvilinear{Apply} MeshMethod=AnsoftClassic
setups:
  Setup1: Magnetostatic MaximumPasses=10 MinimumPasses=2 MinimumConvergedPasses=1 PercentRefinement=30 PercentError=1 NonLinearResidual=0.001

design 0.35_edgewise_3D_DC (Maxwell 3D, Magnetostatic, model units mm)
geometry:
  Region [vacuum] = region(percentage_offset=0 on all sides)
  plate_1, plate_2 [FR4_epoxy] = imported_body(C:\Users\karlr\Documents\0.35_edgewise.step)
  Np1, Np10, Np11, Np12, Np2..Np9, Ns1, Ns10, Ns11, Ns12, Ns2..Ns9 [copper] = imported_body(C:\Users\karlr\Documents\0.35_edgewise.step)
  Body1 [ferrite] = imported_body(C:\Users\karlr\Documents\0.35_edgewise.step)
  Body1_1, Body1_2 [aluminum] = imported_body(C:\Users\karlr\Documents\0.35_edgewise.step)
  Body1_3 [ferrite] = imported_body(C:\Users\karlr\Documents\0.35_edgewise.step)
  Body1_4, Body1_5 [aluminum] = imported_body(C:\Users\karlr\Documents\0.35_edgewise.step)
  Np1_Section1 [copper] = Np1.section(plane=ZX)
  Np2_Section1 [copper] = Np2.section(plane=ZX)
  Np3_Section1 [copper] = Np3.section(plane=ZX)
  Np4_Section1 [copper] = Np4.section(plane=ZX)
  Np5_Section1 [copper] = Np5.section(plane=ZX)
  Np6_Section1 [copper] = Np6.section(plane=ZX)
  Np7_Section1 [copper] = Np7.section(plane=ZX)
  Np8_Section1 [copper] = Np8.section(plane=ZX)
  Np9_Section1 [copper] = Np9.section(plane=ZX)
  Np10_Section1 [copper] = Np10.section(plane=ZX)
  Np11_Section1 [copper] = Np11.section(plane=ZX)
  Np12_Section1 [copper] = Np12.section(plane=ZX)
  Ns1_Section1 [copper] = Ns1.section(plane=ZX)
  Ns2_Section1 [copper] = Ns2.section(plane=ZX)
  Ns3_Section1 [copper] = Ns3.section(plane=ZX)
  Ns4_Section1 [copper] = Ns4.section(plane=ZX)
  Ns5_Section1 [copper] = Ns5.section(plane=ZX)
  Ns6_Section1 [copper] = Ns6.section(plane=ZX)
  Ns7_Section1 [copper] = Ns7.section(plane=ZX)
  Ns8_Section1 [copper] = Ns8.section(plane=ZX)
  Ns9_Section1 [copper] = Ns9.section(plane=ZX)
  Ns10_Section1 [copper] = Ns10.section(plane=ZX)
  Ns11_Section1 [copper] = Ns11.section(plane=ZX)
  Ns12_Section1 [copper] = Ns12.section(plane=ZX)
  Np1_Section1.separate_bodies()
  Np2_Section1.separate_bodies()
  Np3_Section1.separate_bodies()
  Np4_Section1.separate_bodies()
  Np5_Section1.separate_bodies()
  Np6_Section1.separate_bodies()
  Np7_Section1.separate_bodies()
  Np8_Section1.separate_bodies()
  Np9_Section1.separate_bodies()
  Np10_Section1.separate_bodies()
  Np11_Section1.separate_bodies()
  Np12_Section1.separate_bodies()
  Ns1_Section1.separate_bodies()
  Ns2_Section1.separate_bodies()
  Ns3_Section1.separate_bodies()
  Ns4_Section1.separate_bodies()
  Ns5_Section1.separate_bodies()
  Ns6_Section1.separate_bodies()
  Ns7_Section1.separate_bodies()
  Ns8_Section1.separate_bodies()
  Ns9_Section1.separate_bodies()
  Ns10_Section1.separate_bodies()
  Ns11_Section1.separate_bodies()
  Ns12_Section1.separate_bodies()
  group core_assembled_edgewise = plate_1, plate_2, Np1, Np10, Np11, Np12, Np2..Np9, Ns1, Ns10, Ns11, Ns12, Ns2..Ns9, Np1_Section1, Np2_Section1, Np3_Section1, Np4_Section1, Np5_Section1, Np6_Section1, Np7_Section1, Np8_Section1, Np9_Section1, Np10_Section1, Np11_Section1, Np12_Section1, Ns1_Section1, Ns2_Section1, Ns3_Section1, Ns4_Section1, Ns5_Section1, Ns6_Section1, Ns7_Section1, Ns8_Section1, Ns9_Section1, Ns10_Section1, Ns11_Section1, Ns12_Section1
  group core_together_1 = Body1, Body1_1, Body1_2
  group core_together = Body1_3, Body1_4, Body1_5
boundaries and excitations:
  Np_1: Coil Terminal Objects=Np1_Section1 Conductor_number=1 Winding=Primary Point_out_of_terminal=false
  Np_2: Coil Terminal Objects=Np2_Section1 Conductor_number=1 Winding=Primary Point_out_of_terminal=false
  Np_3: Coil Terminal Objects=Np3_Section1 Conductor_number=1 Winding=Primary Point_out_of_terminal=false
  Np_4: Coil Terminal Objects=Np4_Section1 Conductor_number=1 Winding=Primary Point_out_of_terminal=false
  Np_5: Coil Terminal Objects=Np5_Section1 Conductor_number=1 Winding=Primary Point_out_of_terminal=false
  Np_6: Coil Terminal Objects=Np6_Section1 Conductor_number=1 Winding=Primary Point_out_of_terminal=false
  Np_7: Coil Terminal Objects=Np7_Section1 Conductor_number=1 Winding=Primary Point_out_of_terminal=false
  Np_8: Coil Terminal Objects=Np8_Section1 Conductor_number=1 Winding=Primary Point_out_of_terminal=false
  Np_9: Coil Terminal Objects=Np9_Section1 Conductor_number=1 Winding=Primary Point_out_of_terminal=false
  Np_10: Coil Terminal Objects=Np10_Section1 Conductor_number=1 Winding=Primary Point_out_of_terminal=false
  Np_11: Coil Terminal Objects=Np11_Section1 Conductor_number=1 Winding=Primary Point_out_of_terminal=false
  Np_12: Coil Terminal Objects=Np12_Section1 Conductor_number=1 Winding=Primary Point_out_of_terminal=false
  Ns_1: Coil Terminal Objects=Ns1_Section1 Conductor_number=1 Winding=Secondary Point_out_of_terminal=true
  Ns_2: Coil Terminal Objects=Ns2_Section1 Conductor_number=1 Winding=Secondary Point_out_of_terminal=true
  Ns_3: Coil Terminal Objects=Ns3_Section1 Conductor_number=1 Winding=Secondary Point_out_of_terminal=true
  Ns_4: Coil Terminal Objects=Ns4_Section1 Conductor_number=1 Winding=Secondary Point_out_of_terminal=true
  Ns_5: Coil Terminal Objects=Ns5_Section1 Conductor_number=1 Winding=Secondary Point_out_of_terminal=true
  Ns_6: Coil Terminal Objects=Ns6_Section1 Conductor_number=1 Winding=Secondary Point_out_of_terminal=true
  Ns_7: Coil Terminal Objects=Ns7_Section1 Conductor_number=1 Winding=Secondary Point_out_of_terminal=true
  Ns_8: Coil Terminal Objects=Ns8_Section1 Conductor_number=1 Winding=Secondary Point_out_of_terminal=true
  Ns_9: Coil Terminal Objects=Ns9_Section1 Conductor_number=1 Winding=Secondary Point_out_of_terminal=true
  Ns_10: Coil Terminal Objects=Ns10_Section1 Conductor_number=1 Winding=Secondary Point_out_of_terminal=true
  Ns_11: Coil Terminal Objects=Ns11_Section1 Conductor_number=1 Winding=Secondary Point_out_of_terminal=true
  Ns_12: Coil Terminal Objects=Ns12_Section1 Conductor_number=1 Winding=Secondary Point_out_of_terminal=true
  Primary: Winding Group Type=Current IsSolid=true Current=20A ParallelBranchesNum=1
  Secondary: Winding Group Type=Current IsSolid=true Current=0mA ParallelBranchesNum=1
parameters:
  Matrix1: Matrix Primary, Secondary: NumberOfTurns=1
mesh:
  Length1: LengthBased Objects=[Np1..Np12, Ns1..Ns12, plate_1, plate_2] MaxLength=3mm
  Length2: LengthBased Objects=[Body1_4, Body1_5, Body1_3, Body1_1, Body1_2, Body1] MaxLength=3mm
  initial mesh: GlobalCurvilinear{Apply} MeshMethod=AnsoftClassic

design 0.40_edgewise_3D_DC (Maxwell 3D, Magnetostatic, model units mm)
geometry:
  Region [vacuum] = region(percentage_offset=0 on all sides)
  plate_1, plate_2 [FR4_epoxy] = imported_body(C:\Users\karlr\Documents\0.4_edgewise.step)
  Np1, Np10, Np11, Np12, Np2..Np9, Ns1, Ns10, Ns11, Ns12, Ns2..Ns9 [copper] = imported_body(C:\Users\karlr\Documents\0.4_edgewise.step)
  Body1 [ferrite] = imported_body(C:\Users\karlr\Documents\0.4_edgewise.step)
  Body1_1, Body1_2 [aluminum] = imported_body(C:\Users\karlr\Documents\0.4_edgewise.step)
  Body1_3 [ferrite] = imported_body(C:\Users\karlr\Documents\0.4_edgewise.step)
  Body1_4, Body1_5 [aluminum] = imported_body(C:\Users\karlr\Documents\0.4_edgewise.step)
  Ns12_Section1 [copper] = Ns12.section(plane=ZX)
  Np1_Section1 [copper] = Np1.section(plane=ZX)
  Np2_Section1 [copper] = Np2.section(plane=ZX)
  Np3_Section1 [copper] = Np3.section(plane=ZX)
  Np4_Section1 [copper] = Np4.section(plane=ZX)
  Np5_Section1 [copper] = Np5.section(plane=ZX)
  Np6_Section1 [copper] = Np6.section(plane=ZX)
  Np7_Section1 [copper] = Np7.section(plane=ZX)
  Np8_Section1 [copper] = Np8.section(plane=ZX)
  Np9_Section1 [copper] = Np9.section(plane=ZX)
  Np10_Section1 [copper] = Np10.section(plane=ZX)
  Np11_Section1 [copper] = Np11.section(plane=ZX)
  Np12_Section1 [copper] = Np12.section(plane=ZX)
  Ns1_Section1 [copper] = Ns1.section(plane=ZX)
  Ns2_Section1 [copper] = Ns2.section(plane=ZX)
  Ns3_Section1 [copper] = Ns3.section(plane=ZX)
  Ns4_Section1 [copper] = Ns4.section(plane=ZX)
  Ns5_Section1 [copper] = Ns5.section(plane=ZX)
  Ns6_Section1 [copper] = Ns6.section(plane=ZX)
  Ns7_Section1 [copper] = Ns7.section(plane=ZX)
  Ns8_Section1 [copper] = Ns8.section(plane=ZX)
  Ns9_Section1 [copper] = Ns9.section(plane=ZX)
  Ns10_Section1 [copper] = Ns10.section(plane=ZX)
  Ns11_Section1 [copper] = Ns11.section(plane=ZX)
  Ns12_Section1.separate_bodies()
  Np1_Section1.separate_bodies()
  Np2_Section1.separate_bodies()
  Np3_Section1.separate_bodies()
  Np4_Section1.separate_bodies()
  Np5_Section1.separate_bodies()
  Np6_Section1.separate_bodies()
  Np7_Section1.separate_bodies()
  Np8_Section1.separate_bodies()
  Np9_Section1.separate_bodies()
  Np10_Section1.separate_bodies()
  Np11_Section1.separate_bodies()
  Np12_Section1.separate_bodies()
  Ns1_Section1.separate_bodies()
  Ns2_Section1.separate_bodies()
  Ns3_Section1.separate_bodies()
  Ns4_Section1.separate_bodies()
  Ns5_Section1.separate_bodies()
  Ns6_Section1.separate_bodies()
  Ns7_Section1.separate_bodies()
  Ns8_Section1.separate_bodies()
  Ns9_Section1.separate_bodies()
  Ns10_Section1.separate_bodies()
  Ns11_Section1.separate_bodies()
  group core_assembled_edgewise = plate_1, plate_2, Np1, Np10, Np11, Np12, Np2..Np9, Ns1, Ns10, Ns11, Ns12, Ns2..Ns9, Ns12_Section1, Np1_Section1, Np2_Section1, Np3_Section1, Np4_Section1, Np5_Section1, Np6_Section1, Np7_Section1, Np8_Section1, Np9_Section1, Np10_Section1, Np11_Section1, Np12_Section1, Ns1_Section1, Ns2_Section1, Ns3_Section1, Ns4_Section1, Ns5_Section1, Ns6_Section1, Ns7_Section1, Ns8_Section1, Ns9_Section1, Ns10_Section1, Ns11_Section1
  group core_together_1 = Body1, Body1_1, Body1_2
  group core_together = Body1_3, Body1_4, Body1_5
boundaries and excitations:
  Np_1: Coil Terminal Objects=Np1_Section1 Conductor_number=1 Winding=Primary Point_out_of_terminal=false
  Np_2: Coil Terminal Objects=Np2_Section1 Conductor_number=1 Winding=Primary Point_out_of_terminal=false
  Np_3: Coil Terminal Objects=Np3_Section1 Conductor_number=1 Winding=Primary Point_out_of_terminal=false
  Np_4: Coil Terminal Objects=Np4_Section1 Conductor_number=1 Winding=Primary Point_out_of_terminal=false
  Np_5: Coil Terminal Objects=Np5_Section1 Conductor_number=1 Winding=Primary Point_out_of_terminal=false
  Np_6: Coil Terminal Objects=Np6_Section1 Conductor_number=1 Winding=Primary Point_out_of_terminal=false
  Np_7: Coil Terminal Objects=Np7_Section1 Conductor_number=1 Winding=Primary Point_out_of_terminal=false
  Np_8: Coil Terminal Objects=Np8_Section1 Conductor_number=1 Winding=Primary Point_out_of_terminal=false
  Np_9: Coil Terminal Objects=Np9_Section1 Conductor_number=1 Winding=Primary Point_out_of_terminal=false
  Np_10: Coil Terminal Objects=Np10_Section1 Conductor_number=1 Winding=Primary Point_out_of_terminal=false
  Np_11: Coil Terminal Objects=Np11_Section1 Conductor_number=1 Winding=Primary Point_out_of_terminal=false
  Np_12: Coil Terminal Objects=Np12_Section1 Conductor_number=1 Winding=Primary Point_out_of_terminal=false
  Ns_1: Coil Terminal Objects=Ns1_Section1 Conductor_number=1 Winding=Secondary Point_out_of_terminal=true
  Ns_2: Coil Terminal Objects=Ns2_Section1 Conductor_number=1 Winding=Secondary Point_out_of_terminal=true
  Ns_3: Coil Terminal Objects=Ns3_Section1 Conductor_number=1 Winding=Secondary Point_out_of_terminal=true
  Ns_4: Coil Terminal Objects=Ns4_Section1 Conductor_number=1 Winding=Secondary Point_out_of_terminal=true
  Ns_5: Coil Terminal Objects=Ns5_Section1 Conductor_number=1 Winding=Secondary Point_out_of_terminal=true
  Ns_6: Coil Terminal Objects=Ns6_Section1 Conductor_number=1 Winding=Secondary Point_out_of_terminal=true
  Ns_7: Coil Terminal Objects=Ns7_Section1 Conductor_number=1 Winding=Secondary Point_out_of_terminal=true
  Ns_8: Coil Terminal Objects=Ns8_Section1 Conductor_number=1 Winding=Secondary Point_out_of_terminal=true
  Ns_9: Coil Terminal Objects=Ns9_Section1 Conductor_number=1 Winding=Secondary Point_out_of_terminal=true
  Ns_10: Coil Terminal Objects=Ns10_Section1 Conductor_number=1 Winding=Secondary Point_out_of_terminal=true
  Ns_11: Coil Terminal Objects=Ns11_Section1 Conductor_number=1 Winding=Secondary Point_out_of_terminal=true
  Ns_12: Coil Terminal Objects=Ns12_Section1 Conductor_number=1 Winding=Secondary Point_out_of_terminal=true
  Primary: Winding Group Type=Current IsSolid=true Current=20A ParallelBranchesNum=1
  Secondary: Winding Group Type=Current IsSolid=true Current=0mA ParallelBranchesNum=1
parameters:
  Matrix1: Matrix Primary, Secondary: NumberOfTurns=1
mesh:
  Length1: LengthBased Objects=[Np1..Np12, Ns1..Ns12, plate_1, plate_2] MaxLength=3mm
  Length2: LengthBased Objects=[Body1, Body1_2, Body1_1, Body1_3, Body1_5, Body1_4] MaxLength=3mm
  initial mesh: GlobalCurvilinear{Apply} MeshMethod=AnsoftClassic
setups:
  Setup1: Magnetostatic MaximumPasses=10 MinimumPasses=2 MinimumConvergedPasses=1 PercentRefinement=30 PercentError=1 NonLinearResidual=0.001

design 0.30_edgewise_3D1 (Maxwell 3D, EddyCurrent, model units mm)
geometry:
  Region [vacuum] = region(percentage_offset=0 on all sides)
  plate_1, plate_2 [FR4_epoxy] = imported_body(C:\Users\karlr\Documents\0.3_edgewise.step)
  Np1, Np10, Np11, Np12, Np2..Np9, Ns1, Ns10, Ns11, Ns12, Ns2..Ns9 [copper] = imported_body(C:\Users\karlr\Documents\0.3_edgewise.step)
  Body1 [ferrite] = imported_body(C:\Users\karlr\Documents\0.3_edgewise.step)
  Body1_1, Body1_2 [aluminum] = imported_body(C:\Users\karlr\Documents\0.3_edgewise.step)
  Body1_3 [ferrite] = imported_body(C:\Users\karlr\Documents\0.3_edgewise.step)
  Body1_4, Body1_5 [aluminum] = imported_body(C:\Users\karlr\Documents\0.3_edgewise.step)
  Np1_Section1 [copper] = Np1.section(plane=ZX)
  Np2_Section1 [copper] = Np2.section(plane=ZX)
  Np3_Section1 [copper] = Np3.section(plane=ZX)
  Np4_Section1 [copper] = Np4.section(plane=ZX)
  Np5_Section1 [copper] = Np5.section(plane=ZX)
  Np6_Section1 [copper] = Np6.section(plane=ZX)
  Np7_Section1 [copper] = Np7.section(plane=ZX)
  Np8_Section1 [copper] = Np8.section(plane=ZX)
  Np9_Section1 [copper] = Np9.section(plane=ZX)
  Np10_Section1 [copper] = Np10.section(plane=ZX)
  Np11_Section1 [copper] = Np11.section(plane=ZX)
  Np12_Section1 [copper] = Np12.section(plane=ZX)
  Ns1_Section1 [copper] = Ns1.section(plane=ZX)
  Ns2_Section1 [copper] = Ns2.section(plane=ZX)
  Ns3_Section1 [copper] = Ns3.section(plane=ZX)
  Ns4_Section1 [copper] = Ns4.section(plane=ZX)
  Ns5_Section1 [copper] = Ns5.section(plane=ZX)
  Ns6_Section1 [copper] = Ns6.section(plane=ZX)
  Ns7_Section1 [copper] = Ns7.section(plane=ZX)
  Ns8_Section1 [copper] = Ns8.section(plane=ZX)
  Ns9_Section1 [copper] = Ns9.section(plane=ZX)
  Ns10_Section1 [copper] = Ns10.section(plane=ZX)
  Ns11_Section1 [copper] = Ns11.section(plane=ZX)
  Ns12_Section1 [copper] = Ns12.section(plane=ZX)
  Np1_Section1.separate_bodies()
  Np2_Section1.separate_bodies()
  Np3_Section1.separate_bodies()
  Np4_Section1.separate_bodies()
  Np5_Section1.separate_bodies()
  Np6_Section1.separate_bodies()
  Np7_Section1.separate_bodies()
  Np8_Section1.separate_bodies()
  Np9_Section1.separate_bodies()
  Np10_Section1.separate_bodies()
  Np11_Section1.separate_bodies()
  Np12_Section1.separate_bodies()
  Ns1_Section1.separate_bodies()
  Ns2_Section1.separate_bodies()
  Ns3_Section1.separate_bodies()
  Ns4_Section1.separate_bodies()
  Ns5_Section1.separate_bodies()
  Ns6_Section1.separate_bodies()
  Ns7_Section1.separate_bodies()
  Ns8_Section1.separate_bodies()
  Ns9_Section1.separate_bodies()
  Ns10_Section1.separate_bodies()
  Ns11_Section1.separate_bodies()
  Ns12_Section1.separate_bodies()
  Rectangle1 [non-model] = rectangle(corner=(18mm, -10mm, 0mm), y_size=34mm, z_size=20mm)
  Rectangle2 [non-model] = rectangle(corner=(39.8mm, 7.09649239mm, 0mm), z_size=19.7mm, x_size=-39.8mm)
  Rectangle3 [non-model] = rectangle(corner=(5.2mm, -9.7mm, 11.65mm), x_size=29.4mm, y_size=33.59298478mm)
  group core_assembled_edgewise = plate_1, plate_2, Np1, Np10, Np11, Np12, Np2..Np9, Ns1, Ns10, Ns11, Ns12, Ns2..Ns9, Np1_Section1, Np2_Section1, Np3_Section1, Np4_Section1, Np5_Section1, Np6_Section1, Np7_Section1, Np8_Section1, Np9_Section1, Np10_Section1, Np11_Section1, Np12_Section1, Ns1_Section1, Ns2_Section1, Ns3_Section1, Ns4_Section1, Ns5_Section1, Ns6_Section1, Ns7_Section1, Ns8_Section1, Ns9_Section1, Ns10_Section1, Ns11_Section1, Ns12_Section1
  group core_together_1 = Body1, Body1_1, Body1_2
  group core_together = Body1_3, Body1_4, Body1_5
boundaries and excitations:
  Np_1: Coil Terminal Objects=Np1_Section1 Conductor_number=1 Winding=Primary Point_out_of_terminal=false
  Np_2: Coil Terminal Objects=Np2_Section1 Conductor_number=1 Winding=Primary Point_out_of_terminal=false
  Np_3: Coil Terminal Objects=Np3_Section1 Conductor_number=1 Winding=Primary Point_out_of_terminal=false
  Np_4: Coil Terminal Objects=Np4_Section1 Conductor_number=1 Winding=Primary Point_out_of_terminal=false
  Np_5: Coil Terminal Objects=Np5_Section1 Conductor_number=1 Winding=Primary Point_out_of_terminal=false
  Np_6: Coil Terminal Objects=Np6_Section1 Conductor_number=1 Winding=Primary Point_out_of_terminal=false
  Np_7: Coil Terminal Objects=Np7_Section1 Conductor_number=1 Winding=Primary Point_out_of_terminal=false
  Np_8: Coil Terminal Objects=Np8_Section1 Conductor_number=1 Winding=Primary Point_out_of_terminal=false
  Np_9: Coil Terminal Objects=Np9_Section1 Conductor_number=1 Winding=Primary Point_out_of_terminal=false
  Np_10: Coil Terminal Objects=Np10_Section1 Conductor_number=1 Winding=Primary Point_out_of_terminal=false
  Np_11: Coil Terminal Objects=Np11_Section1 Conductor_number=1 Winding=Primary Point_out_of_terminal=false
  Np_12: Coil Terminal Objects=Np12_Section1 Conductor_number=1 Winding=Primary Point_out_of_terminal=false
  Ns_1: Coil Terminal Objects=Ns1_Section1 Conductor_number=1 Winding=Secondary Point_out_of_terminal=true
  Ns_2: Coil Terminal Objects=Ns2_Section1 Conductor_number=1 Winding=Secondary Point_out_of_terminal=true
  Ns_3: Coil Terminal Objects=Ns3_Section1 Conductor_number=1 Winding=Secondary Point_out_of_terminal=true
  Ns_4: Coil Terminal Objects=Ns4_Section1 Conductor_number=1 Winding=Secondary Point_out_of_terminal=true
  Ns_5: Coil Terminal Objects=Ns5_Section1 Conductor_number=1 Winding=Secondary Point_out_of_terminal=true
  Ns_6: Coil Terminal Objects=Ns6_Section1 Conductor_number=1 Winding=Secondary Point_out_of_terminal=true
  Ns_7: Coil Terminal Objects=Ns7_Section1 Conductor_number=1 Winding=Secondary Point_out_of_terminal=true
  Ns_8: Coil Terminal Objects=Ns8_Section1 Conductor_number=1 Winding=Secondary Point_out_of_terminal=true
  Ns_9: Coil Terminal Objects=Ns9_Section1 Conductor_number=1 Winding=Secondary Point_out_of_terminal=true
  Ns_10: Coil Terminal Objects=Ns10_Section1 Conductor_number=1 Winding=Secondary Point_out_of_terminal=true
  Ns_11: Coil Terminal Objects=Ns11_Section1 Conductor_number=1 Winding=Secondary Point_out_of_terminal=true
  Ns_12: Coil Terminal Objects=Ns12_Section1 Conductor_number=1 Winding=Secondary Point_out_of_terminal=true
  Primary: Winding Group Type=Current IsSolid=true Current=14.142A ParallelBranchesNum=1 Phase=0deg
  Secondary: Winding Group Type=Current IsSolid=true Current=13.942A ParallelBranchesNum=1 Phase=0deg
parameters:
  Matrix1: Matrix Primary, Secondary:
mesh:
  Length1: LengthBased Objects=[Np1..Np12, Ns1..Ns12, plate_1, plate_2] MaxLength=3mm
  Length2: LengthBased Objects=[Body1_4, Body1_5, Body1_3, Body1_1, Body1_2, Body1] MaxLength=3mm
  initial mesh: GlobalSurfApproximation{CurvedSurfaceApproxChoice=UseSlider SliderMeshSettings=9} GlobalCurvilinear{Apply}
setups:
  Setup1: EddyCurrent MaximumPasses=15 MinimumPasses=2 MinimumConvergedPasses=1 PercentRefinement=30 PercentError=3 NonLinearResidual=0.0001 Frequency=30000Hz SweepRanges{1Hz to 300001Hz step 10000Hz} SaveAllFields LossAdaptiveCtrl=0.5
field plots:
  Mag_J1: J over a plane on Setup1 : LastAdaptive at Freq=1Hz Phase=45deg
reports:
  Coupling Coeff Table1: Matrix1.CplCoef(Primary,Primary), Matrix1.L(Primary,Primary), Matrix1.R(Primary,Primary), Matrix1.R(Primary,Secondary), Matrix1.R(Secondary,Secondary) vs Freq on Setup1 : LastAdaptive

design 0.20_edgewise_3D1 (Maxwell 3D, EddyCurrent, model units mm)
geometry:
  Region [vacuum] = region(percentage_offset=0 on all sides)
  Np1, Np10, Np11, Np12, Np2..Np9, Ns1, Ns10, Ns11, Ns12, Ns2..Ns9 [copper] = imported_body(C:\Users\karlr\Documents\0.2_edgewise.step)
  plate_1, plate_2 [FR4_epoxy] = imported_body(C:\Users\karlr\Documents\0.2_edgewise.step)
  Body1 [ferrite] = imported_body(C:\Users\karlr\Documents\0.2_edgewise.step)
  Body1_1, Body1_2 [aluminum] = imported_body(C:\Users\karlr\Documents\0.2_edgewise.step)
  Body1_3 [ferrite] = imported_body(C:\Users\karlr\Documents\0.2_edgewise.step)
  Body1_4, Body1_5 [aluminum] = imported_body(C:\Users\karlr\Documents\0.2_edgewise.step)
  Np1_Section1 [copper] = Np1.section(plane=ZX)
  Np2_Section1 [copper] = Np2.section(plane=ZX)
  Np3_Section1 [copper] = Np3.section(plane=ZX)
  Np4_Section1 [copper] = Np4.section(plane=ZX)
  Np5_Section1 [copper] = Np5.section(plane=ZX)
  Np6_Section1 [copper] = Np6.section(plane=ZX)
  Np7_Section1 [copper] = Np7.section(plane=ZX)
  Np8_Section1 [copper] = Np8.section(plane=ZX)
  Np9_Section1 [copper] = Np9.section(plane=ZX)
  Np10_Section1 [copper] = Np10.section(plane=ZX)
  Np11_Section1 [copper] = Np11.section(plane=ZX)
  Np12_Section1 [copper] = Np12.section(plane=ZX)
  Ns1_Section1 [copper] = Ns1.section(plane=ZX)
  Ns2_Section1 [copper] = Ns2.section(plane=ZX)
  Ns3_Section1 [copper] = Ns3.section(plane=ZX)
  Ns4_Section1 [copper] = Ns4.section(plane=ZX)
  Ns5_Section1 [copper] = Ns5.section(plane=ZX)
  Ns6_Section1 [copper] = Ns6.section(plane=ZX)
  Ns7_Section1 [copper] = Ns7.section(plane=ZX)
  Ns8_Section1 [copper] = Ns8.section(plane=ZX)
  Ns9_Section1 [copper] = Ns9.section(plane=ZX)
  Ns10_Section1 [copper] = Ns10.section(plane=ZX)
  Ns11_Section1 [copper] = Ns11.section(plane=ZX)
  Ns12_Section1 [copper] = Ns12.section(plane=ZX)
  Np1_Section1.separate_bodies()
  Np2_Section1.separate_bodies()
  Np3_Section1.separate_bodies()
  Np4_Section1.separate_bodies()
  Np5_Section1.separate_bodies()
  Np6_Section1.separate_bodies()
  Np7_Section1.separate_bodies()
  Np8_Section1.separate_bodies()
  Np9_Section1.separate_bodies()
  Np10_Section1.separate_bodies()
  Np11_Section1.separate_bodies()
  Np12_Section1.separate_bodies()
  Ns1_Section1.separate_bodies()
  Ns2_Section1.separate_bodies()
  Ns3_Section1.separate_bodies()
  Ns4_Section1.separate_bodies()
  Ns5_Section1.separate_bodies()
  Ns6_Section1.separate_bodies()
  Ns7_Section1.separate_bodies()
  Ns8_Section1.separate_bodies()
  Ns9_Section1.separate_bodies()
  Ns10_Section1.separate_bodies()
  Ns11_Section1.separate_bodies()
  Ns12_Section1.separate_bodies()
  group core_assembled_edgewise = Np1, Np10, Np11, Np12, Np2..Np9, Ns1, Ns10, Ns11, Ns12, Ns2..Ns9, plate_1, plate_2, Np1_Section1, Np2_Section1, Np3_Section1, Np4_Section1, Np5_Section1, Np6_Section1, Np7_Section1, Np8_Section1, Np9_Section1, Np10_Section1, Np11_Section1, Np12_Section1, Ns1_Section1, Ns2_Section1, Ns3_Section1, Ns4_Section1, Ns5_Section1, Ns6_Section1, Ns7_Section1, Ns8_Section1, Ns9_Section1, Ns10_Section1, Ns11_Section1, Ns12_Section1
  group core_together_1 = Body1, Body1_1, Body1_2
  group core_together = Body1_3, Body1_4, Body1_5
boundaries and excitations:
  Np_1: Coil Terminal Objects=Np1_Section1 Conductor_number=1 Winding=Primary Point_out_of_terminal=false
  Np_2: Coil Terminal Objects=Np2_Section1 Conductor_number=1 Winding=Primary Point_out_of_terminal=false
  Np_3: Coil Terminal Objects=Np3_Section1 Conductor_number=1 Winding=Primary Point_out_of_terminal=false
  Np_4: Coil Terminal Objects=Np4_Section1 Conductor_number=1 Winding=Primary Point_out_of_terminal=false
  Np_5: Coil Terminal Objects=Np5_Section1 Conductor_number=1 Winding=Primary Point_out_of_terminal=false
  Np_6: Coil Terminal Objects=Np6_Section1 Conductor_number=1 Winding=Primary Point_out_of_terminal=false
  Np_7: Coil Terminal Objects=Np7_Section1 Conductor_number=1 Winding=Primary Point_out_of_terminal=false
  Np_8: Coil Terminal Objects=Np8_Section1 Conductor_number=1 Winding=Primary Point_out_of_terminal=false
  Np_9: Coil Terminal Objects=Np9_Section1 Conductor_number=1 Winding=Primary Point_out_of_terminal=false
  Np_10: Coil Terminal Objects=Np10_Section1 Conductor_number=1 Winding=Primary Point_out_of_terminal=false
  Np_11: Coil Terminal Objects=Np11_Section1 Conductor_number=1 Winding=Primary Point_out_of_terminal=false
  Np_12: Coil Terminal Objects=Np12_Section1 Conductor_number=1 Winding=Primary Point_out_of_terminal=false
  Ns_1: Coil Terminal Objects=Ns1_Section1 Conductor_number=1 Winding=Secondary Point_out_of_terminal=true
  Ns_2: Coil Terminal Objects=Ns2_Section1 Conductor_number=1 Winding=Secondary Point_out_of_terminal=true
  Ns_3: Coil Terminal Objects=Ns3_Section1 Conductor_number=1 Winding=Secondary Point_out_of_terminal=true
  Ns_4: Coil Terminal Objects=Ns4_Section1 Conductor_number=1 Winding=Secondary Point_out_of_terminal=true
  Ns_5: Coil Terminal Objects=Ns5_Section1 Conductor_number=1 Winding=Secondary Point_out_of_terminal=true
  Ns_6: Coil Terminal Objects=Ns6_Section1 Conductor_number=1 Winding=Secondary Point_out_of_terminal=true
  Ns_7: Coil Terminal Objects=Ns7_Section1 Conductor_number=1 Winding=Secondary Point_out_of_terminal=true
  Ns_8: Coil Terminal Objects=Ns8_Section1 Conductor_number=1 Winding=Secondary Point_out_of_terminal=true
  Ns_9: Coil Terminal Objects=Ns9_Section1 Conductor_number=1 Winding=Secondary Point_out_of_terminal=true
  Ns_10: Coil Terminal Objects=Ns10_Section1 Conductor_number=1 Winding=Secondary Point_out_of_terminal=true
  Ns_11: Coil Terminal Objects=Ns11_Section1 Conductor_number=1 Winding=Secondary Point_out_of_terminal=true
  Ns_12: Coil Terminal Objects=Ns12_Section1 Conductor_number=1 Winding=Secondary Point_out_of_terminal=true
  Primary: Winding Group Type=Current IsSolid=true Current=14.142A ParallelBranchesNum=1 Phase=0deg
  Secondary: Winding Group Type=Current IsSolid=true Current=13.942A ParallelBranchesNum=1 Phase=2deg
parameters:
  Matrix1: Matrix Primary, Secondary:
mesh:
  Length1: LengthBased Objects=[Np1..Np12, Ns1..Ns12, plate_1, plate_2] MaxLength=3mm
  Length2: LengthBased Objects=[Body1_1, Body1_2, Body1, Body1_3, Body1_5, Body1_4] MaxLength=3mm
  initial mesh: GlobalSurfApproximation{CurvedSurfaceApproxChoice=UseSlider SliderMeshSettings=9} GlobalCurvilinear{Apply}
setups:
  Setup1: EddyCurrent MaximumPasses=15 MinimumPasses=2 MinimumConvergedPasses=1 PercentRefinement=30 PercentError=3 NonLinearResidual=0.0001 Frequency=30000Hz SweepRanges{1Hz to 300001Hz step 10000Hz} SaveAllFields LossAdaptiveCtrl=0.5
reports:
  Coupling Coeff Table1: Matrix1.CplCoef(Primary,Primary), Matrix1.L(Primary,Primary), Matrix1.R(Primary,Primary), Matrix1.R(Primary,Secondary), Matrix1.R(Secondary,Secondary) vs Freq on Setup1 : LastAdaptive

design 0.25_edgewise_3D1 (Maxwell 3D, EddyCurrent, model units mm)
geometry:
  Region [vacuum] = region(percentage_offset=0 on all sides)
  plate_1, plate_2 [FR4_epoxy] = imported_body(C:\Users\karlr\Documents\0.25_edgewise.step)
  Np1, Np10, Np11, Np12, Np2..Np9, Ns1, Ns10, Ns11, Ns12, Ns2..Ns9 [copper] = imported_body(C:\Users\karlr\Documents\0.25_edgewise.step)
  Body1 [ferrite] = imported_body(C:\Users\karlr\Documents\0.25_edgewise.step)
  Body1_1, Body1_2 [aluminum] = imported_body(C:\Users\karlr\Documents\0.25_edgewise.step)
  Body1_3 [ferrite] = imported_body(C:\Users\karlr\Documents\0.25_edgewise.step)
  Body1_4, Body1_5 [aluminum] = imported_body(C:\Users\karlr\Documents\0.25_edgewise.step)
  Np1_Section1 [copper] = Np1.section(plane=ZX)
  Np2_Section1 [copper] = Np2.section(plane=ZX)
  Np3_Section1 [copper] = Np3.section(plane=ZX)
  Np4_Section1 [copper] = Np4.section(plane=ZX)
  Np5_Section1 [copper] = Np5.section(plane=ZX)
  Np6_Section1 [copper] = Np6.section(plane=ZX)
  Np7_Section1 [copper] = Np7.section(plane=ZX)
  Np8_Section1 [copper] = Np8.section(plane=ZX)
  Np9_Section1 [copper] = Np9.section(plane=ZX)
  Np10_Section1 [copper] = Np10.section(plane=ZX)
  Np11_Section1 [copper] = Np11.section(plane=ZX)
  Np12_Section1 [copper] = Np12.section(plane=ZX)
  Ns1_Section1 [copper] = Ns1.section(plane=ZX)
  Ns2_Section1 [copper] = Ns2.section(plane=ZX)
  Ns3_Section1 [copper] = Ns3.section(plane=ZX)
  Ns4_Section1 [copper] = Ns4.section(plane=ZX)
  Ns5_Section1 [copper] = Ns5.section(plane=ZX)
  Ns6_Section1 [copper] = Ns6.section(plane=ZX)
  Ns7_Section1 [copper] = Ns7.section(plane=ZX)
  Ns8_Section1 [copper] = Ns8.section(plane=ZX)
  Ns9_Section1 [copper] = Ns9.section(plane=ZX)
  Ns10_Section1 [copper] = Ns10.section(plane=ZX)
  Ns11_Section1 [copper] = Ns11.section(plane=ZX)
  Ns12_Section1 [copper] = Ns12.section(plane=ZX)
  Np1_Section1.separate_bodies()
  Np2_Section1.separate_bodies()
  Np3_Section1.separate_bodies()
  Np4_Section1.separate_bodies()
  Np5_Section1.separate_bodies()
  Np6_Section1.separate_bodies()
  Np7_Section1.separate_bodies()
  Np8_Section1.separate_bodies()
  Np9_Section1.separate_bodies()
  Np10_Section1.separate_bodies()
  Np11_Section1.separate_bodies()
  Np12_Section1.separate_bodies()
  Ns1_Section1.separate_bodies()
  Ns2_Section1.separate_bodies()
  Ns3_Section1.separate_bodies()
  Ns4_Section1.separate_bodies()
  Ns5_Section1.separate_bodies()
  Ns6_Section1.separate_bodies()
  Ns7_Section1.separate_bodies()
  Ns8_Section1.separate_bodies()
  Ns9_Section1.separate_bodies()
  Ns10_Section1.separate_bodies()
  Ns11_Section1.separate_bodies()
  Ns12_Section1.separate_bodies()
  group core_assembled_edgewise = plate_1, plate_2, Np1, Np10, Np11, Np12, Np2..Np9, Ns1, Ns10, Ns11, Ns12, Ns2..Ns9, Np1_Section1, Np2_Section1, Np3_Section1, Np4_Section1, Np5_Section1, Np6_Section1, Np7_Section1, Np8_Section1, Np9_Section1, Np10_Section1, Np11_Section1, Np12_Section1, Ns1_Section1, Ns2_Section1, Ns3_Section1, Ns4_Section1, Ns5_Section1, Ns6_Section1, Ns7_Section1, Ns8_Section1, Ns9_Section1, Ns10_Section1, Ns11_Section1, Ns12_Section1
  group core_together_1 = Body1, Body1_1, Body1_2
  group core_together = Body1_3, Body1_4, Body1_5
boundaries and excitations:
  Np_1: Coil Terminal Objects=Np1_Section1 Conductor_number=1 Winding=Primary Point_out_of_terminal=false
  Np_2: Coil Terminal Objects=Np2_Section1 Conductor_number=1 Winding=Primary Point_out_of_terminal=false
  Np_3: Coil Terminal Objects=Np3_Section1 Conductor_number=1 Winding=Primary Point_out_of_terminal=false
  Np_4: Coil Terminal Objects=Np4_Section1 Conductor_number=1 Winding=Primary Point_out_of_terminal=false
  Np_5: Coil Terminal Objects=Np5_Section1 Conductor_number=1 Winding=Primary Point_out_of_terminal=false
  Np_6: Coil Terminal Objects=Np6_Section1 Conductor_number=1 Winding=Primary Point_out_of_terminal=false
  Np_7: Coil Terminal Objects=Np7_Section1 Conductor_number=1 Winding=Primary Point_out_of_terminal=false
  Np_8: Coil Terminal Objects=Np8_Section1 Conductor_number=1 Winding=Primary Point_out_of_terminal=false
  Np_9: Coil Terminal Objects=Np9_Section1 Conductor_number=1 Winding=Primary Point_out_of_terminal=false
  Np_10: Coil Terminal Objects=Np10_Section1 Conductor_number=1 Winding=Primary Point_out_of_terminal=false
  Np_11: Coil Terminal Objects=Np11_Section1 Conductor_number=1 Winding=Primary Point_out_of_terminal=false
  Np_12: Coil Terminal Objects=Np12_Section1 Conductor_number=1 Winding=Primary Point_out_of_terminal=false
  Ns_1: Coil Terminal Objects=Ns1_Section1 Conductor_number=1 Winding=Secondary Point_out_of_terminal=true
  Ns_2: Coil Terminal Objects=Ns2_Section1 Conductor_number=1 Winding=Secondary Point_out_of_terminal=true
  Ns_3: Coil Terminal Objects=Ns3_Section1 Conductor_number=1 Winding=Secondary Point_out_of_terminal=true
  Ns_4: Coil Terminal Objects=Ns4_Section1 Conductor_number=1 Winding=Secondary Point_out_of_terminal=true
  Ns_5: Coil Terminal Objects=Ns5_Section1 Conductor_number=1 Winding=Secondary Point_out_of_terminal=true
  Ns_6: Coil Terminal Objects=Ns6_Section1 Conductor_number=1 Winding=Secondary Point_out_of_terminal=true
  Ns_7: Coil Terminal Objects=Ns7_Section1 Conductor_number=1 Winding=Secondary Point_out_of_terminal=true
  Ns_8: Coil Terminal Objects=Ns8_Section1 Conductor_number=1 Winding=Secondary Point_out_of_terminal=true
  Ns_9: Coil Terminal Objects=Ns9_Section1 Conductor_number=1 Winding=Secondary Point_out_of_terminal=true
  Ns_10: Coil Terminal Objects=Ns10_Section1 Conductor_number=1 Winding=Secondary Point_out_of_terminal=true
  Ns_11: Coil Terminal Objects=Ns11_Section1 Conductor_number=1 Winding=Secondary Point_out_of_terminal=true
  Ns_12: Coil Terminal Objects=Ns12_Section1 Conductor_number=1 Winding=Secondary Point_out_of_terminal=true
  Primary: Winding Group Type=Current IsSolid=true Current=14.142A ParallelBranchesNum=1 Phase=0deg
  Secondary: Winding Group Type=Current IsSolid=true Current=13.942A ParallelBranchesNum=1 Phase=2deg
parameters:
  Matrix1: Matrix Primary, Secondary:
mesh:
  Length1: LengthBased Objects=[Np1..Np12, Ns1..Ns12, plate_1, plate_2] MaxLength=3mm
  Length2: LengthBased Objects=[Body1_4, Body1_5, Body1_3, Body1_1, Body1_2, Body1] MaxLength=3mm
  initial mesh: GlobalSurfApproximation{CurvedSurfaceApproxChoice=UseSlider SliderMeshSettings=9} GlobalCurvilinear{Apply}
setups:
  Setup1: EddyCurrent MaximumPasses=15 MinimumPasses=2 MinimumConvergedPasses=1 PercentRefinement=30 PercentError=3 NonLinearResidual=0.0001 Frequency=30000Hz SweepRanges{1Hz to 300001Hz step 10000Hz} SaveAllFields LossAdaptiveCtrl=0.5
reports:
  L Table1: Matrix1.L(Primary,Primary), Matrix1.CplCoef(Primary,Primary), Matrix1.R(Primary,Primary), Matrix1.R(Primary,Secondary), Matrix1.R(Secondary,Secondary) vs Freq on Setup1 : LastAdaptive

design 0.35_edgewise_3D1 (Maxwell 3D, EddyCurrent, model units mm)
geometry:
  Region [vacuum] = region(percentage_offset=0 on all sides)
  plate_1, plate_2 [FR4_epoxy] = imported_body(C:\Users\karlr\Documents\0.35_edgewise.step)
  Np1, Np10, Np11, Np12, Np2..Np9, Ns1, Ns10, Ns11, Ns12, Ns2..Ns9 [copper] = imported_body(C:\Users\karlr\Documents\0.35_edgewise.step)
  Body1 [ferrite] = imported_body(C:\Users\karlr\Documents\0.35_edgewise.step)
  Body1_1, Body1_2 [aluminum] = imported_body(C:\Users\karlr\Documents\0.35_edgewise.step)
  Body1_3 [ferrite] = imported_body(C:\Users\karlr\Documents\0.35_edgewise.step)
  Body1_4, Body1_5 [aluminum] = imported_body(C:\Users\karlr\Documents\0.35_edgewise.step)
  Np1_Section1 [copper] = Np1.section(plane=ZX)
  Np2_Section1 [copper] = Np2.section(plane=ZX)
  Np3_Section1 [copper] = Np3.section(plane=ZX)
  Np4_Section1 [copper] = Np4.section(plane=ZX)
  Np5_Section1 [copper] = Np5.section(plane=ZX)
  Np6_Section1 [copper] = Np6.section(plane=ZX)
  Np7_Section1 [copper] = Np7.section(plane=ZX)
  Np8_Section1 [copper] = Np8.section(plane=ZX)
  Np9_Section1 [copper] = Np9.section(plane=ZX)
  Np10_Section1 [copper] = Np10.section(plane=ZX)
  Np11_Section1 [copper] = Np11.section(plane=ZX)
  Np12_Section1 [copper] = Np12.section(plane=ZX)
  Ns1_Section1 [copper] = Ns1.section(plane=ZX)
  Ns2_Section1 [copper] = Ns2.section(plane=ZX)
  Ns3_Section1 [copper] = Ns3.section(plane=ZX)
  Ns4_Section1 [copper] = Ns4.section(plane=ZX)
  Ns5_Section1 [copper] = Ns5.section(plane=ZX)
  Ns6_Section1 [copper] = Ns6.section(plane=ZX)
  Ns7_Section1 [copper] = Ns7.section(plane=ZX)
  Ns8_Section1 [copper] = Ns8.section(plane=ZX)
  Ns9_Section1 [copper] = Ns9.section(plane=ZX)
  Ns10_Section1 [copper] = Ns10.section(plane=ZX)
  Ns11_Section1 [copper] = Ns11.section(plane=ZX)
  Ns12_Section1 [copper] = Ns12.section(plane=ZX)
  Np1_Section1.separate_bodies()
  Np2_Section1.separate_bodies()
  Np3_Section1.separate_bodies()
  Np4_Section1.separate_bodies()
  Np5_Section1.separate_bodies()
  Np6_Section1.separate_bodies()
  Np7_Section1.separate_bodies()
  Np8_Section1.separate_bodies()
  Np9_Section1.separate_bodies()
  Np10_Section1.separate_bodies()
  Np11_Section1.separate_bodies()
  Np12_Section1.separate_bodies()
  Ns1_Section1.separate_bodies()
  Ns2_Section1.separate_bodies()
  Ns3_Section1.separate_bodies()
  Ns4_Section1.separate_bodies()
  Ns5_Section1.separate_bodies()
  Ns6_Section1.separate_bodies()
  Ns7_Section1.separate_bodies()
  Ns8_Section1.separate_bodies()
  Ns9_Section1.separate_bodies()
  Ns10_Section1.separate_bodies()
  Ns11_Section1.separate_bodies()
  Ns12_Section1.separate_bodies()
  group core_assembled_edgewise = plate_1, plate_2, Np1, Np10, Np11, Np12, Np2..Np9, Ns1, Ns10, Ns11, Ns12, Ns2..Ns9, Np1_Section1, Np2_Section1, Np3_Section1, Np4_Section1, Np5_Section1, Np6_Section1, Np7_Section1, Np8_Section1, Np9_Section1, Np10_Section1, Np11_Section1, Np12_Section1, Ns1_Section1, Ns2_Section1, Ns3_Section1, Ns4_Section1, Ns5_Section1, Ns6_Section1, Ns7_Section1, Ns8_Section1, Ns9_Section1, Ns10_Section1, Ns11_Section1, Ns12_Section1
  group core_together_1 = Body1, Body1_1, Body1_2
  group core_together = Body1_3, Body1_4, Body1_5
boundaries and excitations:
  Np_1: Coil Terminal Objects=Np1_Section1 Conductor_number=1 Winding=Primary Point_out_of_terminal=false
  Np_2: Coil Terminal Objects=Np2_Section1 Conductor_number=1 Winding=Primary Point_out_of_terminal=false
  Np_3: Coil Terminal Objects=Np3_Section1 Conductor_number=1 Winding=Primary Point_out_of_terminal=false
  Np_4: Coil Terminal Objects=Np4_Section1 Conductor_number=1 Winding=Primary Point_out_of_terminal=false
  Np_5: Coil Terminal Objects=Np5_Section1 Conductor_number=1 Winding=Primary Point_out_of_terminal=false
  Np_6: Coil Terminal Objects=Np6_Section1 Conductor_number=1 Winding=Primary Point_out_of_terminal=false
  Np_7: Coil Terminal Objects=Np7_Section1 Conductor_number=1 Winding=Primary Point_out_of_terminal=false
  Np_8: Coil Terminal Objects=Np8_Section1 Conductor_number=1 Winding=Primary Point_out_of_terminal=false
  Np_9: Coil Terminal Objects=Np9_Section1 Conductor_number=1 Winding=Primary Point_out_of_terminal=false
  Np_10: Coil Terminal Objects=Np10_Section1 Conductor_number=1 Winding=Primary Point_out_of_terminal=false
  Np_11: Coil Terminal Objects=Np11_Section1 Conductor_number=1 Winding=Primary Point_out_of_terminal=false
  Np_12: Coil Terminal Objects=Np12_Section1 Conductor_number=1 Winding=Primary Point_out_of_terminal=false
  Ns_1: Coil Terminal Objects=Ns1_Section1 Conductor_number=1 Winding=Secondary Point_out_of_terminal=true
  Ns_2: Coil Terminal Objects=Ns2_Section1 Conductor_number=1 Winding=Secondary Point_out_of_terminal=true
  Ns_3: Coil Terminal Objects=Ns3_Section1 Conductor_number=1 Winding=Secondary Point_out_of_terminal=true
  Ns_4: Coil Terminal Objects=Ns4_Section1 Conductor_number=1 Winding=Secondary Point_out_of_terminal=true
  Ns_5: Coil Terminal Objects=Ns5_Section1 Conductor_number=1 Winding=Secondary Point_out_of_terminal=true
  Ns_6: Coil Terminal Objects=Ns6_Section1 Conductor_number=1 Winding=Secondary Point_out_of_terminal=true
  Ns_7: Coil Terminal Objects=Ns7_Section1 Conductor_number=1 Winding=Secondary Point_out_of_terminal=true
  Ns_8: Coil Terminal Objects=Ns8_Section1 Conductor_number=1 Winding=Secondary Point_out_of_terminal=true
  Ns_9: Coil Terminal Objects=Ns9_Section1 Conductor_number=1 Winding=Secondary Point_out_of_terminal=true
  Ns_10: Coil Terminal Objects=Ns10_Section1 Conductor_number=1 Winding=Secondary Point_out_of_terminal=true
  Ns_11: Coil Terminal Objects=Ns11_Section1 Conductor_number=1 Winding=Secondary Point_out_of_terminal=true
  Ns_12: Coil Terminal Objects=Ns12_Section1 Conductor_number=1 Winding=Secondary Point_out_of_terminal=true
  Primary: Winding Group Type=Current IsSolid=true Current=14.142A ParallelBranchesNum=1 Phase=0deg
  Secondary: Winding Group Type=Current IsSolid=true Current=13.942A ParallelBranchesNum=1 Phase=2deg
parameters:
  Matrix1: Matrix Primary, Secondary:
mesh:
  Length1: LengthBased Objects=[Np1..Np12, Ns1..Ns12, plate_1, plate_2] MaxLength=3mm
  Length2: LengthBased Objects=[Body1_4, Body1_5, Body1_3, Body1_1, Body1_2, Body1] MaxLength=3mm
  initial mesh: GlobalSurfApproximation{CurvedSurfaceApproxChoice=UseSlider SliderMeshSettings=9} GlobalCurvilinear{Apply}
setups:
  Setup1: EddyCurrent MaximumPasses=15 MinimumPasses=2 MinimumConvergedPasses=1 PercentRefinement=30 PercentError=3 NonLinearResidual=0.0001 Frequency=30000Hz SweepRanges{1Hz to 300001Hz step 10000Hz} SaveAllFields LossAdaptiveCtrl=0.5
reports:
  L Table1: Matrix1.L(Primary,Primary), Matrix1.CplCoef(Primary,Primary), Matrix1.R(Primary,Primary), Matrix1.R(Primary,Secondary), Matrix1.R(Secondary,Secondary) vs Freq on Setup1 : LastAdaptive

design 0.40_edgewise_3D1 (Maxwell 3D, EddyCurrent, model units mm)
geometry:
  Region [vacuum] = region(percentage_offset=0 on all sides)
  plate_1, plate_2 [FR4_epoxy] = imported_body(C:\Users\karlr\Documents\0.4_edgewise.step)
  Np1, Np10, Np11, Np12, Np2..Np9, Ns1, Ns10, Ns11, Ns12, Ns2..Ns9 [copper] = imported_body(C:\Users\karlr\Documents\0.4_edgewise.step)
  Body1 [ferrite] = imported_body(C:\Users\karlr\Documents\0.4_edgewise.step)
  Body1_1, Body1_2 [aluminum] = imported_body(C:\Users\karlr\Documents\0.4_edgewise.step)
  Body1_3 [ferrite] = imported_body(C:\Users\karlr\Documents\0.4_edgewise.step)
  Body1_4, Body1_5 [aluminum] = imported_body(C:\Users\karlr\Documents\0.4_edgewise.step)
  Ns12_Section1 [copper] = Ns12.section(plane=ZX)
  Np1_Section1 [copper] = Np1.section(plane=ZX)
  Np2_Section1 [copper] = Np2.section(plane=ZX)
  Np3_Section1 [copper] = Np3.section(plane=ZX)
  Np4_Section1 [copper] = Np4.section(plane=ZX)
  Np5_Section1 [copper] = Np5.section(plane=ZX)
  Np6_Section1 [copper] = Np6.section(plane=ZX)
  Np7_Section1 [copper] = Np7.section(plane=ZX)
  Np8_Section1 [copper] = Np8.section(plane=ZX)
  Np9_Section1 [copper] = Np9.section(plane=ZX)
  Np10_Section1 [copper] = Np10.section(plane=ZX)
  Np11_Section1 [copper] = Np11.section(plane=ZX)
  Np12_Section1 [copper] = Np12.section(plane=ZX)
  Ns1_Section1 [copper] = Ns1.section(plane=ZX)
  Ns2_Section1 [copper] = Ns2.section(plane=ZX)
  Ns3_Section1 [copper] = Ns3.section(plane=ZX)
  Ns4_Section1 [copper] = Ns4.section(plane=ZX)
  Ns5_Section1 [copper] = Ns5.section(plane=ZX)
  Ns6_Section1 [copper] = Ns6.section(plane=ZX)
  Ns7_Section1 [copper] = Ns7.section(plane=ZX)
  Ns8_Section1 [copper] = Ns8.section(plane=ZX)
  Ns9_Section1 [copper] = Ns9.section(plane=ZX)
  Ns10_Section1 [copper] = Ns10.section(plane=ZX)
  Ns11_Section1 [copper] = Ns11.section(plane=ZX)
  Ns12_Section1.separate_bodies()
  Np1_Section1.separate_bodies()
  Np2_Section1.separate_bodies()
  Np3_Section1.separate_bodies()
  Np4_Section1.separate_bodies()
  Np5_Section1.separate_bodies()
  Np6_Section1.separate_bodies()
  Np7_Section1.separate_bodies()
  Np8_Section1.separate_bodies()
  Np9_Section1.separate_bodies()
  Np10_Section1.separate_bodies()
  Np11_Section1.separate_bodies()
  Np12_Section1.separate_bodies()
  Ns1_Section1.separate_bodies()
  Ns2_Section1.separate_bodies()
  Ns3_Section1.separate_bodies()
  Ns4_Section1.separate_bodies()
  Ns5_Section1.separate_bodies()
  Ns6_Section1.separate_bodies()
  Ns7_Section1.separate_bodies()
  Ns8_Section1.separate_bodies()
  Ns9_Section1.separate_bodies()
  Ns10_Section1.separate_bodies()
  Ns11_Section1.separate_bodies()
  group core_assembled_edgewise = plate_1, plate_2, Np1, Np10, Np11, Np12, Np2..Np9, Ns1, Ns10, Ns11, Ns12, Ns2..Ns9, Ns12_Section1, Np1_Section1, Np2_Section1, Np3_Section1, Np4_Section1, Np5_Section1, Np6_Section1, Np7_Section1, Np8_Section1, Np9_Section1, Np10_Section1, Np11_Section1, Np12_Section1, Ns1_Section1, Ns2_Section1, Ns3_Section1, Ns4_Section1, Ns5_Section1, Ns6_Section1, Ns7_Section1, Ns8_Section1, Ns9_Section1, Ns10_Section1, Ns11_Section1
  group core_together_1 = Body1, Body1_1, Body1_2
  group core_together = Body1_3, Body1_4, Body1_5
boundaries and excitations:
  Np_1: Coil Terminal Objects=Np1_Section1 Conductor_number=1 Winding=Primary Point_out_of_terminal=false
  Np_2: Coil Terminal Objects=Np2_Section1 Conductor_number=1 Winding=Primary Point_out_of_terminal=false
  Np_3: Coil Terminal Objects=Np3_Section1 Conductor_number=1 Winding=Primary Point_out_of_terminal=false
  Np_4: Coil Terminal Objects=Np4_Section1 Conductor_number=1 Winding=Primary Point_out_of_terminal=false
  Np_5: Coil Terminal Objects=Np5_Section1 Conductor_number=1 Winding=Primary Point_out_of_terminal=false
  Np_6: Coil Terminal Objects=Np6_Section1 Conductor_number=1 Winding=Primary Point_out_of_terminal=false
  Np_7: Coil Terminal Objects=Np7_Section1 Conductor_number=1 Winding=Primary Point_out_of_terminal=false
  Np_8: Coil Terminal Objects=Np8_Section1 Conductor_number=1 Winding=Primary Point_out_of_terminal=false
  Np_9: Coil Terminal Objects=Np9_Section1 Conductor_number=1 Winding=Primary Point_out_of_terminal=false
  Np_10: Coil Terminal Objects=Np10_Section1 Conductor_number=1 Winding=Primary Point_out_of_terminal=false
  Np_11: Coil Terminal Objects=Np11_Section1 Conductor_number=1 Winding=Primary Point_out_of_terminal=false
  Np_12: Coil Terminal Objects=Np12_Section1 Conductor_number=1 Winding=Primary Point_out_of_terminal=false
  Ns_1: Coil Terminal Objects=Ns1_Section1 Conductor_number=1 Winding=Secondary Point_out_of_terminal=true
  Ns_2: Coil Terminal Objects=Ns2_Section1 Conductor_number=1 Winding=Secondary Point_out_of_terminal=true
  Ns_3: Coil Terminal Objects=Ns3_Section1 Conductor_number=1 Winding=Secondary Point_out_of_terminal=true
  Ns_4: Coil Terminal Objects=Ns4_Section1 Conductor_number=1 Winding=Secondary Point_out_of_terminal=true
  Ns_5: Coil Terminal Objects=Ns5_Section1 Conductor_number=1 Winding=Secondary Point_out_of_terminal=true
  Ns_6: Coil Terminal Objects=Ns6_Section1 Conductor_number=1 Winding=Secondary Point_out_of_terminal=true
  Ns_7: Coil Terminal Objects=Ns7_Section1 Conductor_number=1 Winding=Secondary Point_out_of_terminal=true
  Ns_8: Coil Terminal Objects=Ns8_Section1 Conductor_number=1 Winding=Secondary Point_out_of_terminal=true
  Ns_9: Coil Terminal Objects=Ns9_Section1 Conductor_number=1 Winding=Secondary Point_out_of_terminal=true
  Ns_10: Coil Terminal Objects=Ns10_Section1 Conductor_number=1 Winding=Secondary Point_out_of_terminal=true
  Ns_11: Coil Terminal Objects=Ns11_Section1 Conductor_number=1 Winding=Secondary Point_out_of_terminal=true
  Ns_12: Coil Terminal Objects=Ns12_Section1 Conductor_number=1 Winding=Secondary Point_out_of_terminal=true
  Primary: Winding Group Type=Current IsSolid=true Current=14.142A ParallelBranchesNum=1 Phase=0deg
  Secondary: Winding Group Type=Current IsSolid=true Current=13.942A ParallelBranchesNum=1 Phase=2deg
parameters:
  Matrix1: Matrix Primary, Secondary:
mesh:
  Length1: LengthBased Objects=[Np1..Np12, Ns1..Ns12, plate_1, plate_2] MaxLength=3mm
  Length2: LengthBased Objects=[Body1, Body1_2, Body1_1, Body1_3, Body1_5, Body1_4] MaxLength=3mm
  initial mesh: GlobalCurvilinear{Apply} MeshMethod=AnsoftClassic
setups:
  Setup1: EddyCurrent MaximumPasses=15 MinimumPasses=2 MinimumConvergedPasses=1 PercentRefinement=30 PercentError=3 NonLinearResidual=0.0001 Frequency=30000Hz SweepRanges{1Hz to 300001Hz step 10000Hz} SaveAllFields LossAdaptiveCtrl=0.5
reports:
  Coupling Coeff Table1: Matrix1.CplCoef(Primary,Primary), Matrix1.L(Primary,Primary), Matrix1.R(Primary,Primary), Matrix1.R(Primary,Secondary), Matrix1.R(Secondary,Secondary) vs Freq on Setup1 : LastAdaptive

design 0.30_edgewise_3D2 (Maxwell 3D, EddyCurrent, model units mm)
geometry:
  Region [vacuum] = region(percentage_offset=0 on all sides)
  plate_1, plate_2 [FR4_epoxy] = imported_body(C:\Users\karlr\Documents\0.3_edgewise.step)
  Np1, Np10, Np11, Np12, Np2..Np9, Ns1, Ns10, Ns11, Ns12, Ns2..Ns9 [copper] = imported_body(C:\Users\karlr\Documents\0.3_edgewise.step)
  Body1 [ferrite] = imported_body(C:\Users\karlr\Documents\0.3_edgewise.step)
  Body1_1, Body1_2 [aluminum] = imported_body(C:\Users\karlr\Documents\0.3_edgewise.step)
  Body1_3 [ferrite] = imported_body(C:\Users\karlr\Documents\0.3_edgewise.step)
  Body1_4, Body1_5 [aluminum] = imported_body(C:\Users\karlr\Documents\0.3_edgewise.step)
  Np1_Section1 [copper] = Np1.section(plane=ZX)
  Np2_Section1 [copper] = Np2.section(plane=ZX)
  Np3_Section1 [copper] = Np3.section(plane=ZX)
  Np4_Section1 [copper] = Np4.section(plane=ZX)
  Np5_Section1 [copper] = Np5.section(plane=ZX)
  Np6_Section1 [copper] = Np6.section(plane=ZX)
  Np7_Section1 [copper] = Np7.section(plane=ZX)
  Np8_Section1 [copper] = Np8.section(plane=ZX)
  Np9_Section1 [copper] = Np9.section(plane=ZX)
  Np10_Section1 [copper] = Np10.section(plane=ZX)
  Np11_Section1 [copper] = Np11.section(plane=ZX)
  Np12_Section1 [copper] = Np12.section(plane=ZX)
  Ns1_Section1 [copper] = Ns1.section(plane=ZX)
  Ns2_Section1 [copper] = Ns2.section(plane=ZX)
  Ns3_Section1 [copper] = Ns3.section(plane=ZX)
  Ns4_Section1 [copper] = Ns4.section(plane=ZX)
  Ns5_Section1 [copper] = Ns5.section(plane=ZX)
  Ns6_Section1 [copper] = Ns6.section(plane=ZX)
  Ns7_Section1 [copper] = Ns7.section(plane=ZX)
  Ns8_Section1 [copper] = Ns8.section(plane=ZX)
  Ns9_Section1 [copper] = Ns9.section(plane=ZX)
  Ns10_Section1 [copper] = Ns10.section(plane=ZX)
  Ns11_Section1 [copper] = Ns11.section(plane=ZX)
  Ns12_Section1 [copper] = Ns12.section(plane=ZX)
  Np1_Section1.separate_bodies()
  Np2_Section1.separate_bodies()
  Np3_Section1.separate_bodies()
  Np4_Section1.separate_bodies()
  Np5_Section1.separate_bodies()
  Np6_Section1.separate_bodies()
  Np7_Section1.separate_bodies()
  Np8_Section1.separate_bodies()
  Np9_Section1.separate_bodies()
  Np10_Section1.separate_bodies()
  Np11_Section1.separate_bodies()
  Np12_Section1.separate_bodies()
  Ns1_Section1.separate_bodies()
  Ns2_Section1.separate_bodies()
  Ns3_Section1.separate_bodies()
  Ns4_Section1.separate_bodies()
  Ns5_Section1.separate_bodies()
  Ns6_Section1.separate_bodies()
  Ns7_Section1.separate_bodies()
  Ns8_Section1.separate_bodies()
  Ns9_Section1.separate_bodies()
  Ns10_Section1.separate_bodies()
  Ns11_Section1.separate_bodies()
  Ns12_Section1.separate_bodies()
  group core_assembled_edgewise = plate_1, plate_2, Np1, Np10, Np11, Np12, Np2..Np9, Ns1, Ns10, Ns11, Ns12, Ns2..Ns9, Np1_Section1, Np2_Section1, Np3_Section1, Np4_Section1, Np5_Section1, Np6_Section1, Np7_Section1, Np8_Section1, Np9_Section1, Np10_Section1, Np11_Section1, Np12_Section1, Ns1_Section1, Ns2_Section1, Ns3_Section1, Ns4_Section1, Ns5_Section1, Ns6_Section1, Ns7_Section1, Ns8_Section1, Ns9_Section1, Ns10_Section1, Ns11_Section1, Ns12_Section1
  group core_together_1 = Body1, Body1_1, Body1_2
  group core_together = Body1_3, Body1_4, Body1_5
boundaries and excitations:
  Np_1: Coil Terminal Objects=Np1_Section1 Conductor_number=1 Winding=Primary Point_out_of_terminal=false
  Np_2: Coil Terminal Objects=Np2_Section1 Conductor_number=1 Winding=Primary Point_out_of_terminal=false
  Np_3: Coil Terminal Objects=Np3_Section1 Conductor_number=1 Winding=Primary Point_out_of_terminal=false
  Np_4: Coil Terminal Objects=Np4_Section1 Conductor_number=1 Winding=Primary Point_out_of_terminal=false
  Np_5: Coil Terminal Objects=Np5_Section1 Conductor_number=1 Winding=Primary Point_out_of_terminal=false
  Np_6: Coil Terminal Objects=Np6_Section1 Conductor_number=1 Winding=Primary Point_out_of_terminal=false
  Np_7: Coil Terminal Objects=Np7_Section1 Conductor_number=1 Winding=Secondary Point_out_of_terminal=true
  Np_8: Coil Terminal Objects=Np8_Section1 Conductor_number=1 Winding=Secondary Point_out_of_terminal=true
  Np_9: Coil Terminal Objects=Np9_Section1 Conductor_number=1 Winding=Secondary Point_out_of_terminal=true
  Np_10: Coil Terminal Objects=Np10_Section1 Conductor_number=1 Winding=Secondary Point_out_of_terminal=true
  Np_11: Coil Terminal Objects=Np11_Section1 Conductor_number=1 Winding=Secondary Point_out_of_terminal=true
  Np_12: Coil Terminal Objects=Np12_Section1 Conductor_number=1 Winding=Secondary Point_out_of_terminal=true
  Ns_1: Coil Terminal Objects=Ns1_Section1 Conductor_number=1 Winding=Primary Point_out_of_terminal=false
  Ns_2: Coil Terminal Objects=Ns2_Section1 Conductor_number=1 Winding=Primary Point_out_of_terminal=false
  Ns_3: Coil Terminal Objects=Ns3_Section1 Conductor_number=1 Winding=Primary Point_out_of_terminal=false
  Ns_4: Coil Terminal Objects=Ns4_Section1 Conductor_number=1 Winding=Primary Point_out_of_terminal=false
  Ns_5: Coil Terminal Objects=Ns5_Section1 Conductor_number=1 Winding=Primary Point_out_of_terminal=false
  Ns_6: Coil Terminal Objects=Ns6_Section1 Conductor_number=1 Winding=Primary Point_out_of_terminal=false
  Ns_7: Coil Terminal Objects=Ns7_Section1 Conductor_number=1 Winding=Secondary Point_out_of_terminal=true
  Ns_8: Coil Terminal Objects=Ns8_Section1 Conductor_number=1 Winding=Secondary Point_out_of_terminal=true
  Ns_9: Coil Terminal Objects=Ns9_Section1 Conductor_number=1 Winding=Secondary Point_out_of_terminal=true
  Ns_10: Coil Terminal Objects=Ns10_Section1 Conductor_number=1 Winding=Secondary Point_out_of_terminal=true
  Ns_11: Coil Terminal Objects=Ns11_Section1 Conductor_number=1 Winding=Secondary Point_out_of_terminal=true
  Ns_12: Coil Terminal Objects=Ns12_Section1 Conductor_number=1 Winding=Secondary Point_out_of_terminal=true
  Primary: Winding Group Type=Current IsSolid=true Current=14.142A ParallelBranchesNum=1 Phase=0deg
  Secondary: Winding Group Type=Current IsSolid=true Current=13.942A ParallelBranchesNum=1 Phase=0deg
parameters:
  Matrix1: Matrix Primary, Secondary:
mesh:
  Length1: LengthBased Objects=[Np1..Np12, Ns1..Ns12, plate_1, plate_2] MaxLength=3mm
  Length2: LengthBased Objects=[Body1_4, Body1_5, Body1_3, Body1_1, Body1_2, Body1] MaxLength=3mm
  initial mesh: GlobalSurfApproximation{CurvedSurfaceApproxChoice=UseSlider SliderMeshSettings=9} GlobalCurvilinear{Apply}
setups:
  Setup1: EddyCurrent MaximumPasses=15 MinimumPasses=2 MinimumConvergedPasses=1 PercentRefinement=30 PercentError=1.5 NonLinearResidual=0.0001 Frequency=30000Hz SweepRanges{1Hz to 300001Hz step 10000Hz} SaveAllFields LossAdaptiveCtrl=0.5
reports:
  Coupling Coeff Table1: Matrix1.CplCoef(Primary,Primary), Matrix1.L(Primary,Primary), Matrix1.R(Primary,Primary), Matrix1.R(Primary,Secondary), Matrix1.R(Secondary,Secondary) vs Freq on Setup1 : LastAdaptive

design 0.30_edgewise_3D3 (Maxwell 3D, EddyCurrent, model units mm)
geometry:
  Region [vacuum] = region(percentage_offset=0 on all sides)
  plate_1, plate_2 [FR4_epoxy] = imported_body(C:\Users\karlr\Documents\0.3_edgewise.step)
  Np1, Np10, Np11, Np12, Np2..Np9, Ns1, Ns10, Ns11, Ns12, Ns2..Ns9 [copper] = imported_body(C:\Users\karlr\Documents\0.3_edgewise.step)
  Body1 [ferrite] = imported_body(C:\Users\karlr\Documents\0.3_edgewise.step)
  Body1_1, Body1_2 [aluminum] = imported_body(C:\Users\karlr\Documents\0.3_edgewise.step)
  Body1_3 [ferrite] = imported_body(C:\Users\karlr\Documents\0.3_edgewise.step)
  Body1_4, Body1_5 [aluminum] = imported_body(C:\Users\karlr\Documents\0.3_edgewise.step)
  Np1_Section1 [copper] = Np1.section(plane=ZX)
  Np2_Section1 [copper] = Np2.section(plane=ZX)
  Np3_Section1 [copper] = Np3.section(plane=ZX)
  Np4_Section1 [copper] = Np4.section(plane=ZX)
  Np5_Section1 [copper] = Np5.section(plane=ZX)
  Np6_Section1 [copper] = Np6.section(plane=ZX)
  Np7_Section1 [copper] = Np7.section(plane=ZX)
  Np8_Section1 [copper] = Np8.section(plane=ZX)
  Np9_Section1 [copper] = Np9.section(plane=ZX)
  Np10_Section1 [copper] = Np10.section(plane=ZX)
  Np11_Section1 [copper] = Np11.section(plane=ZX)
  Np12_Section1 [copper] = Np12.section(plane=ZX)
  Ns1_Section1 [copper] = Ns1.section(plane=ZX)
  Ns2_Section1 [copper] = Ns2.section(plane=ZX)
  Ns3_Section1 [copper] = Ns3.section(plane=ZX)
  Ns4_Section1 [copper] = Ns4.section(plane=ZX)
  Ns5_Section1 [copper] = Ns5.section(plane=ZX)
  Ns6_Section1 [copper] = Ns6.section(plane=ZX)
  Ns7_Section1 [copper] = Ns7.section(plane=ZX)
  Ns8_Section1 [copper] = Ns8.section(plane=ZX)
  Ns9_Section1 [copper] = Ns9.section(plane=ZX)
  Ns10_Section1 [copper] = Ns10.section(plane=ZX)
  Ns11_Section1 [copper] = Ns11.section(plane=ZX)
  Ns12_Section1 [copper] = Ns12.section(plane=ZX)
  Np1_Section1.separate_bodies()
  Np2_Section1.separate_bodies()
  Np3_Section1.separate_bodies()
  Np4_Section1.separate_bodies()
  Np5_Section1.separate_bodies()
  Np6_Section1.separate_bodies()
  Np7_Section1.separate_bodies()
  Np8_Section1.separate_bodies()
  Np9_Section1.separate_bodies()
  Np10_Section1.separate_bodies()
  Np11_Section1.separate_bodies()
  Np12_Section1.separate_bodies()
  Ns1_Section1.separate_bodies()
  Ns2_Section1.separate_bodies()
  Ns3_Section1.separate_bodies()
  Ns4_Section1.separate_bodies()
  Ns5_Section1.separate_bodies()
  Ns6_Section1.separate_bodies()
  Ns7_Section1.separate_bodies()
  Ns8_Section1.separate_bodies()
  Ns9_Section1.separate_bodies()
  Ns10_Section1.separate_bodies()
  Ns11_Section1.separate_bodies()
  Ns12_Section1.separate_bodies()
  Rectangle1 [non-model] = rectangle(corner=(39.8mm, 7.09649239mm, 0mm), z_size=20mm, x_size=-39.8mm)
  group core_assembled_edgewise = plate_1, plate_2, Np1, Np10, Np11, Np12, Np2..Np9, Ns1, Ns10, Ns11, Ns12, Ns2..Ns9, Np1_Section1, Np2_Section1, Np3_Section1, Np4_Section1, Np5_Section1, Np6_Section1, Np7_Section1, Np8_Section1, Np9_Section1, Np10_Section1, Np11_Section1, Np12_Section1, Ns1_Section1, Ns2_Section1, Ns3_Section1, Ns4_Section1, Ns5_Section1, Ns6_Section1, Ns7_Section1, Ns8_Section1, Ns9_Section1, Ns10_Section1, Ns11_Section1, Ns12_Section1
  group core_together_1 = Body1, Body1_1, Body1_2
  group core_together = Body1_3, Body1_4, Body1_5
boundaries and excitations:
  Np_1: Coil Terminal Objects=Np1_Section1 Conductor_number=1 Winding=Primary Point_out_of_terminal=false
  Np_2: Coil Terminal Objects=Np2_Section1 Conductor_number=1 Winding=Primary Point_out_of_terminal=false
  Np_3: Coil Terminal Objects=Np3_Section1 Conductor_number=1 Winding=Primary Point_out_of_terminal=false
  Np_4: Coil Terminal Objects=Np4_Section1 Conductor_number=1 Winding=Primary Point_out_of_terminal=false
  Np_5: Coil Terminal Objects=Np5_Section1 Conductor_number=1 Winding=Primary Point_out_of_terminal=false
  Np_6: Coil Terminal Objects=Np6_Section1 Conductor_number=1 Winding=Primary Point_out_of_terminal=false
  Np_7: Coil Terminal Objects=Np7_Section1 Conductor_number=1 Winding=Primary Point_out_of_terminal=false
  Np_8: Coil Terminal Objects=Np8_Section1 Conductor_number=1 Winding=Primary Point_out_of_terminal=false
  Np_9: Coil Terminal Objects=Np9_Section1 Conductor_number=1 Winding=Primary Point_out_of_terminal=false
  Np_10: Coil Terminal Objects=Np10_Section1 Conductor_number=1 Winding=Primary Point_out_of_terminal=false
  Np_11: Coil Terminal Objects=Np11_Section1 Conductor_number=1 Winding=Primary Point_out_of_terminal=false
  Np_12: Coil Terminal Objects=Np12_Section1 Conductor_number=1 Winding=Primary Point_out_of_terminal=false
  Ns_1: Coil Terminal Objects=Ns1_Section1 Conductor_number=1 Winding=Secondary Point_out_of_terminal=true
  Ns_2: Coil Terminal Objects=Ns2_Section1 Conductor_number=1 Winding=Secondary Point_out_of_terminal=true
  Ns_3: Coil Terminal Objects=Ns3_Section1 Conductor_number=1 Winding=Secondary Point_out_of_terminal=true
  Ns_4: Coil Terminal Objects=Ns4_Section1 Conductor_number=1 Winding=Secondary Point_out_of_terminal=true
  Ns_5: Coil Terminal Objects=Ns5_Section1 Conductor_number=1 Winding=Secondary Point_out_of_terminal=true
  Ns_6: Coil Terminal Objects=Ns6_Section1 Conductor_number=1 Winding=Secondary Point_out_of_terminal=true
  Ns_7: Coil Terminal Objects=Ns7_Section1 Conductor_number=1 Winding=Secondary Point_out_of_terminal=true
  Ns_8: Coil Terminal Objects=Ns8_Section1 Conductor_number=1 Winding=Secondary Point_out_of_terminal=true
  Ns_9: Coil Terminal Objects=Ns9_Section1 Conductor_number=1 Winding=Secondary Point_out_of_terminal=true
  Ns_10: Coil Terminal Objects=Ns10_Section1 Conductor_number=1 Winding=Secondary Point_out_of_terminal=true
  Ns_11: Coil Terminal Objects=Ns11_Section1 Conductor_number=1 Winding=Secondary Point_out_of_terminal=true
  Ns_12: Coil Terminal Objects=Ns12_Section1 Conductor_number=1 Winding=Secondary Point_out_of_terminal=true
  Primary: Winding Group Type=Current IsSolid=true Current=14.14A ParallelBranchesNum=1 Phase=0deg
  Secondary: Winding Group Type=Current IsSolid=true Current=14.14A ParallelBranchesNum=1 Phase=0deg
parameters:
  Matrix1: Matrix Primary, Secondary:
mesh:
  Length1: LengthBased Objects=[Np1..Np12, Ns1..Ns12, plate_1, plate_2] MaxLength=3mm
  Length2: LengthBased Objects=[Body1_4, Body1_5, Body1_3, Body1_1, Body1_2, Body1] MaxLength=3mm
  initial mesh: GlobalSurfApproximation{CurvedSurfaceApproxChoice=UseSlider SliderMeshSettings=9} GlobalCurvilinear{Apply} MeshMethod=AnsoftClassic
setups:
  Setup1: EddyCurrent MaximumPasses=15 MinimumPasses=2 MinimumConvergedPasses=1 PercentRefinement=30 PercentError=2 NonLinearResidual=0.0001 Frequency=1MHz LossAdaptiveCtrl=0.5
field plots:
  Mag_J1: J over a plane on Setup1 : LastAdaptive at Freq=1MHz Phase=20deg

design 0.40_edgewise_2D (Maxwell 2D, EddyCurrent, XY geometry, model units mm)
options: ModelDepth=14.21510085mm
geometry:
  Region [vacuum] = region(percentage_offset=0 on all sides)
  plate_1#13767, plate_2#13819, Np1#13871, Np10#13923, Np11#13975, Np12#14027, Np2#14079, Np3#14131, Np4#14183, Np5#14235, Np6#14287, Np7#14339, Np8#14391, Np9#14443, Ns1#14495, Ns10#14547, Ns11#14599, Ns12#14651, Ns2#14703, Ns3#14755, Ns4#14807, Ns5#14859, Ns6#14911, Ns7#14963, Ns8#15015, Ns9#15067, Body1#15119, Body1_3#15299 = imported_body(C:\Users\karlr\Documents\0.4_edgewise.step)
  plate_1 [FR4_epoxy] = plate_1#13767.section(plane=ZX)
  plate_1#13767.delete()
  plate_1.rotate(axis=X, angle=-90deg)
  plate_2 [FR4_epoxy] = plate_2#13819.section(plane=ZX)
  plate_2#13819.delete()
  plate_2.rotate(axis=X, angle=-90deg)
  Np1 [copper] = Np1#13871.section(plane=ZX)
  Np1#13871.delete()
  Np1.rotate(axis=X, angle=-90deg)
  Np10 [copper] = Np10#13923.section(plane=ZX)
  Np10#13923.delete()
  Np10.rotate(axis=X, angle=-90deg)
  Np11 [copper] = Np11#13975.section(plane=ZX)
  Np11#13975.delete()
  Np11.rotate(axis=X, angle=-90deg)
  Np12 [copper] = Np12#14027.section(plane=ZX)
  Np12#14027.delete()
  Np12.rotate(axis=X, angle=-90deg)
  Np2 [copper] = Np2#14079.section(plane=ZX)
  Np2#14079.delete()
  Np2.rotate(axis=X, angle=-90deg)
  Np3 [copper] = Np3#14131.section(plane=ZX)
  Np3#14131.delete()
  Np3.rotate(axis=X, angle=-90deg)
  Np4 [copper] = Np4#14183.section(plane=ZX)
  Np4#14183.delete()
  Np4.rotate(axis=X, angle=-90deg)
  Np5 [copper] = Np5#14235.section(plane=ZX)
  Np5#14235.delete()
  Np5.rotate(axis=X, angle=-90deg)
  Np6 [copper] = Np6#14287.section(plane=ZX)
  Np6#14287.delete()
  Np6.rotate(axis=X, angle=-90deg)
  Np7 [copper] = Np7#14339.section(plane=ZX)
  Np7#14339.delete()
  Np7.rotate(axis=X, angle=-90deg)
  Np8 [copper] = Np8#14391.section(plane=ZX)
  Np8#14391.delete()
  Np8.rotate(axis=X, angle=-90deg)
  Np9 [copper] = Np9#14443.section(plane=ZX)
  Np9#14443.delete()
  Np9.rotate(axis=X, angle=-90deg)
  Ns1 [copper] = Ns1#14495.section(plane=ZX)
  Ns1#14495.delete()
  Ns1.rotate(axis=X, angle=-90deg)
  Ns10 [copper] = Ns10#14547.section(plane=ZX)
  Ns10#14547.delete()
  Ns10.rotate(axis=X, angle=-90deg)
  Ns11 [copper] = Ns11#14599.section(plane=ZX)
  Ns11#14599.delete()
  Ns11.rotate(axis=X, angle=-90deg)
  Ns12 [copper] = Ns12#14651.section(plane=ZX)
  Ns12#14651.delete()
  Ns12.rotate(axis=X, angle=-90deg)
  Ns2 [copper] = Ns2#14703.section(plane=ZX)
  Ns2#14703.delete()
  Ns2.rotate(axis=X, angle=-90deg)
  Ns3 [copper] = Ns3#14755.section(plane=ZX)
  Ns3#14755.delete()
  Ns3.rotate(axis=X, angle=-90deg)
  Ns4 [copper] = Ns4#14807.section(plane=ZX)
  Ns4#14807.delete()
  Ns4.rotate(axis=X, angle=-90deg)
  Ns5 [copper] = Ns5#14859.section(plane=ZX)
  Ns5#14859.delete()
  Ns5.rotate(axis=X, angle=-90deg)
  Ns6 [copper] = Ns6#14911.section(plane=ZX)
  Ns6#14911.delete()
  Ns6.rotate(axis=X, angle=-90deg)
  Ns7 [copper] = Ns7#14963.section(plane=ZX)
  Ns7#14963.delete()
  Ns7.rotate(axis=X, angle=-90deg)
  Ns8 [copper] = Ns8#15015.section(plane=ZX)
  Ns8#15015.delete()
  Ns8.rotate(axis=X, angle=-90deg)
  Ns9 [copper] = Ns9#15067.section(plane=ZX)
  Ns9#15067.delete()
  Ns9.rotate(axis=X, angle=-90deg)
  Body1 [ferrite] = Body1#15119.section(plane=ZX)
  Body1#15119.delete()
  Body1.rotate(axis=X, angle=-90deg)
  Body1_3 [ferrite] = Body1_3#15299.section(plane=ZX)
  Body1_3#15299.delete()
  Body1_3.rotate(axis=X, angle=-90deg)
  Np1_Separate1 [copper] = Np1.separate_bodies()
  Np2_Separate1 [copper] = Np2.separate_bodies()
  Np3_Separate1 [copper] = Np3.separate_bodies()
  Np4_Separate1 [copper] = Np4.separate_bodies()
  Np5_Separate1 [copper] = Np5.separate_bodies()
  Np6_Separate1 [copper] = Np6.separate_bodies()
  Np7_Separate1 [copper] = Np7.separate_bodies()
  Np8_Separate1 [copper] = Np8.separate_bodies()
  Np9_Separate1 [copper] = Np9.separate_bodies()
  Np10_Separate1 [copper] = Np10.separate_bodies()
  Np11_Separate1 [copper] = Np11.separate_bodies()
  Np12_Separate1 [copper] = Np12.separate_bodies()
  Ns1_Separate1 [copper] = Ns1.separate_bodies()
  Ns2_Separate1 [copper] = Ns2.separate_bodies()
  Ns3_Separate1 [copper] = Ns3.separate_bodies()
  Ns4_Separate1 [copper] = Ns4.separate_bodies()
  Ns5_Separate1 [copper] = Ns5.separate_bodies()
  Ns6_Separate1 [copper] = Ns6.separate_bodies()
  Ns7_Separate1 [copper] = Ns7.separate_bodies()
  Ns8_Separate1 [copper] = Ns8.separate_bodies()
  Ns9_Separate1 [copper] = Ns9.separate_bodies()
  Ns10_Separate1 [copper] = Ns10.separate_bodies()
  Ns11_Separate1 [copper] = Ns11.separate_bodies()
  Ns12_Separate1 [copper] = Ns12.separate_bodies()
  group core_assembled_edgewise = plate_1, plate_2, Np1, Np10, Np11, Np12, Np2..Np9, Ns1, Ns10, Ns11, Ns12, Ns2..Ns9, Np1_Separate1, Np2_Separate1, Np3_Separate1, Np4_Separate1, Np5_Separate1, Np6_Separate1, Np7_Separate1, Np8_Separate1, Np9_Separate1, Np10_Separate1, Np11_Separate1, Np12_Separate1, Ns1_Separate1, Ns2_Separate1, Ns3_Separate1, Ns4_Separate1, Ns5_Separate1, Ns6_Separate1, Ns7_Separate1, Ns8_Separate1, Ns9_Separate1, Ns10_Separate1, Ns11_Separate1, Ns12_Separate1
  group core_together_1 = Body1
  group core_together = Body1_3
boundaries and excitations:
  Balloon1: Balloon Edges=Region.edge(all 4)
  Np1: Coil Objects=Np1 Conductor_number=1 Winding=Primary PolarityType=Positive
  Np2: Coil Objects=Np2 Conductor_number=1 Winding=Primary PolarityType=Positive
  Np3: Coil Objects=Np3 Conductor_number=1 Winding=Primary PolarityType=Positive
  Np4: Coil Objects=Np4 Conductor_number=1 Winding=Primary PolarityType=Positive
  Np5: Coil Objects=Np5 Conductor_number=1 Winding=Primary PolarityType=Positive
  Np6: Coil Objects=Np6 Conductor_number=1 Winding=Primary PolarityType=Positive
  Np7: Coil Objects=Np7 Conductor_number=1 Winding=Primary PolarityType=Positive
  Np8: Coil Objects=Np8 Conductor_number=1 Winding=Primary PolarityType=Positive
  Np9: Coil Objects=Np9 Conductor_number=1 Winding=Primary PolarityType=Positive
  Np10: Coil Objects=Np10 Conductor_number=1 Winding=Primary PolarityType=Positive
  Np11: Coil Objects=Np11 Conductor_number=1 Winding=Primary PolarityType=Positive
  Np12: Coil Objects=Np12 Conductor_number=1 Winding=Primary PolarityType=Positive
  Np1_Separate1: Coil Objects=Np1_Separate1 Conductor_number=1 Winding=Primary PolarityType=Negative
  Np2_Separate1: Coil Objects=Np2_Separate1 Conductor_number=1 Winding=Primary PolarityType=Negative
  Np3_Separate1: Coil Objects=Np3_Separate1 Conductor_number=1 Winding=Primary PolarityType=Negative
  Np4_Separate1: Coil Objects=Np4_Separate1 Conductor_number=1 Winding=Primary PolarityType=Negative
  Np5_Separate1: Coil Objects=Np5_Separate1 Conductor_number=1 Winding=Primary PolarityType=Negative
  Np6_Separate1: Coil Objects=Np6_Separate1 Conductor_number=1 Winding=Primary PolarityType=Negative
  Np7_Separate1: Coil Objects=Np7_Separate1 Conductor_number=1 Winding=Primary PolarityType=Negative
  Np8_Separate1: Coil Objects=Np8_Separate1 Conductor_number=1 Winding=Primary PolarityType=Negative
  Np9_Separate1: Coil Objects=Np9_Separate1 Conductor_number=1 Winding=Primary PolarityType=Negative
  Np10_Separate1: Coil Objects=Np10_Separate1 Conductor_number=1 Winding=Primary PolarityType=Negative
  Np11_Separate1: Coil Objects=Np11_Separate1 Conductor_number=1 Winding=Primary PolarityType=Negative
  Np12_Separate1: Coil Objects=Np12_Separate1 Conductor_number=1 Winding=Primary PolarityType=Negative
  Ns1: Coil Objects=Ns1 Conductor_number=1 Winding=Secondary PolarityType=Negative
  Ns2: Coil Objects=Ns2 Conductor_number=1 Winding=Secondary PolarityType=Negative
  Ns3: Coil Objects=Ns3 Conductor_number=1 Winding=Secondary PolarityType=Negative
  Ns4: Coil Objects=Ns4 Conductor_number=1 Winding=Secondary PolarityType=Negative
  Ns5: Coil Objects=Ns5 Conductor_number=1 Winding=Secondary PolarityType=Negative
  Ns6: Coil Objects=Ns6 Conductor_number=1 Winding=Secondary PolarityType=Negative
  Ns7: Coil Objects=Ns7 Conductor_number=1 Winding=Secondary PolarityType=Negative
  Ns8: Coil Objects=Ns8 Conductor_number=1 Winding=Secondary PolarityType=Negative
  Ns9: Coil Objects=Ns9 Conductor_number=1 Winding=Secondary PolarityType=Negative
  Ns10: Coil Objects=Ns10 Conductor_number=1 Winding=Secondary PolarityType=Negative
  Ns11: Coil Objects=Ns11 Conductor_number=1 Winding=Secondary PolarityType=Negative
  Ns12: Coil Objects=Ns12 Conductor_number=1 Winding=Secondary PolarityType=Negative
  Ns12_Separate1: Coil Objects=Ns12_Separate1 Conductor_number=1 Winding=Secondary PolarityType=Positive
  Ns11_Separate1: Coil Objects=Ns11_Separate1 Conductor_number=1 Winding=Secondary PolarityType=Positive
  Ns10_Separate1: Coil Objects=Ns10_Separate1 Conductor_number=1 Winding=Secondary PolarityType=Positive
  Ns9_Separate1: Coil Objects=Ns9_Separate1 Conductor_number=1 Winding=Secondary PolarityType=Positive
  Ns8_Separate1: Coil Objects=Ns8_Separate1 Conductor_number=1 Winding=Secondary PolarityType=Positive
  Ns7_Separate1: Coil Objects=Ns7_Separate1 Conductor_number=1 Winding=Secondary PolarityType=Positive
  Ns6_Separate1: Coil Objects=Ns6_Separate1 Conductor_number=1 Winding=Secondary PolarityType=Positive
  Ns5_Separate1: Coil Objects=Ns5_Separate1 Conductor_number=1 Winding=Secondary PolarityType=Positive
  Ns4_Separate1: Coil Objects=Ns4_Separate1 Conductor_number=1 Winding=Secondary PolarityType=Positive
  Ns3_Separate1: Coil Objects=Ns3_Separate1 Conductor_number=1 Winding=Secondary PolarityType=Positive
  Ns2_Separate1: Coil Objects=Ns2_Separate1 Conductor_number=1 Winding=Secondary PolarityType=Positive
  Ns1_Separate1: Coil Objects=Ns1_Separate1 Conductor_number=1 Winding=Secondary PolarityType=Positive
  Primary: Winding Group Type=Current IsSolid=true Current=14.14A ParallelBranchesNum=1 Phase=0deg
  Secondary: Winding Group Type=Current IsSolid=true Current=14.14A ParallelBranchesNum=1 Phase=1deg
parameters:
  Matrix1: Matrix Primary, Secondary:
mesh:
  Length1: LengthBased RefineInside Objects=[plate_2, plate_1, Np1, Np1_Separate1, Np2, Np2_Separate1, Np3, Np3_Separate1, Np4, Np4_Separate1, Np5, Np5_Separate1, Np6, Np6_Separate1, Np7, Np7_Separate1, Np8, Np8_Separate1, Np9, Np9_Separate1, Np10, Np10_Separate1, Np11, Np11_Separate1, Np12, Np12_Separate1, Ns1, Ns1_Separate1, Ns2, Ns2_Separate1, Ns3, Ns3_Separate1, Ns4, Ns4_Separate1, Ns5, Ns5_Separate1, Ns6, Ns6_Separate1, Ns7, Ns7_Separate1, Ns8, Ns8_Separate1, Ns9, Ns9_Separate1, Ns10, Ns10_Separate1, Ns11, Ns11_Separate1, Ns12, Ns12_Separate1] MaxLength=0.2mm
  Length2: LengthBased RefineInside Objects=[Body1, Body1_3] MaxLength=2mm
setups:
  Setup1: EddyCurrent MaximumPasses=10 MinimumPasses=2 MinimumConvergedPasses=1 PercentRefinement=30 PercentError=1 NonLinearResidual=0.0001 Frequency=30000Hz

design 0.35_edgewise_2D (Maxwell 2D, EddyCurrent, XY geometry, model units mm)
options: ModelDepth=14.18192675mm
geometry:
  Region [vacuum] = region(percentage_offset=0 on all sides)
  plate_1#12052, plate_2#12104, Np1#12156, Np10#12208, Np11#12260, Np12#12312, Np2#12364, Np3#12416, Np4#12468, Np5#12520, Np6#12572, Np7#12624, Np8#12676, Np9#12728, Ns1#12780, Ns10#12832, Ns11#12884, Ns12#12936, Ns2#12988, Ns3#13040, Ns4#13092, Ns5#13144, Ns6#13196, Ns7#13248, Ns8#13300, Ns9#13352, Body1#13404, Body1_3#13584 = imported_body(C:\Users\karlr\Documents\0.35_edgewise.step)
  plate_1 [FR4_epoxy] = plate_1#12052.section(plane=ZX)
  plate_1#12052.delete()
  plate_1.rotate(axis=X, angle=-90deg)
  plate_2 [FR4_epoxy] = plate_2#12104.section(plane=ZX)
  plate_2#12104.delete()
  plate_2.rotate(axis=X, angle=-90deg)
  Np1 [copper] = Np1#12156.section(plane=ZX)
  Np1#12156.delete()
  Np1.rotate(axis=X, angle=-90deg)
  Np10 [copper] = Np10#12208.section(plane=ZX)
  Np10#12208.delete()
  Np10.rotate(axis=X, angle=-90deg)
  Np11 [copper] = Np11#12260.section(plane=ZX)
  Np11#12260.delete()
  Np11.rotate(axis=X, angle=-90deg)
  Np12 [copper] = Np12#12312.section(plane=ZX)
  Np12#12312.delete()
  Np12.rotate(axis=X, angle=-90deg)
  Np2 [copper] = Np2#12364.section(plane=ZX)
  Np2#12364.delete()
  Np2.rotate(axis=X, angle=-90deg)
  Np3 [copper] = Np3#12416.section(plane=ZX)
  Np3#12416.delete()
  Np3.rotate(axis=X, angle=-90deg)
  Np4 [copper] = Np4#12468.section(plane=ZX)
  Np4#12468.delete()
  Np4.rotate(axis=X, angle=-90deg)
  Np5 [copper] = Np5#12520.section(plane=ZX)
  Np5#12520.delete()
  Np5.rotate(axis=X, angle=-90deg)
  Np6 [copper] = Np6#12572.section(plane=ZX)
  Np6#12572.delete()
  Np6.rotate(axis=X, angle=-90deg)
  Np7 [copper] = Np7#12624.section(plane=ZX)
  Np7#12624.delete()
  Np7.rotate(axis=X, angle=-90deg)
  Np8 [copper] = Np8#12676.section(plane=ZX)
  Np8#12676.delete()
  Np8.rotate(axis=X, angle=-90deg)
  Np9 [copper] = Np9#12728.section(plane=ZX)
  Np9#12728.delete()
  Np9.rotate(axis=X, angle=-90deg)
  Ns1 [copper] = Ns1#12780.section(plane=ZX)
  Ns1#12780.delete()
  Ns1.rotate(axis=X, angle=-90deg)
  Ns10 [copper] = Ns10#12832.section(plane=ZX)
  Ns10#12832.delete()
  Ns10.rotate(axis=X, angle=-90deg)
  Ns11 [copper] = Ns11#12884.section(plane=ZX)
  Ns11#12884.delete()
  Ns11.rotate(axis=X, angle=-90deg)
  Ns12 [copper] = Ns12#12936.section(plane=ZX)
  Ns12#12936.delete()
  Ns12.rotate(axis=X, angle=-90deg)
  Ns2 [copper] = Ns2#12988.section(plane=ZX)
  Ns2#12988.delete()
  Ns2.rotate(axis=X, angle=-90deg)
  Ns3 [copper] = Ns3#13040.section(plane=ZX)
  Ns3#13040.delete()
  Ns3.rotate(axis=X, angle=-90deg)
  Ns4 [copper] = Ns4#13092.section(plane=ZX)
  Ns4#13092.delete()
  Ns4.rotate(axis=X, angle=-90deg)
  Ns5 [copper] = Ns5#13144.section(plane=ZX)
  Ns5#13144.delete()
  Ns5.rotate(axis=X, angle=-90deg)
  Ns6 [copper] = Ns6#13196.section(plane=ZX)
  Ns6#13196.delete()
  Ns6.rotate(axis=X, angle=-90deg)
  Ns7 [copper] = Ns7#13248.section(plane=ZX)
  Ns7#13248.delete()
  Ns7.rotate(axis=X, angle=-90deg)
  Ns8 [copper] = Ns8#13300.section(plane=ZX)
  Ns8#13300.delete()
  Ns8.rotate(axis=X, angle=-90deg)
  Ns9 [copper] = Ns9#13352.section(plane=ZX)
  Ns9#13352.delete()
  Ns9.rotate(axis=X, angle=-90deg)
  Body1 [copper] = Body1#13404.section(plane=ZX)
  Body1#13404.delete()
  Body1.rotate(axis=X, angle=-90deg)
  Body1_3 [copper] = Body1_3#13584.section(plane=ZX)
  Body1_3#13584.delete()
  Body1_3.rotate(axis=X, angle=-90deg)
  Np1_Separate1 [copper] = Np1.separate_bodies()
  Np2_Separate1 [copper] = Np2.separate_bodies()
  Np3_Separate1 [copper] = Np3.separate_bodies()
  Np4_Separate1 [copper] = Np4.separate_bodies()
  Np5_Separate1 [copper] = Np5.separate_bodies()
  Np6_Separate1 [copper] = Np6.separate_bodies()
  Np7_Separate1 [copper] = Np7.separate_bodies()
  Np8_Separate1 [copper] = Np8.separate_bodies()
  Np9_Separate1 [copper] = Np9.separate_bodies()
  Np10_Separate1 [copper] = Np10.separate_bodies()
  Np11_Separate1 [copper] = Np11.separate_bodies()
  Np12_Separate1 [copper] = Np12.separate_bodies()
  Ns1_Separate1 [copper] = Ns1.separate_bodies()
  Ns2_Separate1 [copper] = Ns2.separate_bodies()
  Ns3_Separate1 [copper] = Ns3.separate_bodies()
  Ns4_Separate1 [copper] = Ns4.separate_bodies()
  Ns5_Separate1 [copper] = Ns5.separate_bodies()
  Ns6_Separate1 [copper] = Ns6.separate_bodies()
  Ns7_Separate1 [copper] = Ns7.separate_bodies()
  Ns8_Separate1 [copper] = Ns8.separate_bodies()
  Ns9_Separate1 [copper] = Ns9.separate_bodies()
  Ns10_Separate1 [copper] = Ns10.separate_bodies()
  Ns11_Separate1 [copper] = Ns11.separate_bodies()
  Ns12_Separate1 [copper] = Ns12.separate_bodies()
  group core_assembled_edgewise = plate_1, plate_2, Np1, Np10, Np11, Np12, Np2..Np9, Ns1, Ns10, Ns11, Ns12, Ns2..Ns9, Np1_Separate1, Np2_Separate1, Np3_Separate1, Np4_Separate1, Np5_Separate1, Np6_Separate1, Np7_Separate1, Np8_Separate1, Np9_Separate1, Np10_Separate1, Np11_Separate1, Np12_Separate1, Ns1_Separate1, Ns2_Separate1, Ns3_Separate1, Ns4_Separate1, Ns5_Separate1, Ns6_Separate1, Ns7_Separate1, Ns8_Separate1, Ns9_Separate1, Ns10_Separate1, Ns11_Separate1, Ns12_Separate1
  group core_together_1 = Body1
  group core_together = Body1_3
boundaries and excitations:
  Balloon1: Balloon Edges=Region.edge(all 4)
  Np1: Coil Objects=Np1 Conductor_number=1 Winding=Primary PolarityType=Positive
  Np2: Coil Objects=Np2 Conductor_number=1 Winding=Primary PolarityType=Positive
  Np3: Coil Objects=Np3 Conductor_number=1 Winding=Primary PolarityType=Positive
  Np4: Coil Objects=Np4 Conductor_number=1 Winding=Primary PolarityType=Positive
  Np5: Coil Objects=Np5 Conductor_number=1 Winding=Primary PolarityType=Positive
  Np6: Coil Objects=Np6 Conductor_number=1 Winding=Primary PolarityType=Positive
  Np7: Coil Objects=Np7 Conductor_number=1 Winding=Primary PolarityType=Positive
  Np8: Coil Objects=Np8 Conductor_number=1 Winding=Primary PolarityType=Positive
  Np9: Coil Objects=Np9 Conductor_number=1 Winding=Primary PolarityType=Positive
  Np10: Coil Objects=Np10 Conductor_number=1 Winding=Primary PolarityType=Positive
  Np11: Coil Objects=Np11 Conductor_number=1 Winding=Primary PolarityType=Positive
  Np12: Coil Objects=Np12 Conductor_number=1 Winding=Primary PolarityType=Positive
  Np1_Separate1: Coil Objects=Np1_Separate1 Conductor_number=1 Winding=Primary PolarityType=Negative
  Np2_Separate1: Coil Objects=Np2_Separate1 Conductor_number=1 Winding=Primary PolarityType=Negative
  Np3_Separate1: Coil Objects=Np3_Separate1 Conductor_number=1 Winding=Primary PolarityType=Negative
  Np4_Separate1: Coil Objects=Np4_Separate1 Conductor_number=1 Winding=Primary PolarityType=Negative
  Np5_Separate1: Coil Objects=Np5_Separate1 Conductor_number=1 Winding=Primary PolarityType=Negative
  Np6_Separate1: Coil Objects=Np6_Separate1 Conductor_number=1 Winding=Primary PolarityType=Negative
  Np7_Separate1: Coil Objects=Np7_Separate1 Conductor_number=1 Winding=Primary PolarityType=Negative
  Np8_Separate1: Coil Objects=Np8_Separate1 Conductor_number=1 Winding=Primary PolarityType=Negative
  Np9_Separate1: Coil Objects=Np9_Separate1 Conductor_number=1 Winding=Primary PolarityType=Negative
  Np10_Separate1: Coil Objects=Np10_Separate1 Conductor_number=1 Winding=Primary PolarityType=Negative
  Np11_Separate1: Coil Objects=Np11_Separate1 Conductor_number=1 Winding=Primary PolarityType=Negative
  Np12_Separate1: Coil Objects=Np12_Separate1 Conductor_number=1 Winding=Primary PolarityType=Negative
  Ns1: Coil Objects=Ns1 Conductor_number=1 Winding=Secondary PolarityType=Negative
  Ns2: Coil Objects=Ns2 Conductor_number=1 Winding=Secondary PolarityType=Negative
  Ns3: Coil Objects=Ns3 Conductor_number=1 Winding=Secondary PolarityType=Negative
  Ns4: Coil Objects=Ns4 Conductor_number=1 Winding=Secondary PolarityType=Negative
  Ns5: Coil Objects=Ns5 Conductor_number=1 Winding=Secondary PolarityType=Negative
  Ns6: Coil Objects=Ns6 Conductor_number=1 Winding=Secondary PolarityType=Negative
  Ns7: Coil Objects=Ns7 Conductor_number=1 Winding=Secondary PolarityType=Negative
  Ns8: Coil Objects=Ns8 Conductor_number=1 Winding=Secondary PolarityType=Negative
  Ns9: Coil Objects=Ns9 Conductor_number=1 Winding=Secondary PolarityType=Negative
  Ns10: Coil Objects=Ns10 Conductor_number=1 Winding=Secondary PolarityType=Negative
  Ns11: Coil Objects=Ns11 Conductor_number=1 Winding=Secondary PolarityType=Negative
  Ns12: Coil Objects=Ns12 Conductor_number=1 Winding=Secondary PolarityType=Negative
  Ns1_Separate1: Coil Objects=Ns1_Separate1 Conductor_number=1 Winding=Secondary PolarityType=Positive
  Ns2_Separate1: Coil Objects=Ns2_Separate1 Conductor_number=1 Winding=Secondary PolarityType=Positive
  Ns3_Separate1: Coil Objects=Ns3_Separate1 Conductor_number=1 Winding=Secondary PolarityType=Positive
  Ns4_Separate1: Coil Objects=Ns4_Separate1 Conductor_number=1 Winding=Secondary PolarityType=Positive
  Ns5_Separate1: Coil Objects=Ns5_Separate1 Conductor_number=1 Winding=Secondary PolarityType=Positive
  Ns6_Separate1: Coil Objects=Ns6_Separate1 Conductor_number=1 Winding=Secondary PolarityType=Positive
  Ns7_Separate1: Coil Objects=Ns7_Separate1 Conductor_number=1 Winding=Secondary PolarityType=Positive
  Ns8_Separate1: Coil Objects=Ns8_Separate1 Conductor_number=1 Winding=Secondary PolarityType=Positive
  Ns9_Separate1: Coil Objects=Ns9_Separate1 Conductor_number=1 Winding=Secondary PolarityType=Positive
  Ns10_Separate1: Coil Objects=Ns10_Separate1 Conductor_number=1 Winding=Secondary PolarityType=Positive
  Ns11_Separate1: Coil Objects=Ns11_Separate1 Conductor_number=1 Winding=Secondary PolarityType=Positive
  Ns12_Separate1: Coil Objects=Ns12_Separate1 Conductor_number=1 Winding=Secondary PolarityType=Positive
  Primary: Winding Group Type=Current IsSolid=true Current=14.14A ParallelBranchesNum=1 Phase=0deg
  Secondary: Winding Group Type=Current IsSolid=true Current=14.14A ParallelBranchesNum=1 Phase=1deg
parameters:
  Matrix1: Matrix Primary, Secondary:
mesh:
  Length1: LengthBased RefineInside Objects=[Body1_3, Body1] MaxLength=2mm
  Length2: LengthBased RefineInside Objects=[Np1..Np12, Ns1..Ns12, plate_1, plate_2] MaxLength=0.2mm
setups:
  Setup1: EddyCurrent MaximumPasses=10 MinimumPasses=2 MinimumConvergedPasses=1 PercentRefinement=30 PercentError=1 NonLinearResidual=0.0001 Frequency=30000Hz

design 0.30_edgewise_2D (Maxwell 2D, EddyCurrent, XY geometry, model units mm)
options: ModelDepth=14.19298478mm
geometry:
  Region [vacuum] = region(percentage_offset=0 on all sides)
  plate_1#10337, plate_2#10389, Np1#10441, Np10#10493, Np11#10545, Np12#10597, Np2#10649, Np3#10701, Np4#10753, Np5#10805, Np6#10857, Np7#10909, Np8#10961, Np9#11013, Ns1#11065, Ns10#11117, Ns11#11169, Ns12#11221, Ns2#11273, Ns3#11325, Ns4#11377, Ns5#11429, Ns6#11481, Ns7#11533, Ns8#11585, Ns9#11637, Body1#11689, Body1_3#11869 = imported_body(C:\Users\karlr\Documents\0.3_edgewise.step)
  plate_1 [FR4_epoxy] = plate_1#10337.section(plane=ZX)
  plate_1#10337.delete()
  plate_1.rotate(axis=X, angle=-90deg)
  plate_2 [FR4_epoxy] = plate_2#10389.section(plane=ZX)
  plate_2#10389.delete()
  plate_2.rotate(axis=X, angle=-90deg)
  Np1 [copper] = Np1#10441.section(plane=ZX)
  Np1#10441.delete()
  Np1.rotate(axis=X, angle=-90deg)
  Np10 [copper] = Np10#10493.section(plane=ZX)
  Np10#10493.delete()
  Np10.rotate(axis=X, angle=-90deg)
  Np11 [copper] = Np11#10545.section(plane=ZX)
  Np11#10545.delete()
  Np11.rotate(axis=X, angle=-90deg)
  Np12 [copper] = Np12#10597.section(plane=ZX)
  Np12#10597.delete()
  Np12.rotate(axis=X, angle=-90deg)
  Np2 [copper] = Np2#10649.section(plane=ZX)
  Np2#10649.delete()
  Np2.rotate(axis=X, angle=-90deg)
  Np3 [copper] = Np3#10701.section(plane=ZX)
  Np3#10701.delete()
  Np3.rotate(axis=X, angle=-90deg)
  Np4 [copper] = Np4#10753.section(plane=ZX)
  Np4#10753.delete()
  Np4.rotate(axis=X, angle=-90deg)
  Np5 [copper] = Np5#10805.section(plane=ZX)
  Np5#10805.delete()
  Np5.rotate(axis=X, angle=-90deg)
  Np6 [copper] = Np6#10857.section(plane=ZX)
  Np6#10857.delete()
  Np6.rotate(axis=X, angle=-90deg)
  Np7 [copper] = Np7#10909.section(plane=ZX)
  Np7#10909.delete()
  Np7.rotate(axis=X, angle=-90deg)
  Np8 [copper] = Np8#10961.section(plane=ZX)
  Np8#10961.delete()
  Np8.rotate(axis=X, angle=-90deg)
  Np9 [copper] = Np9#11013.section(plane=ZX)
  Np9#11013.delete()
  Np9.rotate(axis=X, angle=-90deg)
  Ns1 [copper] = Ns1#11065.section(plane=ZX)
  Ns1#11065.delete()
  Ns1.rotate(axis=X, angle=-90deg)
  Ns10 [copper] = Ns10#11117.section(plane=ZX)
  Ns10#11117.delete()
  Ns10.rotate(axis=X, angle=-90deg)
  Ns11 [copper] = Ns11#11169.section(plane=ZX)
  Ns11#11169.delete()
  Ns11.rotate(axis=X, angle=-90deg)
  Ns12 [copper] = Ns12#11221.section(plane=ZX)
  Ns12#11221.delete()
  Ns12.rotate(axis=X, angle=-90deg)
  Ns2 [copper] = Ns2#11273.section(plane=ZX)
  Ns2#11273.delete()
  Ns2.rotate(axis=X, angle=-90deg)
  Ns3 [copper] = Ns3#11325.section(plane=ZX)
  Ns3#11325.delete()
  Ns3.rotate(axis=X, angle=-90deg)
  Ns4 [copper] = Ns4#11377.section(plane=ZX)
  Ns4#11377.delete()
  Ns4.rotate(axis=X, angle=-90deg)
  Ns5 [copper] = Ns5#11429.section(plane=ZX)
  Ns5#11429.delete()
  Ns5.rotate(axis=X, angle=-90deg)
  Ns6 [copper] = Ns6#11481.section(plane=ZX)
  Ns6#11481.delete()
  Ns6.rotate(axis=X, angle=-90deg)
  Ns7 [copper] = Ns7#11533.section(plane=ZX)
  Ns7#11533.delete()
  Ns7.rotate(axis=X, angle=-90deg)
  Ns8 [copper] = Ns8#11585.section(plane=ZX)
  Ns8#11585.delete()
  Ns8.rotate(axis=X, angle=-90deg)
  Ns9 [copper] = Ns9#11637.section(plane=ZX)
  Ns9#11637.delete()
  Ns9.rotate(axis=X, angle=-90deg)
  Body1 [ferrite] = Body1#11689.section(plane=ZX)
  Body1#11689.delete()
  Body1.rotate(axis=X, angle=-90deg)
  Body1_3 [ferrite] = Body1_3#11869.section(plane=ZX)
  Body1_3#11869.delete()
  Body1_3.rotate(axis=X, angle=-90deg)
  Np1_Separate1 [copper] = Np1.separate_bodies()
  Np2_Separate1 [copper] = Np2.separate_bodies()
  Np3_Separate1 [copper] = Np3.separate_bodies()
  Np4_Separate1 [copper] = Np4.separate_bodies()
  Np5_Separate1 [copper] = Np5.separate_bodies()
  Np6_Separate1 [copper] = Np6.separate_bodies()
  Np7_Separate1 [copper] = Np7.separate_bodies()
  Np8_Separate1 [copper] = Np8.separate_bodies()
  Np9_Separate1 [copper] = Np9.separate_bodies()
  Np10_Separate1 [copper] = Np10.separate_bodies()
  Np11_Separate1 [copper] = Np11.separate_bodies()
  Np12_Separate1 [copper] = Np12.separate_bodies()
  Ns1_Separate1 [copper] = Ns1.separate_bodies()
  Ns2_Separate1 [copper] = Ns2.separate_bodies()
  Ns3_Separate1 [copper] = Ns3.separate_bodies()
  Ns4_Separate1 [copper] = Ns4.separate_bodies()
  Ns5_Separate1 [copper] = Ns5.separate_bodies()
  Ns6_Separate1 [copper] = Ns6.separate_bodies()
  Ns7_Separate1 [copper] = Ns7.separate_bodies()
  Ns8_Separate1 [copper] = Ns8.separate_bodies()
  Ns9_Separate1 [copper] = Ns9.separate_bodies()
  Ns10_Separate1 [copper] = Ns10.separate_bodies()
  Ns11_Separate1 [copper] = Ns11.separate_bodies()
  Ns12_Separate1 [copper] = Ns12.separate_bodies()
  group core_assembled_edgewise = plate_1, plate_2, Np1, Np10, Np11, Np12, Np2..Np9, Ns1, Ns10, Ns11, Ns12, Ns2..Ns9, Np1_Separate1, Np2_Separate1, Np3_Separate1, Np4_Separate1, Np5_Separate1, Np6_Separate1, Np7_Separate1, Np8_Separate1, Np9_Separate1, Np10_Separate1, Np11_Separate1, Np12_Separate1, Ns1_Separate1, Ns2_Separate1, Ns3_Separate1, Ns4_Separate1, Ns5_Separate1, Ns6_Separate1, Ns7_Separate1, Ns8_Separate1, Ns9_Separate1, Ns10_Separate1, Ns11_Separate1, Ns12_Separate1
  group core_together_1 = Body1
  group core_together = Body1_3
boundaries and excitations:
  Balloon1: Balloon Edges=Region.edge(all 4)
  Np1: Coil Objects=Np1 Conductor_number=1 Winding=Primary PolarityType=Positive
  Np2: Coil Objects=Np2 Conductor_number=1 Winding=Primary PolarityType=Positive
  Np3: Coil Objects=Np3 Conductor_number=1 Winding=Primary PolarityType=Positive
  Np4: Coil Objects=Np4 Conductor_number=1 Winding=Primary PolarityType=Positive
  Np5: Coil Objects=Np5 Conductor_number=1 Winding=Primary PolarityType=Positive
  Np6: Coil Objects=Np6 Conductor_number=1 Winding=Primary PolarityType=Positive
  Np7: Coil Objects=Np7 Conductor_number=1 Winding=Primary PolarityType=Positive
  Np8: Coil Objects=Np8 Conductor_number=1 Winding=Primary PolarityType=Positive
  Np9: Coil Objects=Np9 Conductor_number=1 Winding=Primary PolarityType=Positive
  Np10: Coil Objects=Np10 Conductor_number=1 Winding=Primary PolarityType=Positive
  Np11: Coil Objects=Np11 Conductor_number=1 Winding=Primary PolarityType=Positive
  Np12: Coil Objects=Np12 Conductor_number=1 Winding=Primary PolarityType=Positive
  Np1_Separate1: Coil Objects=Np1_Separate1 Conductor_number=1 Winding=Primary PolarityType=Negative
  Np2_Separate1: Coil Objects=Np2_Separate1 Conductor_number=1 Winding=Primary PolarityType=Negative
  Np3_Separate1: Coil Objects=Np3_Separate1 Conductor_number=1 Winding=Primary PolarityType=Negative
  Np4_Separate1: Coil Objects=Np4_Separate1 Conductor_number=1 Winding=Primary PolarityType=Negative
  Np5_Separate1: Coil Objects=Np5_Separate1 Conductor_number=1 Winding=Primary PolarityType=Negative
  Np6_Separate1: Coil Objects=Np6_Separate1 Conductor_number=1 Winding=Primary PolarityType=Negative
  Np7_Separate1: Coil Objects=Np7_Separate1 Conductor_number=1 Winding=Primary PolarityType=Negative
  Np8_Separate1: Coil Objects=Np8_Separate1 Conductor_number=1 Winding=Primary PolarityType=Negative
  Np9_Separate1: Coil Objects=Np9_Separate1 Conductor_number=1 Winding=Primary PolarityType=Negative
  Np10_Separate1: Coil Objects=Np10_Separate1 Conductor_number=1 Winding=Primary PolarityType=Negative
  Np11_Separate1: Coil Objects=Np11_Separate1 Conductor_number=1 Winding=Primary PolarityType=Negative
  Np12_Separate1: Coil Objects=Np12_Separate1 Conductor_number=1 Winding=Primary PolarityType=Negative
  Ns1: Coil Objects=Ns1 Conductor_number=1 Winding=Secondary PolarityType=Negative
  Ns2: Coil Objects=Ns2 Conductor_number=1 Winding=Secondary PolarityType=Negative
  Ns3: Coil Objects=Ns3 Conductor_number=1 Winding=Secondary PolarityType=Negative
  Ns4: Coil Objects=Ns4 Conductor_number=1 Winding=Secondary PolarityType=Negative
  Ns5: Coil Objects=Ns5 Conductor_number=1 Winding=Secondary PolarityType=Negative
  Ns6: Coil Objects=Ns6 Conductor_number=1 Winding=Secondary PolarityType=Negative
  Ns7: Coil Objects=Ns7 Conductor_number=1 Winding=Secondary PolarityType=Negative
  Ns8: Coil Objects=Ns8 Conductor_number=1 Winding=Secondary PolarityType=Negative
  Ns9: Coil Objects=Ns9 Conductor_number=1 Winding=Secondary PolarityType=Negative
  Ns10: Coil Objects=Ns10 Conductor_number=1 Winding=Secondary PolarityType=Negative
  Ns11: Coil Objects=Ns11 Conductor_number=1 Winding=Secondary PolarityType=Negative
  Ns12: Coil Objects=Ns12 Conductor_number=1 Winding=Secondary PolarityType=Negative
  Ns1_Separate1: Coil Objects=Ns1_Separate1 Conductor_number=1 Winding=Secondary PolarityType=Positive
  Ns2_Separate1: Coil Objects=Ns2_Separate1 Conductor_number=1 Winding=Secondary PolarityType=Positive
  Ns3_Separate1: Coil Objects=Ns3_Separate1 Conductor_number=1 Winding=Secondary PolarityType=Positive
  Ns4_Separate1: Coil Objects=Ns4_Separate1 Conductor_number=1 Winding=Secondary PolarityType=Positive
  Ns5_Separate1: Coil Objects=Ns5_Separate1 Conductor_number=1 Winding=Secondary PolarityType=Positive
  Ns6_Separate1: Coil Objects=Ns6_Separate1 Conductor_number=1 Winding=Secondary PolarityType=Positive
  Ns7_Separate1: Coil Objects=Ns7_Separate1 Conductor_number=1 Winding=Secondary PolarityType=Positive
  Ns8_Separate1: Coil Objects=Ns8_Separate1 Conductor_number=1 Winding=Secondary PolarityType=Positive
  Ns9_Separate1: Coil Objects=Ns9_Separate1 Conductor_number=1 Winding=Secondary PolarityType=Positive
  Ns10_Separate1: Coil Objects=Ns10_Separate1 Conductor_number=1 Winding=Secondary PolarityType=Positive
  Ns11_Separate1: Coil Objects=Ns11_Separate1 Conductor_number=1 Winding=Secondary PolarityType=Positive
  Ns12_Separate1: Coil Objects=Ns12_Separate1 Conductor_number=1 Winding=Secondary PolarityType=Positive
  Primary: Winding Group Type=Current IsSolid=true Current=14.14A ParallelBranchesNum=1 Phase=0deg
  Secondary: Winding Group Type=Current IsSolid=true Current=14.14A ParallelBranchesNum=1 Phase=1deg
  eddy effects on: Np1, Np10, Np11, Np12, Np2..Np9, Ns1, Ns10, Ns11, Ns12, Ns2..Ns9, Np1_Separate1, Np2_Separate1, Np3_Separate1, Np4_Separate1, Np5_Separate1, Np6_Separate1, Np7_Separate1, Np8_Separate1, Np9_Separate1, Np10_Separate1, Np11_Separate1, Np12_Separate1, Ns1_Separate1, Ns2_Separate1, Ns3_Separate1, Ns4_Separate1, Ns5_Separate1, Ns6_Separate1, Ns7_Separate1, Ns8_Separate1, Ns9_Separate1, Ns10_Separate1, Ns11_Separate1, Ns12_Separate1
parameters:
  Matrix1: Matrix Primary, Secondary:
mesh:
  Length1: LengthBased RefineInside Objects=[Body1, Body1_3] MaxLength=2mm
  Length2: LengthBased RefineInside Objects=[plate_1, plate_2, Np1, Np10, Np11, Np12, Np2..Np9, Ns1, Ns10, Ns11, Ns12, Ns2..Ns9] MaxLength=0.2mm
setups:
  Setup1: EddyCurrent MaximumPasses=10 MinimumPasses=2 MinimumConvergedPasses=1 PercentRefinement=30 PercentError=1 ConstantDelta=0s NonLinearResidual=0.0001 Frequency=1MHz
field plots:
  JAtPhase1: J over Np1, Np1_Separate1, Np2, Np2_Separate1, Np3, Np3_Separate1, Np4, Np4_Separate1, Np5, Np5_Separate1, Np6, Np6_Separate1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 on Setup1 : LastAdaptive at Freq=1MHz Phase=40deg

design 0.20_edgewise_2D (Maxwell 2D, EddyCurrent, XY geometry, model units mm)
options: ModelDepth=14.47607042mm
geometry:
  Region [vacuum] = region(percentage_offset=0 on all sides)
  Np1#6907, Np10#6959, Np11#7011, Np12#7063, Np2#7115, Np3#7167, Np4#7219, Np5#7271, Np6#7323, Np7#7375, Np8#7427, Np9#7479, Ns1#7531, Ns10#7583, Ns11#7635, Ns12#7687, Ns2#7739, Ns3#7791, Ns4#7843, Ns5#7895, Ns6#7947, Ns7#7999, Ns8#8051, Ns9#8103, plate_1#8155, plate_2#8207, Body1#8259, Body1_3#8439 = imported_body(C:\Users\karlr\Documents\0.2_edgewise.step)
  Np1 [copper] = Np1#6907.section(plane=ZX)
  Np1#6907.delete()
  Np1.rotate(axis=X, angle=-90deg)
  Np10 [copper] = Np10#6959.section(plane=ZX)
  Np10#6959.delete()
  Np10.rotate(axis=X, angle=-90deg)
  Np11 [copper] = Np11#7011.section(plane=ZX)
  Np11#7011.delete()
  Np11.rotate(axis=X, angle=-90deg)
  Np12 [copper] = Np12#7063.section(plane=ZX)
  Np12#7063.delete()
  Np12.rotate(axis=X, angle=-90deg)
  Np2 [copper] = Np2#7115.section(plane=ZX)
  Np2#7115.delete()
  Np2.rotate(axis=X, angle=-90deg)
  Np3 [copper] = Np3#7167.section(plane=ZX)
  Np3#7167.delete()
  Np3.rotate(axis=X, angle=-90deg)
  Np4 [copper] = Np4#7219.section(plane=ZX)
  Np4#7219.delete()
  Np4.rotate(axis=X, angle=-90deg)
  Np5 [copper] = Np5#7271.section(plane=ZX)
  Np5#7271.delete()
  Np5.rotate(axis=X, angle=-90deg)
  Np6 [copper] = Np6#7323.section(plane=ZX)
  Np6#7323.delete()
  Np6.rotate(axis=X, angle=-90deg)
  Np7 [copper] = Np7#7375.section(plane=ZX)
  Np7#7375.delete()
  Np7.rotate(axis=X, angle=-90deg)
  Np8 [copper] = Np8#7427.section(plane=ZX)
  Np8#7427.delete()
  Np8.rotate(axis=X, angle=-90deg)
  Np9 [copper] = Np9#7479.section(plane=ZX)
  Np9#7479.delete()
  Np9.rotate(axis=X, angle=-90deg)
  Ns1 [copper] = Ns1#7531.section(plane=ZX)
  Ns1#7531.delete()
  Ns1.rotate(axis=X, angle=-90deg)
  Ns10 [copper] = Ns10#7583.section(plane=ZX)
  Ns10#7583.delete()
  Ns10.rotate(axis=X, angle=-90deg)
  Ns11 [copper] = Ns11#7635.section(plane=ZX)
  Ns11#7635.delete()
  Ns11.rotate(axis=X, angle=-90deg)
  Ns12 [copper] = Ns12#7687.section(plane=ZX)
  Ns12#7687.delete()
  Ns12.rotate(axis=X, angle=-90deg)
  Ns2 [copper] = Ns2#7739.section(plane=ZX)
  Ns2#7739.delete()
  Ns2.rotate(axis=X, angle=-90deg)
  Ns3 [copper] = Ns3#7791.section(plane=ZX)
  Ns3#7791.delete()
  Ns3.rotate(axis=X, angle=-90deg)
  Ns4 [copper] = Ns4#7843.section(plane=ZX)
  Ns4#7843.delete()
  Ns4.rotate(axis=X, angle=-90deg)
  Ns5 [copper] = Ns5#7895.section(plane=ZX)
  Ns5#7895.delete()
  Ns5.rotate(axis=X, angle=-90deg)
  Ns6 [copper] = Ns6#7947.section(plane=ZX)
  Ns6#7947.delete()
  Ns6.rotate(axis=X, angle=-90deg)
  Ns7 [copper] = Ns7#7999.section(plane=ZX)
  Ns7#7999.delete()
  Ns7.rotate(axis=X, angle=-90deg)
  Ns8 [copper] = Ns8#8051.section(plane=ZX)
  Ns8#8051.delete()
  Ns8.rotate(axis=X, angle=-90deg)
  Ns9 [copper] = Ns9#8103.section(plane=ZX)
  Ns9#8103.delete()
  Ns9.rotate(axis=X, angle=-90deg)
  plate_1 [FR4_epoxy] = plate_1#8155.section(plane=ZX)
  plate_1#8155.delete()
  plate_1.rotate(axis=X, angle=-90deg)
  plate_2 [FR4_epoxy] = plate_2#8207.section(plane=ZX)
  plate_2#8207.delete()
  plate_2.rotate(axis=X, angle=-90deg)
  Body1 [ferrite] = Body1#8259.section(plane=ZX)
  Body1#8259.delete()
  Body1.rotate(axis=X, angle=-90deg)
  Body1_3 [ferrite] = Body1_3#8439.section(plane=ZX)
  Body1_3#8439.delete()
  Body1_3.rotate(axis=X, angle=-90deg)
  Ns12_Separate1 [copper] = Ns12.separate_bodies()
  Np1_Separate1 [copper] = Np1.separate_bodies()
  Np2_Separate1 [copper] = Np2.separate_bodies()
  Np3_Separate1 [copper] = Np3.separate_bodies()
  Np4_Separate1 [copper] = Np4.separate_bodies()
  Np5_Separate1 [copper] = Np5.separate_bodies()
  Np6_Separate1 [copper] = Np6.separate_bodies()
  Np7_Separate1 [copper] = Np7.separate_bodies()
  Np8_Separate1 [copper] = Np8.separate_bodies()
  Np9_Separate1 [copper] = Np9.separate_bodies()
  Np10_Separate1 [copper] = Np10.separate_bodies()
  Np11_Separate1 [copper] = Np11.separate_bodies()
  Np12_Separate1 [copper] = Np12.separate_bodies()
  Ns1_Separate1 [copper] = Ns1.separate_bodies()
  Ns2_Separate1 [copper] = Ns2.separate_bodies()
  Ns3_Separate1 [copper] = Ns3.separate_bodies()
  Ns4_Separate1 [copper] = Ns4.separate_bodies()
  Ns5_Separate1 [copper] = Ns5.separate_bodies()
  Ns6_Separate1 [copper] = Ns6.separate_bodies()
  Ns7_Separate1 [copper] = Ns7.separate_bodies()
  Ns8_Separate1 [copper] = Ns8.separate_bodies()
  Ns9_Separate1 [copper] = Ns9.separate_bodies()
  Ns10_Separate1 [copper] = Ns10.separate_bodies()
  Ns11_Separate1 [copper] = Ns11.separate_bodies()
  group core_assembled_edgewise = Np1, Np10, Np11, Np12, Np2..Np9, Ns1, Ns10, Ns11, Ns12, Ns2..Ns9, plate_1, plate_2, Ns12_Separate1, Np1_Separate1, Np2_Separate1, Np3_Separate1, Np4_Separate1, Np5_Separate1, Np6_Separate1, Np7_Separate1, Np8_Separate1, Np9_Separate1, Np10_Separate1, Np11_Separate1, Np12_Separate1, Ns1_Separate1, Ns2_Separate1, Ns3_Separate1, Ns4_Separate1, Ns5_Separate1, Ns6_Separate1, Ns7_Separate1, Ns8_Separate1, Ns9_Separate1, Ns10_Separate1, Ns11_Separate1
  group core_together_1 = Body1
  group core_together = Body1_3
boundaries and excitations:
  Balloon1: Balloon Edges=Region.edge(all 4)
  Np1: Coil Objects=Np1 Conductor_number=1 Winding=Primary PolarityType=Positive
  Np2: Coil Objects=Np2 Conductor_number=1 Winding=Primary PolarityType=Positive
  Np3: Coil Objects=Np3 Conductor_number=1 Winding=Primary PolarityType=Positive
  Np4: Coil Objects=Np4 Conductor_number=1 Winding=Primary PolarityType=Positive
  Np5: Coil Objects=Np5 Conductor_number=1 Winding=Primary PolarityType=Positive
  Np6: Coil Objects=Np6 Conductor_number=1 Winding=Primary PolarityType=Positive
  Np7: Coil Objects=Np7 Conductor_number=1 Winding=Primary PolarityType=Positive
  Np8: Coil Objects=Np8 Conductor_number=1 Winding=Primary PolarityType=Positive
  Np9: Coil Objects=Np9 Conductor_number=1 Winding=Primary PolarityType=Positive
  Np10: Coil Objects=Np10 Conductor_number=1 Winding=Primary PolarityType=Positive
  Np11: Coil Objects=Np11 Conductor_number=1 Winding=Primary PolarityType=Positive
  Np12: Coil Objects=Np12 Conductor_number=1 Winding=Primary PolarityType=Positive
  Np1_Separate1: Coil Objects=Np1_Separate1 Conductor_number=1 Winding=Primary PolarityType=Negative
  Np2_Separate1: Coil Objects=Np2_Separate1 Conductor_number=1 Winding=Primary PolarityType=Negative
  Np3_Separate1: Coil Objects=Np3_Separate1 Conductor_number=1 Winding=Primary PolarityType=Negative
  Np4_Separate1: Coil Objects=Np4_Separate1 Conductor_number=1 Winding=Primary PolarityType=Negative
  Np5_Separate1: Coil Objects=Np5_Separate1 Conductor_number=1 Winding=Primary PolarityType=Negative
  Np6_Separate1: Coil Objects=Np6_Separate1 Conductor_number=1 Winding=Primary PolarityType=Negative
  Np7_Separate1: Coil Objects=Np7_Separate1 Conductor_number=1 Winding=Primary PolarityType=Negative
  Np8_Separate1: Coil Objects=Np8_Separate1 Conductor_number=1 Winding=Primary PolarityType=Negative
  Np9_Separate1: Coil Objects=Np9_Separate1 Conductor_number=1 Winding=Primary PolarityType=Negative
  Np10_Separate1: Coil Objects=Np10_Separate1 Conductor_number=1 Winding=Primary PolarityType=Negative
  Np11_Separate1: Coil Objects=Np11_Separate1 Conductor_number=1 Winding=Primary PolarityType=Negative
  Np12_Separate1: Coil Objects=Np12_Separate1 Conductor_number=1 Winding=Primary PolarityType=Negative
  Ns1: Coil Objects=Ns1 Conductor_number=1 Winding=Secondary PolarityType=Negative
  Ns2: Coil Objects=Ns2 Conductor_number=1 Winding=Secondary PolarityType=Negative
  Ns3: Coil Objects=Ns3 Conductor_number=1 Winding=Secondary PolarityType=Negative
  Ns4: Coil Objects=Ns4 Conductor_number=1 Winding=Secondary PolarityType=Negative
  Ns5: Coil Objects=Ns5 Conductor_number=1 Winding=Secondary PolarityType=Negative
  Ns6: Coil Objects=Ns6 Conductor_number=1 Winding=Secondary PolarityType=Negative
  Ns7: Coil Objects=Ns7 Conductor_number=1 Winding=Secondary PolarityType=Negative
  Ns8: Coil Objects=Ns8 Conductor_number=1 Winding=Secondary PolarityType=Negative
  Ns9: Coil Objects=Ns9 Conductor_number=1 Winding=Secondary PolarityType=Negative
  Ns10: Coil Objects=Ns10 Conductor_number=1 Winding=Secondary PolarityType=Negative
  Ns11: Coil Objects=Ns11 Conductor_number=1 Winding=Secondary PolarityType=Negative
  Ns12: Coil Objects=Ns12 Conductor_number=1 Winding=Secondary PolarityType=Negative
  Ns1_Separate1: Coil Objects=Ns1_Separate1 Conductor_number=1 Winding=Secondary PolarityType=Positive
  Ns2_Separate1: Coil Objects=Ns2_Separate1 Conductor_number=1 Winding=Secondary PolarityType=Positive
  Ns3_Separate1: Coil Objects=Ns3_Separate1 Conductor_number=1 Winding=Secondary PolarityType=Positive
  Ns4_Separate1: Coil Objects=Ns4_Separate1 Conductor_number=1 Winding=Secondary PolarityType=Positive
  Ns5_Separate1: Coil Objects=Ns5_Separate1 Conductor_number=1 Winding=Secondary PolarityType=Positive
  Ns6_Separate1: Coil Objects=Ns6_Separate1 Conductor_number=1 Winding=Secondary PolarityType=Positive
  Ns7_Separate1: Coil Objects=Ns7_Separate1 Conductor_number=1 Winding=Secondary PolarityType=Positive
  Ns8_Separate1: Coil Objects=Ns8_Separate1 Conductor_number=1 Winding=Secondary PolarityType=Positive
  Ns9_Separate1: Coil Objects=Ns9_Separate1 Conductor_number=1 Winding=Secondary PolarityType=Positive
  Ns10_Separate1: Coil Objects=Ns10_Separate1 Conductor_number=1 Winding=Secondary PolarityType=Positive
  Ns11_Separate1: Coil Objects=Ns11_Separate1 Conductor_number=1 Winding=Secondary PolarityType=Positive
  Ns12_Separate1: Coil Objects=Ns12_Separate1 Conductor_number=1 Winding=Secondary PolarityType=Positive
  Primary: Winding Group Type=Current IsSolid=true Current=14.14A ParallelBranchesNum=1 Phase=0deg
  Secondary: Winding Group Type=Current IsSolid=true Current=14.14A ParallelBranchesNum=1 Phase=1deg
parameters:
  Matrix1: Matrix Primary, Secondary:
mesh:
  Length1: LengthBased RefineInside Objects=[Np1, Np1_Separate1, Np2, Np2_Separate1, Np3, Np3_Separate1, Np4, Np4_Separate1, Np5, Np5_Separate1, Np6, Np6_Separate1, Np7, Np7_Separate1, Np8, Np8_Separate1, Np9, Np9_Separate1, Np10, Np10_Separate1, Np11, Np11_Separate1, Np12, Np12_Separate1, Ns1, Ns1_Separate1, Ns2, Ns2_Separate1, Ns3, Ns3_Separate1, Ns4, Ns4_Separate1, Ns5, Ns5_Separate1, Ns6, Ns6_Separate1, Ns7, Ns7_Separate1, Ns8, Ns8_Separate1, Ns9, Ns9_Separate1, Ns10, Ns10_Separate1, Ns11, Ns11_Separate1, Ns12, Ns12_Separate1, plate_1, plate_2] MaxLength=0.2mm
  Length2: LengthBased RefineInside Objects=[Body1, Body1_3] MaxLength=2mm
setups:
  Setup1: EddyCurrent MaximumPasses=10 MinimumPasses=2 MinimumConvergedPasses=1 PercentRefinement=30 PercentError=1 NonLinearResidual=0.0001 Frequency=30000Hz

design 0.25_edgewise_2D (Maxwell 2D, EddyCurrent, XY geometry, model units mm)
options: ModelDepth=14.28587226mm
geometry:
  Region [vacuum] = region(percentage_offset=0 on all sides)
  plate_1#8622, plate_2#8674, Np1#8726, Np10#8778, Np11#8830, Np12#8882, Np2#8934, Np3#8986, Np4#9038, Np5#9090, Np6#9142, Np7#9194, Np8#9246, Np9#9298, Ns1#9350, Ns10#9402, Ns11#9454, Ns12#9506, Ns2#9558, Ns3#9610, Ns4#9662, Ns5#9714, Ns6#9766, Ns7#9818, Ns8#9870, Ns9#9922, Body1#9974, Body1_3#10154 = imported_body(C:\Users\karlr\Documents\0.25_edgewise.step)
  plate_1 [FR4_epoxy] = plate_1#8622.section(plane=ZX)
  plate_1#8622.delete()
  plate_1.rotate(axis=X, angle=-90deg)
  plate_2 [FR4_epoxy] = plate_2#8674.section(plane=ZX)
  plate_2#8674.delete()
  plate_2.rotate(axis=X, angle=-90deg)
  Np1 [copper] = Np1#8726.section(plane=ZX)
  Np1#8726.delete()
  Np1.rotate(axis=X, angle=-90deg)
  Np10 [copper] = Np10#8778.section(plane=ZX)
  Np10#8778.delete()
  Np10.rotate(axis=X, angle=-90deg)
  Np11 [copper] = Np11#8830.section(plane=ZX)
  Np11#8830.delete()
  Np11.rotate(axis=X, angle=-90deg)
  Np12 [copper] = Np12#8882.section(plane=ZX)
  Np12#8882.delete()
  Np12.rotate(axis=X, angle=-90deg)
  Np2 [copper] = Np2#8934.section(plane=ZX)
  Np2#8934.delete()
  Np2.rotate(axis=X, angle=-90deg)
  Np3 [copper] = Np3#8986.section(plane=ZX)
  Np3#8986.delete()
  Np3.rotate(axis=X, angle=-90deg)
  Np4 [copper] = Np4#9038.section(plane=ZX)
  Np4#9038.delete()
  Np4.rotate(axis=X, angle=-90deg)
  Np5 [copper] = Np5#9090.section(plane=ZX)
  Np5#9090.delete()
  Np5.rotate(axis=X, angle=-90deg)
  Np6 [copper] = Np6#9142.section(plane=ZX)
  Np6#9142.delete()
  Np6.rotate(axis=X, angle=-90deg)
  Np7 [copper] = Np7#9194.section(plane=ZX)
  Np7#9194.delete()
  Np7.rotate(axis=X, angle=-90deg)
  Np8 [copper] = Np8#9246.section(plane=ZX)
  Np8#9246.delete()
  Np8.rotate(axis=X, angle=-90deg)
  Np9 [copper] = Np9#9298.section(plane=ZX)
  Np9#9298.delete()
  Np9.rotate(axis=X, angle=-90deg)
  Ns1 [copper] = Ns1#9350.section(plane=ZX)
  Ns1#9350.delete()
  Ns1.rotate(axis=X, angle=-90deg)
  Ns10 [copper] = Ns10#9402.section(plane=ZX)
  Ns10#9402.delete()
  Ns10.rotate(axis=X, angle=-90deg)
  Ns11 [copper] = Ns11#9454.section(plane=ZX)
  Ns11#9454.delete()
  Ns11.rotate(axis=X, angle=-90deg)
  Ns12 [copper] = Ns12#9506.section(plane=ZX)
  Ns12#9506.delete()
  Ns12.rotate(axis=X, angle=-90deg)
  Ns2 [copper] = Ns2#9558.section(plane=ZX)
  Ns2#9558.delete()
  Ns2.rotate(axis=X, angle=-90deg)
  Ns3 [copper] = Ns3#9610.section(plane=ZX)
  Ns3#9610.delete()
  Ns3.rotate(axis=X, angle=-90deg)
  Ns4 [copper] = Ns4#9662.section(plane=ZX)
  Ns4#9662.delete()
  Ns4.rotate(axis=X, angle=-90deg)
  Ns5 [copper] = Ns5#9714.section(plane=ZX)
  Ns5#9714.delete()
  Ns5.rotate(axis=X, angle=-90deg)
  Ns6 [copper] = Ns6#9766.section(plane=ZX)
  Ns6#9766.delete()
  Ns6.rotate(axis=X, angle=-90deg)
  Ns7 [copper] = Ns7#9818.section(plane=ZX)
  Ns7#9818.delete()
  Ns7.rotate(axis=X, angle=-90deg)
  Ns8 [copper] = Ns8#9870.section(plane=ZX)
  Ns8#9870.delete()
  Ns8.rotate(axis=X, angle=-90deg)
  Ns9 [copper] = Ns9#9922.section(plane=ZX)
  Ns9#9922.delete()
  Ns9.rotate(axis=X, angle=-90deg)
  Body1 [ferrite] = Body1#9974.section(plane=ZX)
  Body1#9974.delete()
  Body1.rotate(axis=X, angle=-90deg)
  Body1_3 [ferrite] = Body1_3#10154.section(plane=ZX)
  Body1_3#10154.delete()
  Body1_3.rotate(axis=X, angle=-90deg)
  Np1_Separate1 [copper] = Np1.separate_bodies()
  Np2_Separate1 [copper] = Np2.separate_bodies()
  Np3_Separate1 [copper] = Np3.separate_bodies()
  Np4_Separate1 [copper] = Np4.separate_bodies()
  Np5_Separate1 [copper] = Np5.separate_bodies()
  Np6_Separate1 [copper] = Np6.separate_bodies()
  Np7_Separate1 [copper] = Np7.separate_bodies()
  Np8_Separate1 [copper] = Np8.separate_bodies()
  Np9_Separate1 [copper] = Np9.separate_bodies()
  Np10_Separate1 [copper] = Np10.separate_bodies()
  Np11_Separate1 [copper] = Np11.separate_bodies()
  Np12_Separate1 [copper] = Np12.separate_bodies()
  Ns1_Separate1 [copper] = Ns1.separate_bodies()
  Ns2_Separate1 [copper] = Ns2.separate_bodies()
  Ns3_Separate1 [copper] = Ns3.separate_bodies()
  Ns4_Separate1 [copper] = Ns4.separate_bodies()
  Ns5_Separate1 [copper] = Ns5.separate_bodies()
  Ns6_Separate1 [copper] = Ns6.separate_bodies()
  Ns7_Separate1 [copper] = Ns7.separate_bodies()
  Ns8_Separate1 [copper] = Ns8.separate_bodies()
  Ns9_Separate1 [copper] = Ns9.separate_bodies()
  Ns10_Separate1 [copper] = Ns10.separate_bodies()
  Ns11_Separate1 [copper] = Ns11.separate_bodies()
  Ns12_Separate1 [copper] = Ns12.separate_bodies()
  group core_assembled_edgewise = plate_1, plate_2, Np1, Np10, Np11, Np12, Np2..Np9, Ns1, Ns10, Ns11, Ns12, Ns2..Ns9, Np1_Separate1, Np2_Separate1, Np3_Separate1, Np4_Separate1, Np5_Separate1, Np6_Separate1, Np7_Separate1, Np8_Separate1, Np9_Separate1, Np10_Separate1, Np11_Separate1, Np12_Separate1, Ns1_Separate1, Ns2_Separate1, Ns3_Separate1, Ns4_Separate1, Ns5_Separate1, Ns6_Separate1, Ns7_Separate1, Ns8_Separate1, Ns9_Separate1, Ns10_Separate1, Ns11_Separate1, Ns12_Separate1
  group core_together_1 = Body1
  group core_together = Body1_3
boundaries and excitations:
  Balloon1: Balloon Edges=Region.edge(all 4)
  Np1: Coil Objects=Np1 Conductor_number=1 Winding=Primary PolarityType=Positive
  Np2: Coil Objects=Np2 Conductor_number=1 Winding=Primary PolarityType=Positive
  Np3: Coil Objects=Np3 Conductor_number=1 Winding=Primary PolarityType=Positive
  Np4: Coil Objects=Np4 Conductor_number=1 Winding=Primary PolarityType=Positive
  Np5: Coil Objects=Np5 Conductor_number=1 Winding=Primary PolarityType=Positive
  Np6: Coil Objects=Np6 Conductor_number=1 Winding=Primary PolarityType=Positive
  Np7: Coil Objects=Np7 Conductor_number=1 Winding=Primary PolarityType=Positive
  Np8: Coil Objects=Np8 Conductor_number=1 Winding=Primary PolarityType=Positive
  Np9: Coil Objects=Np9 Conductor_number=1 Winding=Primary PolarityType=Positive
  Np10: Coil Objects=Np10 Conductor_number=1 Winding=Primary PolarityType=Positive
  Np11: Coil Objects=Np11 Conductor_number=1 Winding=Primary PolarityType=Positive
  Np12: Coil Objects=Np12 Conductor_number=1 Winding=Primary PolarityType=Positive
  Np1_Separate1: Coil Objects=Np1_Separate1 Conductor_number=1 Winding=Primary PolarityType=Negative
  Np2_Separate1: Coil Objects=Np2_Separate1 Conductor_number=1 Winding=Primary PolarityType=Negative
  Np3_Separate1: Coil Objects=Np3_Separate1 Conductor_number=1 Winding=Primary PolarityType=Negative
  Np4_Separate1: Coil Objects=Np4_Separate1 Conductor_number=1 Winding=Primary PolarityType=Negative
  Np5_Separate1: Coil Objects=Np5_Separate1 Conductor_number=1 Winding=Primary PolarityType=Negative
  Np6_Separate1: Coil Objects=Np6_Separate1 Conductor_number=1 Winding=Primary PolarityType=Negative
  Np7_Separate1: Coil Objects=Np7_Separate1 Conductor_number=1 Winding=Primary PolarityType=Negative
  Np8_Separate1: Coil Objects=Np8_Separate1 Conductor_number=1 Winding=Primary PolarityType=Negative
  Np9_Separate1: Coil Objects=Np9_Separate1 Conductor_number=1 Winding=Primary PolarityType=Negative
  Np10_Separate1: Coil Objects=Np10_Separate1 Conductor_number=1 Winding=Primary PolarityType=Negative
  Np11_Separate1: Coil Objects=Np11_Separate1 Conductor_number=1 Winding=Primary PolarityType=Negative
  Np12_Separate1: Coil Objects=Np12_Separate1 Conductor_number=1 Winding=Primary PolarityType=Negative
  Ns1: Coil Objects=Ns1 Conductor_number=1 Winding=Secondary PolarityType=Negative
  Ns2: Coil Objects=Ns2 Conductor_number=1 Winding=Secondary PolarityType=Negative
  Ns3: Coil Objects=Ns3 Conductor_number=1 Winding=Secondary PolarityType=Negative
  Ns4: Coil Objects=Ns4 Conductor_number=1 Winding=Secondary PolarityType=Negative
  Ns5: Coil Objects=Ns5 Conductor_number=1 Winding=Secondary PolarityType=Negative
  Ns6: Coil Objects=Ns6 Conductor_number=1 Winding=Secondary PolarityType=Negative
  Ns7: Coil Objects=Ns7 Conductor_number=1 Winding=Secondary PolarityType=Negative
  Ns8: Coil Objects=Ns8 Conductor_number=1 Winding=Secondary PolarityType=Negative
  Ns9: Coil Objects=Ns9 Conductor_number=1 Winding=Secondary PolarityType=Negative
  Ns10: Coil Objects=Ns10 Conductor_number=1 Winding=Secondary PolarityType=Negative
  Ns11: Coil Objects=Ns11 Conductor_number=1 Winding=Secondary PolarityType=Negative
  Ns12: Coil Objects=Ns12 Conductor_number=1 Winding=Secondary PolarityType=Negative
  Ns1_Separate1: Coil Objects=Ns1_Separate1 Conductor_number=1 Winding=Secondary PolarityType=Positive
  Ns2_Separate1: Coil Objects=Ns2_Separate1 Conductor_number=1 Winding=Secondary PolarityType=Positive
  Ns3_Separate1: Coil Objects=Ns3_Separate1 Conductor_number=1 Winding=Secondary PolarityType=Positive
  Ns4_Separate1: Coil Objects=Ns4_Separate1 Conductor_number=1 Winding=Secondary PolarityType=Positive
  Ns5_Separate1: Coil Objects=Ns5_Separate1 Conductor_number=1 Winding=Secondary PolarityType=Positive
  Ns6_Separate1: Coil Objects=Ns6_Separate1 Conductor_number=1 Winding=Secondary PolarityType=Positive
  Ns7_Separate1: Coil Objects=Ns7_Separate1 Conductor_number=1 Winding=Secondary PolarityType=Positive
  Ns8_Separate1: Coil Objects=Ns8_Separate1 Conductor_number=1 Winding=Secondary PolarityType=Positive
  Ns9_Separate1: Coil Objects=Ns9_Separate1 Conductor_number=1 Winding=Secondary PolarityType=Positive
  Ns10_Separate1: Coil Objects=Ns10_Separate1 Conductor_number=1 Winding=Secondary PolarityType=Positive
  Ns11_Separate1: Coil Objects=Ns11_Separate1 Conductor_number=1 Winding=Secondary PolarityType=Positive
  Ns12_Separate1: Coil Objects=Ns12_Separate1 Conductor_number=1 Winding=Secondary PolarityType=Positive
  Primary: Winding Group Type=Current IsSolid=true Current=14.14A ParallelBranchesNum=1 Phase=0deg
  Secondary: Winding Group Type=Current IsSolid=true Current=14.14A ParallelBranchesNum=1 Phase=1deg
parameters:
  Matrix1: Matrix Primary, Secondary:
mesh:
  Length1: LengthBased RefineInside Objects=[Body1_3, Body1] MaxLength=2mm
  Length2: LengthBased RefineInside Objects=[Np1, Np1_Separate1, Np2, Np2_Separate1, Np3, Np3_Separate1, Np4, Np4_Separate1, Np5, Np5_Separate1, Np6, Np6_Separate1, Np7, Np7_Separate1, Np8, Np8_Separate1, Np9, Np9_Separate1, Np10, Np10_Separate1, Np11, Np11_Separate1, Np12, Np12_Separate1, Ns1, Ns1_Separate1, Ns2, Ns2_Separate1, Ns3, Ns3_Separate1, Ns4, Ns4_Separate1, Ns5, Ns5_Separate1, Ns6, Ns6_Separate1, Ns7, Ns7_Separate1, Ns8, Ns8_Separate1, Ns9, Ns9_Separate1, Ns10, Ns10_Separate1, Ns11, Ns11_Separate1, Ns12, Ns12_Separate1, plate_1, plate_2] MaxLength=0.2mm
setups:
  Setup1: EddyCurrent MaximumPasses=10 MinimumPasses=2 MinimumConvergedPasses=1 PercentRefinement=30 PercentError=1 NonLinearResidual=0.0001 Frequency=30000Hz

design IcepakDesign1 (Icepak, SteadyState TemperatureAndFlow, model units mm)
options: Default_Fluid_Material=air Default_Solid_Material=Al-Extruded Default_Surface_Material=Steel-oxidised-surface AmbientTemperature=20cel AmbientPressure=0n_per_meter_sq AmbientRadiationTemperature=20cel Gravity_Vector_CS_ID=Global Gravity_Vector_Axis=Z Positive=false Altitude=0meter OperatingPressure=101325n_per_meter_sq OperatingDensity=1.225kg_per_m3
geometry:
  plate_1, plate_2 [Material1] = imported_body(C:\Users\karlr\Documents\0.3_edgewise.step)
  Np1 [copper] = imported_body(C:\Users\karlr\Documents\0.3_edgewise.step)
  Np1_Section1 [copper] = Np1.section(plane=ZX)
  Np10 [copper] = imported_body(C:\Users\karlr\Documents\0.3_edgewise.step)
  Np10_Section1 [copper] = Np10.section(plane=ZX)
  Np11 [copper] = imported_body(C:\Users\karlr\Documents\0.3_edgewise.step)
  Np11_Section1 [copper] = Np11.section(plane=ZX)
  Np12 [copper] = imported_body(C:\Users\karlr\Documents\0.3_edgewise.step)
  Np12_Section1 [copper] = Np12.section(plane=ZX)
  Np2 [copper] = imported_body(C:\Users\karlr\Documents\0.3_edgewise.step)
  Np2_Section1 [copper] = Np2.section(plane=ZX)
  Np3 [copper] = imported_body(C:\Users\karlr\Documents\0.3_edgewise.step)
  Np3_Section1 [copper] = Np3.section(plane=ZX)
  Np4 [copper] = imported_body(C:\Users\karlr\Documents\0.3_edgewise.step)
  Np4_Section1 [copper] = Np4.section(plane=ZX)
  Np5 [copper] = imported_body(C:\Users\karlr\Documents\0.3_edgewise.step)
  Np5_Section1 [copper] = Np5.section(plane=ZX)
  Np6 [copper] = imported_body(C:\Users\karlr\Documents\0.3_edgewise.step)
  Np6_Section1 [copper] = Np6.section(plane=ZX)
  Np7 [copper] = imported_body(C:\Users\karlr\Documents\0.3_edgewise.step)
  Np7_Section1 [copper] = Np7.section(plane=ZX)
  Np8 [copper] = imported_body(C:\Users\karlr\Documents\0.3_edgewise.step)
  Np8_Section1 [copper] = Np8.section(plane=ZX)
  Np9 [copper] = imported_body(C:\Users\karlr\Documents\0.3_edgewise.step)
  Np9_Section1 [copper] = Np9.section(plane=ZX)
  Ns1 [copper] = imported_body(C:\Users\karlr\Documents\0.3_edgewise.step)
  Ns1_Section1 [copper] = Ns1.section(plane=ZX)
  Ns10 [copper] = imported_body(C:\Users\karlr\Documents\0.3_edgewise.step)
  Ns10_Section1 [copper] = Ns10.section(plane=ZX)
  Ns11 [copper] = imported_body(C:\Users\karlr\Documents\0.3_edgewise.step)
  Ns11_Section1 [copper] = Ns11.section(plane=ZX)
  Ns12 [copper] = imported_body(C:\Users\karlr\Documents\0.3_edgewise.step)
  Ns12_Section1 [copper] = Ns12.section(plane=ZX)
  Ns2 [copper] = imported_body(C:\Users\karlr\Documents\0.3_edgewise.step)
  Ns2_Section1 [copper] = Ns2.section(plane=ZX)
  Ns3 [copper] = imported_body(C:\Users\karlr\Documents\0.3_edgewise.step)
  Ns3_Section1 [copper] = Ns3.section(plane=ZX)
  Ns4 [copper] = imported_body(C:\Users\karlr\Documents\0.3_edgewise.step)
  Ns4_Section1 [copper] = Ns4.section(plane=ZX)
  Ns5 [copper] = imported_body(C:\Users\karlr\Documents\0.3_edgewise.step)
  Ns5_Section1 [copper] = Ns5.section(plane=ZX)
  Ns6 [copper] = imported_body(C:\Users\karlr\Documents\0.3_edgewise.step)
  Ns6_Section1 [copper] = Ns6.section(plane=ZX)
  Ns7 [copper] = imported_body(C:\Users\karlr\Documents\0.3_edgewise.step)
  Ns7_Section1 [copper] = Ns7.section(plane=ZX)
  Ns8 [copper] = imported_body(C:\Users\karlr\Documents\0.3_edgewise.step)
  Ns8_Section1 [copper] = Ns8.section(plane=ZX)
  Ns9 [copper] = imported_body(C:\Users\karlr\Documents\0.3_edgewise.step)
  Ns9_Section1 [copper] = Ns9.section(plane=ZX)
  Body1 [ferrite] = imported_body(C:\Users\karlr\Documents\0.3_edgewise.step)
  Body1_1, Body1_2 [aluminum] = imported_body(C:\Users\karlr\Documents\0.3_edgewise.step)
  Body1_3 [ferrite] = imported_body(C:\Users\karlr\Documents\0.3_edgewise.step)
  Body1_4, Body1_5 [aluminum] = imported_body(C:\Users\karlr\Documents\0.3_edgewise.step)
  Np1_Section1.separate_bodies()
  Np2_Section1.separate_bodies()
  Np3_Section1.separate_bodies()
  Np4_Section1.separate_bodies()
  Np5_Section1.separate_bodies()
  Np6_Section1.separate_bodies()
  Np7_Section1.separate_bodies()
  Np8_Section1.separate_bodies()
  Np9_Section1.separate_bodies()
  Np10_Section1.separate_bodies()
  Np11_Section1.separate_bodies()
  Np12_Section1.separate_bodies()
  Ns1_Section1.separate_bodies()
  Ns2_Section1.separate_bodies()
  Ns3_Section1.separate_bodies()
  Ns4_Section1.separate_bodies()
  Ns5_Section1.separate_bodies()
  Ns6_Section1.separate_bodies()
  Ns7_Section1.separate_bodies()
  Ns8_Section1.separate_bodies()
  Ns9_Section1.separate_bodies()
  Ns10_Section1.separate_bodies()
  Ns11_Section1.separate_bodies()
  Ns12_Section1.separate_bodies()
  Region [air] = region(percentage_offset=1000 on all sides)
  MeshRegion1_SubRegion [air, non-model] = sub_region(of=plate_1, percentage_offset=0 on all sides)
  MeshRegion2_SubRegion [air, non-model] = sub_region(of=plate_2, percentage_offset=0 on all sides)
  Rectangle1 [Al-Extruded, non-model] = rectangle(corner=(0mm, 0mm, 0mm), z_size=19.7mm, x_size=39.8mm)
  group core_assembled_edgewise = plate_1, plate_2, Np1, Np10, Np11, Np12, Np2..Np9, Ns1, Ns10, Ns11, Ns12, Ns2..Ns9, Np1_Section1, Np2_Section1, Np3_Section1, Np4_Section1, Np5_Section1, Np6_Section1, Np7_Section1, Np8_Section1, Np9_Section1, Np10_Section1, Np11_Section1, Np12_Section1, Ns1_Section1, Ns2_Section1, Ns3_Section1, Ns4_Section1, Ns5_Section1, Ns6_Section1, Ns7_Section1, Ns8_Section1, Ns9_Section1, Ns10_Section1, Ns11_Section1, Ns12_Section1
  group core_together_1 = Body1, Body1_1, Body1_2
  group core_together = Body1_3, Body1_4, Body1_5
boundaries and excitations:
  Opening1: Opening Faces=Region.face(-y) Temperature=AmbientTemp External_Rad._Temperature=AmbientRadTemp Inlet_Type=Pressure Total_Pressure=AmbientPressure
  Opening2: Opening Faces=Region.face(+z) Temperature=AmbientTemp External_Rad._Temperature=AmbientRadTemp Inlet_Type=Pressure Total_Pressure=AmbientPressure
  Opening3: Opening Faces=Region.face(+x) Temperature=AmbientTemp External_Rad._Temperature=AmbientRadTemp Inlet_Type=Pressure Total_Pressure=AmbientPressure
  Opening4: Opening Faces=Region.face(+y) Temperature=AmbientTemp External_Rad._Temperature=AmbientRadTemp Inlet_Type=Pressure Total_Pressure=AmbientPressure
  Opening5: Opening Faces=Region.face(-x) Temperature=AmbientTemp External_Rad._Temperature=AmbientRadTemp Inlet_Type=Pressure Total_Pressure=AmbientPressure
  Opening6: Opening Faces=Region.face(-z) Temperature=AmbientTemp External_Rad._Temperature=AmbientRadTemp Inlet_Type=Pressure Total_Pressure=AmbientPressure
  StationaryWall3: Stationary Wall Faces=Body1_5.face(at (19.9, 19.143, 0)) Body1_3.face(at (19.9, 7.09649, 0)) Body1_4.face(at (19.9, -4.95, 0)) Body1_2.face(at (19.9, 19.143, 19.7)) Body1.face(at (19.9, 7.09649, 19.7)) Body1_1.face(at (19.9, -4.95, 19.7)) Thickness=0mm Solid_Material=Al-Extruded External_Condition="Heat Transfer Coefficient" Heat_Flux=0irrad_W_per_m2 Temperature=AmbientTemp Heat_Transfer_Coefficient=250w_per_m2kel Reference_Temperature=AmbientTemp Heat_Transfer_Data{Heat_Transfer_Convection_Type="Forced Convection"} External_Material=Steel-oxidised-surface External_Radiation_Reference_Temperature=AmbientTemp External_Radiation_View_Factor=1
  Block1: Block Objects=[Np1..Np12, Ns1..Ns12] Block_Type=Solid Use_Total_Power Total_Power="(20/24) W"
mesh:
  Global:  MeshMethod=MesherHD ComputeGap MeshRegionResolution=5 MinGapX=1mm MinGapY=1mm MinGapZ=1mm Objects=Region FacetLevel=5 ProximitySizeFunction CurvatureSizeFunction OptimizePCBMesh
  MeshRegion1:  MeshMethod=MesherHD MeshRegionResolution=5 MinGapX=1mm MinGapY=1mm MinGapZ=0.0099999983mm Objects=MeshRegion1_SubRegion ProximitySizeFunction CurvatureSizeFunction OptimizePCBMesh
  MeshRegion2:  MeshMethod=MesherHD MeshRegionResolution=5 MinGapX=1mm MinGapY=1mm MinGapZ=0.0099999983mm Objects=MeshRegion2_SubRegion ProximitySizeFunction CurvatureSizeFunction OptimizePCBMesh
setups:
  Setup1: IcepakSteadyState Flow_Regime=Laminar Include_Temperature=true Include_Flow=true Include_Gravity Solution_Initialization_-_Z_Velocity=0.000980665m_per_sec Convergence_Criteria_-_Flow=0.001 Convergence_Criteria_-_Energy=1e-07 Convergence_Criteria_-_Discrete_Ordinates=1e-06 GPU_Convergence_Criteria_-_Flow=0.001 GPU_Convergence_Criteria_-_Energy=1e-05 GPU_Convergence_Criteria_-_Discrete_Ordinates=1e-05 Radiation_Model="Discrete Ordinates Model" Flow_Iteration_Per_Radiation_Iteration=10 Time_Step_Interval=1 ThetaDivision=2 PhiDivision=2 ThetaPixels=2 PhiPixels=2 Under-relaxation_-_Pressure=0.7 Under-relaxation_-_Momentum=0.3 Under-relaxation_-_Temperature=1 Under-relaxation_-_Body_Force=1 Discretization_Scheme_-_Pressure=Standard Discretization_Scheme_-_Momentum=First Discretization_Scheme_-_Temperature=First Discretization_Scheme_-_Discrete_Ordinates=First Convergence_Criteria_-_Max_Iterations=500

design Coupled_Loss (Icepak, SteadyState TemperatureAndFlow, model units mm)
options: Default_Fluid_Material=air Default_Solid_Material=Al-Extruded Default_Surface_Material=Steel-oxidised-surface AmbientTemperature=20cel AmbientPressure=0n_per_meter_sq AmbientRadiationTemperature=20cel Gravity_Vector_CS_ID=Global Gravity_Vector_Axis=Z Positive=false Altitude=0meter OperatingPressure=101325n_per_meter_sq OperatingDensity=1.225kg_per_m3
geometry:
  plate_1, plate_2 [Material1] = imported_body(C:\Users\karlr\Documents\0.3_edgewise.step)
  Np1 [copper] = imported_body(C:\Users\karlr\Documents\0.3_edgewise.step)
  Np1_Section1 [copper] = Np1.section(plane=ZX)
  Np10 [copper] = imported_body(C:\Users\karlr\Documents\0.3_edgewise.step)
  Np10_Section1 [copper] = Np10.section(plane=ZX)
  Np11 [copper] = imported_body(C:\Users\karlr\Documents\0.3_edgewise.step)
  Np11_Section1 [copper] = Np11.section(plane=ZX)
  Np12 [copper] = imported_body(C:\Users\karlr\Documents\0.3_edgewise.step)
  Np12_Section1 [copper] = Np12.section(plane=ZX)
  Np2 [copper] = imported_body(C:\Users\karlr\Documents\0.3_edgewise.step)
  Np2_Section1 [copper] = Np2.section(plane=ZX)
  Np3 [copper] = imported_body(C:\Users\karlr\Documents\0.3_edgewise.step)
  Np3_Section1 [copper] = Np3.section(plane=ZX)
  Np4 [copper] = imported_body(C:\Users\karlr\Documents\0.3_edgewise.step)
  Np4_Section1 [copper] = Np4.section(plane=ZX)
  Np5 [copper] = imported_body(C:\Users\karlr\Documents\0.3_edgewise.step)
  Np5_Section1 [copper] = Np5.section(plane=ZX)
  Np6 [copper] = imported_body(C:\Users\karlr\Documents\0.3_edgewise.step)
  Np6_Section1 [copper] = Np6.section(plane=ZX)
  Np7 [copper] = imported_body(C:\Users\karlr\Documents\0.3_edgewise.step)
  Np7_Section1 [copper] = Np7.section(plane=ZX)
  Np8 [copper] = imported_body(C:\Users\karlr\Documents\0.3_edgewise.step)
  Np8_Section1 [copper] = Np8.section(plane=ZX)
  Np9 [copper] = imported_body(C:\Users\karlr\Documents\0.3_edgewise.step)
  Np9_Section1 [copper] = Np9.section(plane=ZX)
  Ns1 [copper] = imported_body(C:\Users\karlr\Documents\0.3_edgewise.step)
  Ns1_Section1 [copper] = Ns1.section(plane=ZX)
  Ns10 [copper] = imported_body(C:\Users\karlr\Documents\0.3_edgewise.step)
  Ns10_Section1 [copper] = Ns10.section(plane=ZX)
  Ns11 [copper] = imported_body(C:\Users\karlr\Documents\0.3_edgewise.step)
  Ns11_Section1 [copper] = Ns11.section(plane=ZX)
  Ns12 [copper] = imported_body(C:\Users\karlr\Documents\0.3_edgewise.step)
  Ns12_Section1 [copper] = Ns12.section(plane=ZX)
  Ns2 [copper] = imported_body(C:\Users\karlr\Documents\0.3_edgewise.step)
  Ns2_Section1 [copper] = Ns2.section(plane=ZX)
  Ns3 [copper] = imported_body(C:\Users\karlr\Documents\0.3_edgewise.step)
  Ns3_Section1 [copper] = Ns3.section(plane=ZX)
  Ns4 [copper] = imported_body(C:\Users\karlr\Documents\0.3_edgewise.step)
  Ns4_Section1 [copper] = Ns4.section(plane=ZX)
  Ns5 [copper] = imported_body(C:\Users\karlr\Documents\0.3_edgewise.step)
  Ns5_Section1 [copper] = Ns5.section(plane=ZX)
  Ns6 [copper] = imported_body(C:\Users\karlr\Documents\0.3_edgewise.step)
  Ns6_Section1 [copper] = Ns6.section(plane=ZX)
  Ns7 [copper] = imported_body(C:\Users\karlr\Documents\0.3_edgewise.step)
  Ns7_Section1 [copper] = Ns7.section(plane=ZX)
  Ns8 [copper] = imported_body(C:\Users\karlr\Documents\0.3_edgewise.step)
  Ns8_Section1 [copper] = Ns8.section(plane=ZX)
  Ns9 [copper] = imported_body(C:\Users\karlr\Documents\0.3_edgewise.step)
  Ns9_Section1 [copper] = Ns9.section(plane=ZX)
  Body1 [ferrite] = imported_body(C:\Users\karlr\Documents\0.3_edgewise.step)
  Body1_1, Body1_2 [aluminum] = imported_body(C:\Users\karlr\Documents\0.3_edgewise.step)
  Body1_3 [ferrite] = imported_body(C:\Users\karlr\Documents\0.3_edgewise.step)
  Body1_4, Body1_5 [aluminum] = imported_body(C:\Users\karlr\Documents\0.3_edgewise.step)
  Np1_Section1.separate_bodies()
  Np2_Section1.separate_bodies()
  Np3_Section1.separate_bodies()
  Np4_Section1.separate_bodies()
  Np5_Section1.separate_bodies()
  Np6_Section1.separate_bodies()
  Np7_Section1.separate_bodies()
  Np8_Section1.separate_bodies()
  Np9_Section1.separate_bodies()
  Np10_Section1.separate_bodies()
  Np11_Section1.separate_bodies()
  Np12_Section1.separate_bodies()
  Ns1_Section1.separate_bodies()
  Ns2_Section1.separate_bodies()
  Ns3_Section1.separate_bodies()
  Ns4_Section1.separate_bodies()
  Ns5_Section1.separate_bodies()
  Ns6_Section1.separate_bodies()
  Ns7_Section1.separate_bodies()
  Ns8_Section1.separate_bodies()
  Ns9_Section1.separate_bodies()
  Ns10_Section1.separate_bodies()
  Ns11_Section1.separate_bodies()
  Ns12_Section1.separate_bodies()
  Region [air] = region(percentage_offset=1000 on all sides)
  group core_assembled_edgewise = plate_1, plate_2, Np1, Np10, Np11, Np12, Np2..Np9, Ns1, Ns10, Ns11, Ns12, Ns2..Ns9, Np1_Section1, Np2_Section1, Np3_Section1, Np4_Section1, Np5_Section1, Np6_Section1, Np7_Section1, Np8_Section1, Np9_Section1, Np10_Section1, Np11_Section1, Np12_Section1, Ns1_Section1, Ns2_Section1, Ns3_Section1, Ns4_Section1, Ns5_Section1, Ns6_Section1, Ns7_Section1, Ns8_Section1, Ns9_Section1, Ns10_Section1, Ns11_Section1, Ns12_Section1
  group core_together_1 = Body1, Body1_1, Body1_2
  group core_together = Body1_3, Body1_4, Body1_5
boundaries and excitations:
  EMLoss1: EM Loss Objects=[Body1, Body1_1..Body1_5, Np1..Np12, Ns1..Ns12, plate_1, plate_2] LinkID=6 Project="This Project*" Product="Maxwell 3D" Design=0.30_edgewise_3D1 ForceSourceToSolve PathRelativeTo=TargetProject LossMultiplier=1
  Opening1: Opening Faces=Region.face(-y) Temperature=AmbientTemp External_Rad._Temperature=AmbientRadTemp Inlet_Type=Velocity Static_Pressure=AmbientPressure X_Velocity=0m_per_sec Y_Velocity=0m_per_sec Z_Velocity=0m_per_sec
  Opening2: Opening Faces=Region.face(+y) Temperature=AmbientTemp External_Rad._Temperature=AmbientRadTemp Inlet_Type=Pressure Total_Pressure=AmbientPressure
mesh:
  Global:  MeshMethod=MesherHD ComputeGap MeshRegionResolution=5 MinGapX=1mm MinGapY=1mm MinGapZ=1mm Objects=Region FacetLevel=5 ProximitySizeFunction CurvatureSizeFunction OptimizePCBMesh
setups:
  Setup1: IcepakSteadyState Flow_Regime=Laminar Include_Temperature=true Include_Flow=true Include_Gravity Solution_Initialization_-_Z_Velocity=0.000980665m_per_sec Convergence_Criteria_-_Flow=0.001 Convergence_Criteria_-_Energy=1e-07 Convergence_Criteria_-_Discrete_Ordinates=1e-06 GPU_Convergence_Criteria_-_Flow=0.001 GPU_Convergence_Criteria_-_Energy=1e-05 GPU_Convergence_Criteria_-_Discrete_Ordinates=1e-05 Radiation_Model="Discrete Ordinates Model" Flow_Iteration_Per_Radiation_Iteration=10 Time_Step_Interval=1 ThetaDivision=2 PhiDivision=2 ThetaPixels=2 PhiPixels=2 Under-relaxation_-_Pressure=0.7 Under-relaxation_-_Momentum=0.3 Under-relaxation_-_Temperature=1 Under-relaxation_-_Body_Force=1 Discretization_Scheme_-_Pressure=Standard Discretization_Scheme_-_Momentum=First Discretization_Scheme_-_Temperature=First Discretization_Scheme_-_Discrete_Ordinates=First Convergence_Criteria_-_Max_Iterations=100
field plots:
  Temperature1: Temperature over plate_1.face(all 10) plate_2.face(all 10) Np1.face(all 10) Np10.face(all 10) Np11.face(all 10) Np12.face(all 10) Np2.face(all 10) Np3.face(all 10) Np4.face(all 10) Np5.face(all 10) Np6.face(all 10) Np7.face(all 10) Np8.face(all 10) Np9.face(all 10) Ns1.face(all 10) Ns10.face(all 10) Ns11.face(all 10) Ns12.face(all 10) Ns2.face(all 10) Ns3.face(all 10) Ns4.face(all 10) Ns5.face(all 10) Ns6.face(all 10) Ns7.face(all 10) Ns8.face(all 10) Ns9.face(all 10) Body1.face(all 14) Body1_1.face(all 10) Body1_2.face(all 10) Body1_3.face(all 14) Body1_4.face(all 10) Body1_5.face(all 10) on Setup1 : SteadyState

design 0.30_NaturalCooling_30W (Icepak, SteadyState TemperatureAndFlow, model units mm)
options: Default_Fluid_Material=air Default_Solid_Material=Al-Extruded Default_Surface_Material=Steel-oxidised-surface AmbientTemperature=20cel AmbientPressure=0n_per_meter_sq AmbientRadiationTemperature=20cel Gravity_Vector_CS_ID=Global Gravity_Vector_Axis=Z Positive=false Altitude=0meter OperatingPressure=101325n_per_meter_sq OperatingDensity=1.225kg_per_m3
geometry:
  plate_1, plate_2 [Material1] = imported_body(C:\Users\karlr\Documents\0.3_edgewise.step)
  Np1 [copper] = imported_body(C:\Users\karlr\Documents\0.3_edgewise.step)
  Np1_Section1 [copper] = Np1.section(plane=ZX)
  Np10 [copper] = imported_body(C:\Users\karlr\Documents\0.3_edgewise.step)
  Np10_Section1 [copper] = Np10.section(plane=ZX)
  Np11 [copper] = imported_body(C:\Users\karlr\Documents\0.3_edgewise.step)
  Np11_Section1 [copper] = Np11.section(plane=ZX)
  Np12 [copper] = imported_body(C:\Users\karlr\Documents\0.3_edgewise.step)
  Np12_Section1 [copper] = Np12.section(plane=ZX)
  Np2 [copper] = imported_body(C:\Users\karlr\Documents\0.3_edgewise.step)
  Np2_Section1 [copper] = Np2.section(plane=ZX)
  Np3 [copper] = imported_body(C:\Users\karlr\Documents\0.3_edgewise.step)
  Np3_Section1 [copper] = Np3.section(plane=ZX)
  Np4 [copper] = imported_body(C:\Users\karlr\Documents\0.3_edgewise.step)
  Np4_Section1 [copper] = Np4.section(plane=ZX)
  Np5 [copper] = imported_body(C:\Users\karlr\Documents\0.3_edgewise.step)
  Np5_Section1 [copper] = Np5.section(plane=ZX)
  Np6 [copper] = imported_body(C:\Users\karlr\Documents\0.3_edgewise.step)
  Np6_Section1 [copper] = Np6.section(plane=ZX)
  Np7 [copper] = imported_body(C:\Users\karlr\Documents\0.3_edgewise.step)
  Np7_Section1 [copper] = Np7.section(plane=ZX)
  Np8 [copper] = imported_body(C:\Users\karlr\Documents\0.3_edgewise.step)
  Np8_Section1 [copper] = Np8.section(plane=ZX)
  Np9 [copper] = imported_body(C:\Users\karlr\Documents\0.3_edgewise.step)
  Np9_Section1 [copper] = Np9.section(plane=ZX)
  Ns1 [copper] = imported_body(C:\Users\karlr\Documents\0.3_edgewise.step)
  Ns1_Section1 [copper] = Ns1.section(plane=ZX)
  Ns10 [copper] = imported_body(C:\Users\karlr\Documents\0.3_edgewise.step)
  Ns10_Section1 [copper] = Ns10.section(plane=ZX)
  Ns11 [copper] = imported_body(C:\Users\karlr\Documents\0.3_edgewise.step)
  Ns11_Section1 [copper] = Ns11.section(plane=ZX)
  Ns12 [copper] = imported_body(C:\Users\karlr\Documents\0.3_edgewise.step)
  Ns12_Section1 [copper] = Ns12.section(plane=ZX)
  Ns2 [copper] = imported_body(C:\Users\karlr\Documents\0.3_edgewise.step)
  Ns2_Section1 [copper] = Ns2.section(plane=ZX)
  Ns3 [copper] = imported_body(C:\Users\karlr\Documents\0.3_edgewise.step)
  Ns3_Section1 [copper] = Ns3.section(plane=ZX)
  Ns4 [copper] = imported_body(C:\Users\karlr\Documents\0.3_edgewise.step)
  Ns4_Section1 [copper] = Ns4.section(plane=ZX)
  Ns5 [copper] = imported_body(C:\Users\karlr\Documents\0.3_edgewise.step)
  Ns5_Section1 [copper] = Ns5.section(plane=ZX)
  Ns6 [copper] = imported_body(C:\Users\karlr\Documents\0.3_edgewise.step)
  Ns6_Section1 [copper] = Ns6.section(plane=ZX)
  Ns7 [copper] = imported_body(C:\Users\karlr\Documents\0.3_edgewise.step)
  Ns7_Section1 [copper] = Ns7.section(plane=ZX)
  Ns8 [copper] = imported_body(C:\Users\karlr\Documents\0.3_edgewise.step)
  Ns8_Section1 [copper] = Ns8.section(plane=ZX)
  Ns9 [copper] = imported_body(C:\Users\karlr\Documents\0.3_edgewise.step)
  Ns9_Section1 [copper] = Ns9.section(plane=ZX)
  Body1 [ferrite] = imported_body(C:\Users\karlr\Documents\0.3_edgewise.step)
  Body1_1, Body1_2 [aluminum] = imported_body(C:\Users\karlr\Documents\0.3_edgewise.step)
  Body1_3 [ferrite] = imported_body(C:\Users\karlr\Documents\0.3_edgewise.step)
  Body1_4, Body1_5 [aluminum] = imported_body(C:\Users\karlr\Documents\0.3_edgewise.step)
  Np1_Section1.separate_bodies()
  Np2_Section1.separate_bodies()
  Np3_Section1.separate_bodies()
  Np4_Section1.separate_bodies()
  Np5_Section1.separate_bodies()
  Np6_Section1.separate_bodies()
  Np7_Section1.separate_bodies()
  Np8_Section1.separate_bodies()
  Np9_Section1.separate_bodies()
  Np10_Section1.separate_bodies()
  Np11_Section1.separate_bodies()
  Np12_Section1.separate_bodies()
  Ns1_Section1.separate_bodies()
  Ns2_Section1.separate_bodies()
  Ns3_Section1.separate_bodies()
  Ns4_Section1.separate_bodies()
  Ns5_Section1.separate_bodies()
  Ns6_Section1.separate_bodies()
  Ns7_Section1.separate_bodies()
  Ns8_Section1.separate_bodies()
  Ns9_Section1.separate_bodies()
  Ns10_Section1.separate_bodies()
  Ns11_Section1.separate_bodies()
  Ns12_Section1.separate_bodies()
  Region [air] = region(percentage_offset=1000 on all sides)
  group core_assembled_edgewise = plate_1, plate_2, Np1, Np10, Np11, Np12, Np2..Np9, Ns1, Ns10, Ns11, Ns12, Ns2..Ns9, Np1_Section1, Np2_Section1, Np3_Section1, Np4_Section1, Np5_Section1, Np6_Section1, Np7_Section1, Np8_Section1, Np9_Section1, Np10_Section1, Np11_Section1, Np12_Section1, Ns1_Section1, Ns2_Section1, Ns3_Section1, Ns4_Section1, Ns5_Section1, Ns6_Section1, Ns7_Section1, Ns8_Section1, Ns9_Section1, Ns10_Section1, Ns11_Section1, Ns12_Section1
  group core_together_1 = Body1, Body1_1, Body1_2
  group core_together = Body1_3, Body1_4, Body1_5
boundaries and excitations:
  Opening1: Opening Faces=Region.face(-y) Temperature=AmbientTemp External_Rad._Temperature=AmbientRadTemp Inlet_Type=Velocity Static_Pressure=AmbientPressure X_Velocity=0m_per_sec Y_Velocity=0m_per_sec Z_Velocity=0m_per_sec
  Opening2: Opening Faces=Region.face(+y) Temperature=AmbientTemp External_Rad._Temperature=AmbientRadTemp Inlet_Type=Pressure Total_Pressure=AmbientPressure
  Block1: Block Objects=[Np1..Np12, Ns1..Ns12] Block_Type=Solid Use_Total_Power Total_Power="(30/24) W"
mesh:
  Global:  MeshMethod=MesherHD ComputeGap MeshRegionResolution=5 MinGapX=1mm MinGapY=1mm MinGapZ=1mm Objects=Region FacetLevel=5 ProximitySizeFunction CurvatureSizeFunction OptimizePCBMesh
setups:
  Setup1: IcepakSteadyState Flow_Regime=Laminar Include_Temperature=true Include_Flow=true Include_Gravity Solution_Initialization_-_Z_Velocity=0.000980665m_per_sec Convergence_Criteria_-_Flow=0.001 Convergence_Criteria_-_Energy=1e-07 Convergence_Criteria_-_Discrete_Ordinates=1e-06 GPU_Convergence_Criteria_-_Flow=0.001 GPU_Convergence_Criteria_-_Energy=1e-05 GPU_Convergence_Criteria_-_Discrete_Ordinates=1e-05 Radiation_Model="Discrete Ordinates Model" Flow_Iteration_Per_Radiation_Iteration=10 Time_Step_Interval=1 ThetaDivision=2 PhiDivision=2 ThetaPixels=2 PhiPixels=2 Under-relaxation_-_Pressure=0.7 Under-relaxation_-_Momentum=0.3 Under-relaxation_-_Temperature=1 Under-relaxation_-_Body_Force=1 Discretization_Scheme_-_Pressure=Standard Discretization_Scheme_-_Momentum=First Discretization_Scheme_-_Temperature=First Discretization_Scheme_-_Discrete_Ordinates=First Convergence_Criteria_-_Max_Iterations=100
field plots:
  Temperature1: Temperature over plate_1.face(all 10) plate_2.face(all 10) Np1.face(all 10) Np10.face(all 10) Np11.face(all 10) Np12.face(all 10) Np2.face(all 10) Np3.face(all 10) Np4.face(all 10) Np5.face(all 10) Np6.face(all 10) Np7.face(all 10) Np8.face(all 10) Np9.face(all 10) Ns1.face(all 10) Ns10.face(all 10) Ns11.face(all 10) Ns12.face(all 10) Ns2.face(all 10) Ns3.face(all 10) Ns4.face(all 10) Ns5.face(all 10) Ns6.face(all 10) Ns7.face(all 10) Ns8.face(all 10) Ns9.face(all 10) Body1.face(all 14) Body1_1.face(all 10) Body1_2.face(all 10) Body1_3.face(all 14) Body1_4.face(all 10) Body1_5.face(all 10) on Setup1 : SteadyState

design Coupled_Loss_Block1 (Icepak, SteadyState TemperatureAndFlow, model units mm)
options: Default_Fluid_Material=air Default_Solid_Material=Al-Extruded Default_Surface_Material=Steel-oxidised-surface AmbientTemperature=20cel AmbientPressure=0n_per_meter_sq AmbientRadiationTemperature=20cel Gravity_Vector_CS_ID=Global Gravity_Vector_Axis=Z Positive=false Altitude=0meter OperatingPressure=101325n_per_meter_sq OperatingDensity=1.225kg_per_m3
geometry:
  plate_1, plate_2 [Material1] = imported_body(C:\Users\karlr\Documents\0.3_edgewise.step)
  Np1 [copper] = imported_body(C:\Users\karlr\Documents\0.3_edgewise.step)
  Np1_Section1 [copper] = Np1.section(plane=ZX)
  Np10 [copper] = imported_body(C:\Users\karlr\Documents\0.3_edgewise.step)
  Np10_Section1 [copper] = Np10.section(plane=ZX)
  Np11 [copper] = imported_body(C:\Users\karlr\Documents\0.3_edgewise.step)
  Np11_Section1 [copper] = Np11.section(plane=ZX)
  Np12 [copper] = imported_body(C:\Users\karlr\Documents\0.3_edgewise.step)
  Np12_Section1 [copper] = Np12.section(plane=ZX)
  Np2 [copper] = imported_body(C:\Users\karlr\Documents\0.3_edgewise.step)
  Np2_Section1 [copper] = Np2.section(plane=ZX)
  Np3 [copper] = imported_body(C:\Users\karlr\Documents\0.3_edgewise.step)
  Np3_Section1 [copper] = Np3.section(plane=ZX)
  Np4 [copper] = imported_body(C:\Users\karlr\Documents\0.3_edgewise.step)
  Np4_Section1 [copper] = Np4.section(plane=ZX)
  Np5 [copper] = imported_body(C:\Users\karlr\Documents\0.3_edgewise.step)
  Np5_Section1 [copper] = Np5.section(plane=ZX)
  Np6 [copper] = imported_body(C:\Users\karlr\Documents\0.3_edgewise.step)
  Np6_Section1 [copper] = Np6.section(plane=ZX)
  Np7 [copper] = imported_body(C:\Users\karlr\Documents\0.3_edgewise.step)
  Np7_Section1 [copper] = Np7.section(plane=ZX)
  Np8 [copper] = imported_body(C:\Users\karlr\Documents\0.3_edgewise.step)
  Np8_Section1 [copper] = Np8.section(plane=ZX)
  Np9 [copper] = imported_body(C:\Users\karlr\Documents\0.3_edgewise.step)
  Np9_Section1 [copper] = Np9.section(plane=ZX)
  Ns1 [copper] = imported_body(C:\Users\karlr\Documents\0.3_edgewise.step)
  Ns1_Section1 [copper] = Ns1.section(plane=ZX)
  Ns10 [copper] = imported_body(C:\Users\karlr\Documents\0.3_edgewise.step)
  Ns10_Section1 [copper] = Ns10.section(plane=ZX)
  Ns11 [copper] = imported_body(C:\Users\karlr\Documents\0.3_edgewise.step)
  Ns11_Section1 [copper] = Ns11.section(plane=ZX)
  Ns12 [copper] = imported_body(C:\Users\karlr\Documents\0.3_edgewise.step)
  Ns12_Section1 [copper] = Ns12.section(plane=ZX)
  Ns2 [copper] = imported_body(C:\Users\karlr\Documents\0.3_edgewise.step)
  Ns2_Section1 [copper] = Ns2.section(plane=ZX)
  Ns3 [copper] = imported_body(C:\Users\karlr\Documents\0.3_edgewise.step)
  Ns3_Section1 [copper] = Ns3.section(plane=ZX)
  Ns4 [copper] = imported_body(C:\Users\karlr\Documents\0.3_edgewise.step)
  Ns4_Section1 [copper] = Ns4.section(plane=ZX)
  Ns5 [copper] = imported_body(C:\Users\karlr\Documents\0.3_edgewise.step)
  Ns5_Section1 [copper] = Ns5.section(plane=ZX)
  Ns6 [copper] = imported_body(C:\Users\karlr\Documents\0.3_edgewise.step)
  Ns6_Section1 [copper] = Ns6.section(plane=ZX)
  Ns7 [copper] = imported_body(C:\Users\karlr\Documents\0.3_edgewise.step)
  Ns7_Section1 [copper] = Ns7.section(plane=ZX)
  Ns8 [copper] = imported_body(C:\Users\karlr\Documents\0.3_edgewise.step)
  Ns8_Section1 [copper] = Ns8.section(plane=ZX)
  Ns9 [copper] = imported_body(C:\Users\karlr\Documents\0.3_edgewise.step)
  Ns9_Section1 [copper] = Ns9.section(plane=ZX)
  Body1 [ferrite] = imported_body(C:\Users\karlr\Documents\0.3_edgewise.step)
  Body1_1, Body1_2 [aluminum] = imported_body(C:\Users\karlr\Documents\0.3_edgewise.step)
  Body1_3 [ferrite] = imported_body(C:\Users\karlr\Documents\0.3_edgewise.step)
  Body1_4, Body1_5 [aluminum] = imported_body(C:\Users\karlr\Documents\0.3_edgewise.step)
  Np1_Section1.separate_bodies()
  Np2_Section1.separate_bodies()
  Np3_Section1.separate_bodies()
  Np4_Section1.separate_bodies()
  Np5_Section1.separate_bodies()
  Np6_Section1.separate_bodies()
  Np7_Section1.separate_bodies()
  Np8_Section1.separate_bodies()
  Np9_Section1.separate_bodies()
  Np10_Section1.separate_bodies()
  Np11_Section1.separate_bodies()
  Np12_Section1.separate_bodies()
  Ns1_Section1.separate_bodies()
  Ns2_Section1.separate_bodies()
  Ns3_Section1.separate_bodies()
  Ns4_Section1.separate_bodies()
  Ns5_Section1.separate_bodies()
  Ns6_Section1.separate_bodies()
  Ns7_Section1.separate_bodies()
  Ns8_Section1.separate_bodies()
  Ns9_Section1.separate_bodies()
  Ns10_Section1.separate_bodies()
  Ns11_Section1.separate_bodies()
  Ns12_Section1.separate_bodies()
  Region [air] = region(percentage_offset=1000 on all sides)
  group core_assembled_edgewise = plate_1, plate_2, Np1, Np10, Np11, Np12, Np2..Np9, Ns1, Ns10, Ns11, Ns12, Ns2..Ns9, Np1_Section1, Np2_Section1, Np3_Section1, Np4_Section1, Np5_Section1, Np6_Section1, Np7_Section1, Np8_Section1, Np9_Section1, Np10_Section1, Np11_Section1, Np12_Section1, Ns1_Section1, Ns2_Section1, Ns3_Section1, Ns4_Section1, Ns5_Section1, Ns6_Section1, Ns7_Section1, Ns8_Section1, Ns9_Section1, Ns10_Section1, Ns11_Section1, Ns12_Section1
  group core_together_1 = Body1, Body1_1, Body1_2
  group core_together = Body1_3, Body1_4, Body1_5
boundaries and excitations:
  Opening1: Opening Faces=Region.face(-y) Temperature=AmbientTemp External_Rad._Temperature=AmbientRadTemp Inlet_Type=Velocity Static_Pressure=AmbientPressure X_Velocity=0m_per_sec Y_Velocity=0m_per_sec Z_Velocity=0m_per_sec
  Opening2: Opening Faces=Region.face(+y) Temperature=AmbientTemp External_Rad._Temperature=AmbientRadTemp Inlet_Type=Pressure Total_Pressure=AmbientPressure
  Block1: Block Objects=[Np1..Np12, Ns1..Ns12] Block_Type=Solid Use_Total_Power Total_Power="(1/24) W"
mesh:
  Global:  MeshMethod=MesherHD ComputeGap MeshRegionResolution=5 MinGapX=1mm MinGapY=1mm MinGapZ=1mm Objects=Region FacetLevel=5 ProximitySizeFunction CurvatureSizeFunction OptimizePCBMesh
setups:
  Setup1: IcepakSteadyState Flow_Regime=Laminar Include_Temperature=true Include_Flow=true Include_Gravity Solution_Initialization_-_Z_Velocity=0.000980665m_per_sec Convergence_Criteria_-_Flow=0.001 Convergence_Criteria_-_Energy=1e-07 Convergence_Criteria_-_Discrete_Ordinates=1e-06 GPU_Convergence_Criteria_-_Flow=0.001 GPU_Convergence_Criteria_-_Energy=1e-05 GPU_Convergence_Criteria_-_Discrete_Ordinates=1e-05 Radiation_Model="Discrete Ordinates Model" Flow_Iteration_Per_Radiation_Iteration=10 Time_Step_Interval=1 ThetaDivision=2 PhiDivision=2 ThetaPixels=2 PhiPixels=2 Under-relaxation_-_Pressure=0.7 Under-relaxation_-_Momentum=0.3 Under-relaxation_-_Temperature=1 Under-relaxation_-_Body_Force=1 Discretization_Scheme_-_Pressure=Standard Discretization_Scheme_-_Momentum=First Discretization_Scheme_-_Temperature=First Discretization_Scheme_-_Discrete_Ordinates=First Convergence_Criteria_-_Max_Iterations=100
field plots:
  Temperature1: Temperature over plate_1.face(all 10) plate_2.face(all 10) Np1.face(all 10) Np10.face(all 10) Np11.face(all 10) Np12.face(all 10) Np2.face(all 10) Np3.face(all 10) Np4.face(all 10) Np5.face(all 10) Np6.face(all 10) Np7.face(all 10) Np8.face(all 10) Np9.face(all 10) Ns1.face(all 10) Ns10.face(all 10) Ns11.face(all 10) Ns12.face(all 10) Ns2.face(all 10) Ns3.face(all 10) Ns4.face(all 10) Ns5.face(all 10) Ns6.face(all 10) Ns7.face(all 10) Ns8.face(all 10) Ns9.face(all 10) Body1.face(all 14) Body1_1.face(all 10) Body1_2.face(all 10) Body1_3.face(all 14) Body1_4.face(all 10) Body1_5.face(all 10) on Setup1 : SteadyState

design 0.35_NaturalCooling_30W (Icepak, SteadyState TemperatureAndFlow, model units mm)
options: Default_Fluid_Material=air Default_Solid_Material=Al-Extruded Default_Surface_Material=Steel-oxidised-surface AmbientTemperature=20cel AmbientPressure=0n_per_meter_sq AmbientRadiationTemperature=20cel Gravity_Vector_CS_ID=Global Gravity_Vector_Axis=Z Positive=false Altitude=0meter OperatingPressure=101325n_per_meter_sq OperatingDensity=1.225kg_per_m3
geometry:
  Region [air] = region(percentage_offset=1000 on all sides)
  plate_1, plate_2 [Material1] = imported_body(C:\Users\karlr\Documents\0.35_edgewise.step)
  Np1 [copper] = imported_body(C:\Users\karlr\Documents\0.35_edgewise.step)
  Np1_Section1 [copper] = Np1.section(plane=ZX)
  Np10 [copper] = imported_body(C:\Users\karlr\Documents\0.35_edgewise.step)
  Np10_Section1 [copper] = Np10.section(plane=ZX)
  Np11 [copper] = imported_body(C:\Users\karlr\Documents\0.35_edgewise.step)
  Np11_Section1 [copper] = Np11.section(plane=ZX)
  Np12 [copper] = imported_body(C:\Users\karlr\Documents\0.35_edgewise.step)
  Np12_Section1 [copper] = Np12.section(plane=ZX)
  Np2 [copper] = imported_body(C:\Users\karlr\Documents\0.35_edgewise.step)
  Np2_Section1 [copper] = Np2.section(plane=ZX)
  Np3 [copper] = imported_body(C:\Users\karlr\Documents\0.35_edgewise.step)
  Np3_Section1 [copper] = Np3.section(plane=ZX)
  Np4 [copper] = imported_body(C:\Users\karlr\Documents\0.35_edgewise.step)
  Np4_Section1 [copper] = Np4.section(plane=ZX)
  Np5 [copper] = imported_body(C:\Users\karlr\Documents\0.35_edgewise.step)
  Np5_Section1 [copper] = Np5.section(plane=ZX)
  Np6 [copper] = imported_body(C:\Users\karlr\Documents\0.35_edgewise.step)
  Np6_Section1 [copper] = Np6.section(plane=ZX)
  Np7 [copper] = imported_body(C:\Users\karlr\Documents\0.35_edgewise.step)
  Np7_Section1 [copper] = Np7.section(plane=ZX)
  Np8 [copper] = imported_body(C:\Users\karlr\Documents\0.35_edgewise.step)
  Np8_Section1 [copper] = Np8.section(plane=ZX)
  Np9 [copper] = imported_body(C:\Users\karlr\Documents\0.35_edgewise.step)
  Np9_Section1 [copper] = Np9.section(plane=ZX)
  Ns1 [copper] = imported_body(C:\Users\karlr\Documents\0.35_edgewise.step)
  Ns1_Section1 [copper] = Ns1.section(plane=ZX)
  Ns10 [copper] = imported_body(C:\Users\karlr\Documents\0.35_edgewise.step)
  Ns10_Section1 [copper] = Ns10.section(plane=ZX)
  Ns11 [copper] = imported_body(C:\Users\karlr\Documents\0.35_edgewise.step)
  Ns11_Section1 [copper] = Ns11.section(plane=ZX)
  Ns12 [copper] = imported_body(C:\Users\karlr\Documents\0.35_edgewise.step)
  Ns12_Section1 [copper] = Ns12.section(plane=ZX)
  Ns2 [copper] = imported_body(C:\Users\karlr\Documents\0.35_edgewise.step)
  Ns2_Section1 [copper] = Ns2.section(plane=ZX)
  Ns3 [copper] = imported_body(C:\Users\karlr\Documents\0.35_edgewise.step)
  Ns3_Section1 [copper] = Ns3.section(plane=ZX)
  Ns4 [copper] = imported_body(C:\Users\karlr\Documents\0.35_edgewise.step)
  Ns4_Section1 [copper] = Ns4.section(plane=ZX)
  Ns5 [copper] = imported_body(C:\Users\karlr\Documents\0.35_edgewise.step)
  Ns5_Section1 [copper] = Ns5.section(plane=ZX)
  Ns6 [copper] = imported_body(C:\Users\karlr\Documents\0.35_edgewise.step)
  Ns6_Section1 [copper] = Ns6.section(plane=ZX)
  Ns7 [copper] = imported_body(C:\Users\karlr\Documents\0.35_edgewise.step)
  Ns7_Section1 [copper] = Ns7.section(plane=ZX)
  Ns8 [copper] = imported_body(C:\Users\karlr\Documents\0.35_edgewise.step)
  Ns8_Section1 [copper] = Ns8.section(plane=ZX)
  Ns9 [copper] = imported_body(C:\Users\karlr\Documents\0.35_edgewise.step)
  Ns9_Section1 [copper] = Ns9.section(plane=ZX)
  Body1 [ferrite] = imported_body(C:\Users\karlr\Documents\0.35_edgewise.step)
  Body1_1, Body1_2 [aluminum] = imported_body(C:\Users\karlr\Documents\0.35_edgewise.step)
  Body1_3 [ferrite] = imported_body(C:\Users\karlr\Documents\0.35_edgewise.step)
  Body1_4, Body1_5 [aluminum] = imported_body(C:\Users\karlr\Documents\0.35_edgewise.step)
  Np1_Section1.separate_bodies()
  Np2_Section1.separate_bodies()
  Np3_Section1.separate_bodies()
  Np4_Section1.separate_bodies()
  Np5_Section1.separate_bodies()
  Np6_Section1.separate_bodies()
  Np7_Section1.separate_bodies()
  Np8_Section1.separate_bodies()
  Np9_Section1.separate_bodies()
  Np10_Section1.separate_bodies()
  Np11_Section1.separate_bodies()
  Np12_Section1.separate_bodies()
  Ns1_Section1.separate_bodies()
  Ns2_Section1.separate_bodies()
  Ns3_Section1.separate_bodies()
  Ns4_Section1.separate_bodies()
  Ns5_Section1.separate_bodies()
  Ns6_Section1.separate_bodies()
  Ns7_Section1.separate_bodies()
  Ns8_Section1.separate_bodies()
  Ns9_Section1.separate_bodies()
  Ns10_Section1.separate_bodies()
  Ns11_Section1.separate_bodies()
  Ns12_Section1.separate_bodies()
  group core_assembled_edgewise = plate_1, plate_2, Np1, Np10, Np11, Np12, Np2..Np9, Ns1, Ns10, Ns11, Ns12, Ns2..Ns9, Np1_Section1, Np2_Section1, Np3_Section1, Np4_Section1, Np5_Section1, Np6_Section1, Np7_Section1, Np8_Section1, Np9_Section1, Np10_Section1, Np11_Section1, Np12_Section1, Ns1_Section1, Ns2_Section1, Ns3_Section1, Ns4_Section1, Ns5_Section1, Ns6_Section1, Ns7_Section1, Ns8_Section1, Ns9_Section1, Ns10_Section1, Ns11_Section1, Ns12_Section1
  group core_together_1 = Body1, Body1_1, Body1_2
  group core_together = Body1_3, Body1_4, Body1_5
boundaries and excitations:
  Opening1: Opening Faces=Region.face(-y) Temperature=AmbientTemp External_Rad._Temperature=AmbientRadTemp Inlet_Type=Velocity Static_Pressure=AmbientPressure X_Velocity=0m_per_sec Y_Velocity=0m_per_sec Z_Velocity=0m_per_sec
  Opening2: Opening Faces=Region.face(+y) Temperature=AmbientTemp External_Rad._Temperature=AmbientRadTemp Inlet_Type=Pressure Total_Pressure=AmbientPressure
  Block1: Block Objects=[Np1..Np12, Ns1..Ns12] Block_Type=Solid Use_Total_Power Total_Power="(30/24) W"
mesh:
  Global:  MeshMethod=MesherHD ComputeGap MeshRegionResolution=5 MinGapX=1mm MinGapY=1mm MinGapZ=1mm Objects=Region FacetLevel=5 ProximitySizeFunction CurvatureSizeFunction OptimizePCBMesh
setups:
  Setup1: IcepakSteadyState Flow_Regime=Laminar Include_Temperature=true Include_Flow=true Include_Gravity Solution_Initialization_-_Z_Velocity=0.000980665m_per_sec Convergence_Criteria_-_Flow=0.001 Convergence_Criteria_-_Energy=1e-07 Convergence_Criteria_-_Discrete_Ordinates=1e-06 GPU_Convergence_Criteria_-_Flow=0.001 GPU_Convergence_Criteria_-_Energy=1e-05 GPU_Convergence_Criteria_-_Discrete_Ordinates=1e-05 Radiation_Model="Discrete Ordinates Model" Flow_Iteration_Per_Radiation_Iteration=10 Time_Step_Interval=1 ThetaDivision=2 PhiDivision=2 ThetaPixels=2 PhiPixels=2 Under-relaxation_-_Pressure=0.7 Under-relaxation_-_Momentum=0.3 Under-relaxation_-_Temperature=1 Under-relaxation_-_Body_Force=1 Discretization_Scheme_-_Pressure=Standard Discretization_Scheme_-_Momentum=First Discretization_Scheme_-_Temperature=First Discretization_Scheme_-_Discrete_Ordinates=First Convergence_Criteria_-_Max_Iterations=100
field plots:
  Temperature1: Temperature over plate_1.face(all 10) plate_2.face(all 10) Np1.face(all 10) Np10.face(all 10) Np11.face(all 10) Np12.face(all 10) Np2.face(all 10) Np3.face(all 10) Np4.face(all 10) Np5.face(all 10) Np6.face(all 10) Np7.face(all 10) Np8.face(all 10) Np9.face(all 10) Ns1.face(all 10) Ns10.face(all 10) Ns11.face(all 10) Ns12.face(all 10) Ns2.face(all 10) Ns3.face(all 10) Ns4.face(all 10) Ns5.face(all 10) Ns6.face(all 10) Ns7.face(all 10) Ns8.face(all 10) Ns9.face(all 10) Body1.face(all 14) Body1_1.face(all 10) Body1_2.face(all 10) Body1_3.face(all 14) Body1_4.face(all 10) Body1_5.face(all 10) Np1_Section1.face Np2_Section1.face Np3_Section1.face Np4_Section1.face Np5_Section1.face Np6_Section1.face Np7_Section1.face Np8_Section1.face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 on Setup1 : SteadyState

design 0.40_NaturalCooling_30W (Icepak, SteadyState TemperatureAndFlow, model units mm)
options: Default_Fluid_Material=air Default_Solid_Material=Al-Extruded Default_Surface_Material=Steel-oxidised-surface AmbientTemperature=20cel AmbientPressure=0n_per_meter_sq AmbientRadiationTemperature=20cel Gravity_Vector_CS_ID=Global Gravity_Vector_Axis=Z Positive=false Altitude=0meter OperatingPressure=101325n_per_meter_sq OperatingDensity=1.225kg_per_m3
geometry:
  Region [air] = region(percentage_offset=1000 on all sides)
  plate_1, plate_2 [Material1] = imported_body(C:\Users\karlr\Documents\0.4_edgewise.step)
  Np1 [copper] = imported_body(C:\Users\karlr\Documents\0.4_edgewise.step)
  Np1_Section1 [copper] = Np1.section(plane=ZX)
  Np10 [copper] = imported_body(C:\Users\karlr\Documents\0.4_edgewise.step)
  Np10_Section1 [copper] = Np10.section(plane=ZX)
  Np11 [copper] = imported_body(C:\Users\karlr\Documents\0.4_edgewise.step)
  Np11_Section1 [copper] = Np11.section(plane=ZX)
  Np12 [copper] = imported_body(C:\Users\karlr\Documents\0.4_edgewise.step)
  Np12_Section1 [copper] = Np12.section(plane=ZX)
  Np2 [copper] = imported_body(C:\Users\karlr\Documents\0.4_edgewise.step)
  Np2_Section1 [copper] = Np2.section(plane=ZX)
  Np3 [copper] = imported_body(C:\Users\karlr\Documents\0.4_edgewise.step)
  Np3_Section1 [copper] = Np3.section(plane=ZX)
  Np4 [copper] = imported_body(C:\Users\karlr\Documents\0.4_edgewise.step)
  Np4_Section1 [copper] = Np4.section(plane=ZX)
  Np5 [copper] = imported_body(C:\Users\karlr\Documents\0.4_edgewise.step)
  Np5_Section1 [copper] = Np5.section(plane=ZX)
  Np6 [copper] = imported_body(C:\Users\karlr\Documents\0.4_edgewise.step)
  Np6_Section1 [copper] = Np6.section(plane=ZX)
  Np7 [copper] = imported_body(C:\Users\karlr\Documents\0.4_edgewise.step)
  Np7_Section1 [copper] = Np7.section(plane=ZX)
  Np8 [copper] = imported_body(C:\Users\karlr\Documents\0.4_edgewise.step)
  Np8_Section1 [copper] = Np8.section(plane=ZX)
  Np9 [copper] = imported_body(C:\Users\karlr\Documents\0.4_edgewise.step)
  Np9_Section1 [copper] = Np9.section(plane=ZX)
  Ns1 [copper] = imported_body(C:\Users\karlr\Documents\0.4_edgewise.step)
  Ns1_Section1 [copper] = Ns1.section(plane=ZX)
  Ns10 [copper] = imported_body(C:\Users\karlr\Documents\0.4_edgewise.step)
  Ns10_Section1 [copper] = Ns10.section(plane=ZX)
  Ns11 [copper] = imported_body(C:\Users\karlr\Documents\0.4_edgewise.step)
  Ns11_Section1 [copper] = Ns11.section(plane=ZX)
  Ns12 [copper] = imported_body(C:\Users\karlr\Documents\0.4_edgewise.step)
  Ns12_Section1 [copper] = Ns12.section(plane=ZX)
  Ns2 [copper] = imported_body(C:\Users\karlr\Documents\0.4_edgewise.step)
  Ns2_Section1 [copper] = Ns2.section(plane=ZX)
  Ns3 [copper] = imported_body(C:\Users\karlr\Documents\0.4_edgewise.step)
  Ns3_Section1 [copper] = Ns3.section(plane=ZX)
  Ns4 [copper] = imported_body(C:\Users\karlr\Documents\0.4_edgewise.step)
  Ns4_Section1 [copper] = Ns4.section(plane=ZX)
  Ns5 [copper] = imported_body(C:\Users\karlr\Documents\0.4_edgewise.step)
  Ns5_Section1 [copper] = Ns5.section(plane=ZX)
  Ns6 [copper] = imported_body(C:\Users\karlr\Documents\0.4_edgewise.step)
  Ns6_Section1 [copper] = Ns6.section(plane=ZX)
  Ns7 [copper] = imported_body(C:\Users\karlr\Documents\0.4_edgewise.step)
  Ns7_Section1 [copper] = Ns7.section(plane=ZX)
  Ns8 [copper] = imported_body(C:\Users\karlr\Documents\0.4_edgewise.step)
  Ns8_Section1 [copper] = Ns8.section(plane=ZX)
  Ns9 [copper] = imported_body(C:\Users\karlr\Documents\0.4_edgewise.step)
  Ns9_Section1 [copper] = Ns9.section(plane=ZX)
  Body1 [ferrite] = imported_body(C:\Users\karlr\Documents\0.4_edgewise.step)
  Body1_1, Body1_2 [aluminum] = imported_body(C:\Users\karlr\Documents\0.4_edgewise.step)
  Body1_3 [ferrite] = imported_body(C:\Users\karlr\Documents\0.4_edgewise.step)
  Body1_4, Body1_5 [aluminum] = imported_body(C:\Users\karlr\Documents\0.4_edgewise.step)
  Ns12_Section1.separate_bodies()
  Np1_Section1.separate_bodies()
  Np2_Section1.separate_bodies()
  Np3_Section1.separate_bodies()
  Np4_Section1.separate_bodies()
  Np5_Section1.separate_bodies()
  Np6_Section1.separate_bodies()
  Np7_Section1.separate_bodies()
  Np8_Section1.separate_bodies()
  Np9_Section1.separate_bodies()
  Np10_Section1.separate_bodies()
  Np11_Section1.separate_bodies()
  Np12_Section1.separate_bodies()
  Ns1_Section1.separate_bodies()
  Ns2_Section1.separate_bodies()
  Ns3_Section1.separate_bodies()
  Ns4_Section1.separate_bodies()
  Ns5_Section1.separate_bodies()
  Ns6_Section1.separate_bodies()
  Ns7_Section1.separate_bodies()
  Ns8_Section1.separate_bodies()
  Ns9_Section1.separate_bodies()
  Ns10_Section1.separate_bodies()
  Ns11_Section1.separate_bodies()
  group core_assembled_edgewise = plate_1, plate_2, Np1, Np10, Np11, Np12, Np2..Np9, Ns1, Ns10, Ns11, Ns12, Ns2..Ns9, Ns12_Section1, Np1_Section1, Np2_Section1, Np3_Section1, Np4_Section1, Np5_Section1, Np6_Section1, Np7_Section1, Np8_Section1, Np9_Section1, Np10_Section1, Np11_Section1, Np12_Section1, Ns1_Section1, Ns2_Section1, Ns3_Section1, Ns4_Section1, Ns5_Section1, Ns6_Section1, Ns7_Section1, Ns8_Section1, Ns9_Section1, Ns10_Section1, Ns11_Section1
  group core_together_1 = Body1, Body1_1, Body1_2
  group core_together = Body1_3, Body1_4, Body1_5
boundaries and excitations:
  Opening1: Opening Faces=Region.face(-y) Temperature=AmbientTemp External_Rad._Temperature=AmbientRadTemp Inlet_Type=Velocity Static_Pressure=AmbientPressure X_Velocity=0m_per_sec Y_Velocity=0m_per_sec Z_Velocity=0m_per_sec
  Opening2: Opening Faces=Region.face(+y) Temperature=AmbientTemp External_Rad._Temperature=AmbientRadTemp Inlet_Type=Pressure Total_Pressure=AmbientPressure
  Block1: Block Objects=[Np1..Np12, Ns1..Ns12] Block_Type=Solid Use_Total_Power Total_Power="(30/24) W"
mesh:
  Global:  MeshMethod=MesherHD ComputeGap MeshRegionResolution=5 MinGapX=1mm MinGapY=1mm MinGapZ=1mm Objects=Region FacetLevel=5 ProximitySizeFunction CurvatureSizeFunction OptimizePCBMesh
setups:
  Setup1: IcepakSteadyState Flow_Regime=Laminar Include_Temperature=true Include_Flow=true Include_Gravity Solution_Initialization_-_Z_Velocity=0.000980665m_per_sec Convergence_Criteria_-_Flow=0.001 Convergence_Criteria_-_Energy=1e-07 Convergence_Criteria_-_Discrete_Ordinates=1e-06 GPU_Convergence_Criteria_-_Flow=0.001 GPU_Convergence_Criteria_-_Energy=1e-05 GPU_Convergence_Criteria_-_Discrete_Ordinates=1e-05 Radiation_Model="Discrete Ordinates Model" Flow_Iteration_Per_Radiation_Iteration=10 Time_Step_Interval=1 ThetaDivision=2 PhiDivision=2 ThetaPixels=2 PhiPixels=2 Under-relaxation_-_Pressure=0.7 Under-relaxation_-_Momentum=0.3 Under-relaxation_-_Temperature=1 Under-relaxation_-_Body_Force=1 Discretization_Scheme_-_Pressure=Standard Discretization_Scheme_-_Momentum=First Discretization_Scheme_-_Temperature=First Discretization_Scheme_-_Discrete_Ordinates=First Convergence_Criteria_-_Max_Iterations=100
field plots:
  Temperature1: Temperature on Setup1 : SteadyState

design 0.25_NaturalCooling_25W (Icepak, SteadyState TemperatureAndFlow, model units mm)
options: Default_Fluid_Material=air Default_Solid_Material=Al-Extruded Default_Surface_Material=Steel-oxidised-surface AmbientTemperature=20cel AmbientPressure=0n_per_meter_sq AmbientRadiationTemperature=20cel Gravity_Vector_CS_ID=Global Gravity_Vector_Axis=Z Positive=false Altitude=0meter OperatingPressure=101325n_per_meter_sq OperatingDensity=1.225kg_per_m3
geometry:
  plate_1, plate_2 [Material1] = imported_body(C:\Users\karlr\Documents\0.25_edgewise.step)
  Np1, Np10, Np11, Np12, Np2..Np9, Ns1, Ns10, Ns11, Ns12, Ns2..Ns9 [copper] = imported_body(C:\Users\karlr\Documents\0.25_edgewise.step)
  Body1 [ferrite] = imported_body(C:\Users\karlr\Documents\0.25_edgewise.step)
  Body1_1, Body1_2 [aluminum] = imported_body(C:\Users\karlr\Documents\0.25_edgewise.step)
  Body1_3 [ferrite] = imported_body(C:\Users\karlr\Documents\0.25_edgewise.step)
  Body1_4, Body1_5 [aluminum] = imported_body(C:\Users\karlr\Documents\0.25_edgewise.step)
  MeshRegion1_SubRegion [air, non-model] = sub_region(of=plate_1, percentage_offset=0 on all sides)
  MeshRegion2_SubRegion [air, non-model] = sub_region(of=plate_2, percentage_offset=0 on all sides)
  Region [air] = region(percentage_offset=1000 on all sides)
  group core_assembled_edgewise = plate_1, plate_2, Np1, Np10, Np11, Np12, Np2..Np9, Ns1, Ns10, Ns11, Ns12, Ns2..Ns9
  group core_together_1 = Body1, Body1_1, Body1_2
  group core_together = Body1_3, Body1_4, Body1_5
boundaries and excitations:
  Block1: Block Objects=[Np1..Np12, Ns1..Ns12] Block_Type=Solid Use_Total_Power Total_Power="(30/24) W"
  Opening1: Opening Faces=Region.face(-y) Temperature=AmbientTemp External_Rad._Temperature=AmbientRadTemp Inlet_Type=Pressure Total_Pressure=AmbientPressure
  Opening2: Opening Faces=Region.face(+y) Temperature=AmbientTemp External_Rad._Temperature=AmbientRadTemp Inlet_Type=Velocity Static_Pressure=AmbientPressure X_Velocity=0m_per_sec Y_Velocity=0m_per_sec Z_Velocity=0m_per_sec
mesh:
  Global:  MeshMethod=MesherHD ComputeGap MeshRegionResolution=5 GeometryBasedMeshing MinGapX=1mm MinGapY=1mm MinGapZ=1mm Objects=Region StairStepSliderMeshing FacetLevel=5 ProximitySizeFunction CurvatureSizeFunction OptimizePCBMesh
  MeshRegion1:  MeshMethod=MesherHD MeshRegionResolution=5 MinGapX=1mm MinGapY=1mm MinGapZ=0.0099999983mm Objects=MeshRegion1_SubRegion ProximitySizeFunction CurvatureSizeFunction OptimizePCBMesh
  MeshRegion2:  MeshMethod=MesherHD MeshRegionResolution=5 MinGapX=1mm MinGapY=1mm MinGapZ=0.0099999983mm Objects=MeshRegion2_SubRegion ProximitySizeFunction CurvatureSizeFunction OptimizePCBMesh
setups:
  Setup1: IcepakSteadyState Flow_Regime=Laminar Include_Temperature=true Include_Flow=true Include_Gravity Solution_Initialization_-_Z_Velocity=0.000980665m_per_sec Convergence_Criteria_-_Flow=0.001 Convergence_Criteria_-_Energy=1e-07 Convergence_Criteria_-_Discrete_Ordinates=1e-06 GPU_Convergence_Criteria_-_Flow=0.001 GPU_Convergence_Criteria_-_Energy=1e-05 GPU_Convergence_Criteria_-_Discrete_Ordinates=1e-05 Radiation_Model="Discrete Ordinates Model" Flow_Iteration_Per_Radiation_Iteration=10 Time_Step_Interval=1 ThetaDivision=2 PhiDivision=2 ThetaPixels=2 PhiPixels=2 Under-relaxation_-_Pressure=0.7 Under-relaxation_-_Momentum=0.3 Under-relaxation_-_Temperature=1 Under-relaxation_-_Body_Force=1 Discretization_Scheme_-_Pressure=Standard Discretization_Scheme_-_Momentum=First Discretization_Scheme_-_Temperature=First Discretization_Scheme_-_Discrete_Ordinates=First Convergence_Criteria_-_Max_Iterations=300
field plots:
  Temperature1: Temperature on Setup1 : SteadyState

design 0.40_NaturalCooling_30W1 (Icepak, SteadyState TemperatureAndFlow, model units mm)
options: Default_Fluid_Material=air Default_Solid_Material=Al-Extruded Default_Surface_Material=Steel-oxidised-surface AmbientTemperature=20cel AmbientPressure=0n_per_meter_sq AmbientRadiationTemperature=20cel Gravity_Vector_CS_ID=Global Gravity_Vector_Axis=Z Positive=false Altitude=0meter OperatingPressure=101325n_per_meter_sq OperatingDensity=1.225kg_per_m3
geometry:
  Np1 [copper] = imported_body(C:\Users\karlr\Documents\0.2_edgewise.step)
  Np1_Section1 [copper] = Np1.section(plane=ZX)
  Np10 [copper] = imported_body(C:\Users\karlr\Documents\0.2_edgewise.step)
  Np10_Section1 [copper] = Np10.section(plane=ZX)
  Np11 [copper] = imported_body(C:\Users\karlr\Documents\0.2_edgewise.step)
  Np11_Section1 [copper] = Np11.section(plane=ZX)
  Np12 [copper] = imported_body(C:\Users\karlr\Documents\0.2_edgewise.step)
  Np12_Section1 [copper] = Np12.section(plane=ZX)
  Np2 [copper] = imported_body(C:\Users\karlr\Documents\0.2_edgewise.step)
  Np2_Section1 [copper] = Np2.section(plane=ZX)
  Np3 [copper] = imported_body(C:\Users\karlr\Documents\0.2_edgewise.step)
  Np3_Section1 [copper] = Np3.section(plane=ZX)
  Np4 [copper] = imported_body(C:\Users\karlr\Documents\0.2_edgewise.step)
  Np4_Section1 [copper] = Np4.section(plane=ZX)
  Np5 [copper] = imported_body(C:\Users\karlr\Documents\0.2_edgewise.step)
  Np5_Section1 [copper] = Np5.section(plane=ZX)
  Np6 [copper] = imported_body(C:\Users\karlr\Documents\0.2_edgewise.step)
  Np6_Section1 [copper] = Np6.section(plane=ZX)
  Np7 [copper] = imported_body(C:\Users\karlr\Documents\0.2_edgewise.step)
  Np7_Section1 [copper] = Np7.section(plane=ZX)
  Np8 [copper] = imported_body(C:\Users\karlr\Documents\0.2_edgewise.step)
  Np8_Section1 [copper] = Np8.section(plane=ZX)
  Np9 [copper] = imported_body(C:\Users\karlr\Documents\0.2_edgewise.step)
  Np9_Section1 [copper] = Np9.section(plane=ZX)
  Ns1 [copper] = imported_body(C:\Users\karlr\Documents\0.2_edgewise.step)
  Ns1_Section1 [copper] = Ns1.section(plane=ZX)
  Ns10 [copper] = imported_body(C:\Users\karlr\Documents\0.2_edgewise.step)
  Ns10_Section1 [copper] = Ns10.section(plane=ZX)
  Ns11 [copper] = imported_body(C:\Users\karlr\Documents\0.2_edgewise.step)
  Ns11_Section1 [copper] = Ns11.section(plane=ZX)
  Ns12 [copper] = imported_body(C:\Users\karlr\Documents\0.2_edgewise.step)
  Ns12_Section1 [copper] = Ns12.section(plane=ZX)
  Ns2 [copper] = imported_body(C:\Users\karlr\Documents\0.2_edgewise.step)
  Ns2_Section1 [copper] = Ns2.section(plane=ZX)
  Ns3 [copper] = imported_body(C:\Users\karlr\Documents\0.2_edgewise.step)
  Ns3_Section1 [copper] = Ns3.section(plane=ZX)
  Ns4 [copper] = imported_body(C:\Users\karlr\Documents\0.2_edgewise.step)
  Ns4_Section1 [copper] = Ns4.section(plane=ZX)
  Ns5 [copper] = imported_body(C:\Users\karlr\Documents\0.2_edgewise.step)
  Ns5_Section1 [copper] = Ns5.section(plane=ZX)
  Ns6 [copper] = imported_body(C:\Users\karlr\Documents\0.2_edgewise.step)
  Ns6_Section1 [copper] = Ns6.section(plane=ZX)
  Ns7 [copper] = imported_body(C:\Users\karlr\Documents\0.2_edgewise.step)
  Ns7_Section1 [copper] = Ns7.section(plane=ZX)
  Ns8 [copper] = imported_body(C:\Users\karlr\Documents\0.2_edgewise.step)
  Ns8_Section1 [copper] = Ns8.section(plane=ZX)
  Ns9 [copper] = imported_body(C:\Users\karlr\Documents\0.2_edgewise.step)
  Ns9_Section1 [copper] = Ns9.section(plane=ZX)
  plate_1, plate_2 [Material1] = imported_body(C:\Users\karlr\Documents\0.2_edgewise.step)
  Body1 [ferrite] = imported_body(C:\Users\karlr\Documents\0.2_edgewise.step)
  Body1_1, Body1_2 [aluminum] = imported_body(C:\Users\karlr\Documents\0.2_edgewise.step)
  Body1_3 [ferrite] = imported_body(C:\Users\karlr\Documents\0.2_edgewise.step)
  Body1_4, Body1_5 [aluminum] = imported_body(C:\Users\karlr\Documents\0.2_edgewise.step)
  Np1_Section1.separate_bodies()
  Np2_Section1.separate_bodies()
  Np3_Section1.separate_bodies()
  Np4_Section1.separate_bodies()
  Np5_Section1.separate_bodies()
  Np6_Section1.separate_bodies()
  Np7_Section1.separate_bodies()
  Np8_Section1.separate_bodies()
  Np9_Section1.separate_bodies()
  Np10_Section1.separate_bodies()
  Np11_Section1.separate_bodies()
  Np12_Section1.separate_bodies()
  Ns1_Section1.separate_bodies()
  Ns2_Section1.separate_bodies()
  Ns3_Section1.separate_bodies()
  Ns4_Section1.separate_bodies()
  Ns5_Section1.separate_bodies()
  Ns6_Section1.separate_bodies()
  Ns7_Section1.separate_bodies()
  Ns8_Section1.separate_bodies()
  Ns9_Section1.separate_bodies()
  Ns10_Section1.separate_bodies()
  Ns11_Section1.separate_bodies()
  Ns12_Section1.separate_bodies()
  Region [air] = region(percentage_offset=1000 on all sides)
  MeshRegion1_SubRegion [air, non-model] = sub_region(of=plate_1, percentage_offset=0 on all sides)
  MeshRegion2_SubRegion [air, non-model] = sub_region(of=plate_2, percentage_offset=0 on all sides)
  MeshRegion3_SubRegion [air, non-model] = sub_region(of=Np8, Np1, Np3, Ns12, Np2, Np7, Ns5, Np4, Np5, Np6, Np9, Np10, Ns9, Np11, Ns8, Np12, Ns1, Ns2, Ns3, Ns7, Ns4, Ns6, Ns10, Ns11, percentage_offset=0 on all sides)
  group core_assembled_edgewise = Np1, Np10, Np11, Np12, Np2..Np9, Ns1, Ns10, Ns11, Ns12, Ns2..Ns9, plate_1, plate_2, Np1_Section1, Np2_Section1, Np3_Section1, Np4_Section1, Np5_Section1, Np6_Section1, Np7_Section1, Np8_Section1, Np9_Section1, Np10_Section1, Np11_Section1, Np12_Section1, Ns1_Section1, Ns2_Section1, Ns3_Section1, Ns4_Section1, Ns5_Section1, Ns6_Section1, Ns7_Section1, Ns8_Section1, Ns9_Section1, Ns10_Section1, Ns11_Section1, Ns12_Section1
  group core_together_1 = Body1, Body1_1, Body1_2
  group core_together = Body1_3, Body1_4, Body1_5
boundaries and excitations:
  Opening1: Opening Faces=Region.face(-y) Temperature=AmbientTemp External_Rad._Temperature=AmbientRadTemp Inlet_Type=Pressure Total_Pressure=AmbientPressure
  Opening2: Opening Faces=Region.face(+y) Temperature=AmbientTemp External_Rad._Temperature=AmbientRadTemp Inlet_Type=Velocity Static_Pressure=AmbientPressure X_Velocity=0m_per_sec Y_Velocity=0m_per_sec Z_Velocity=0m_per_sec
  Block1: Block Objects=[Np1..Np12, Ns1..Ns12] Block_Type=Solid Use_Total_Power Total_Power="(30/24) W"
mesh:
  Global:  MeshMethod=MesherHD ComputeGap MeshRegionResolution=5 GeometryBasedMeshing MinGapX=1mm MinGapY=1mm MinGapZ=1mm Objects=Region StairStepSliderMeshing FacetLevel=5 ProximitySizeFunction CurvatureSizeFunction OptimizePCBMesh
  MeshRegion1:  MeshMethod=MesherHD MeshRegionResolution=5 MinGapX=1mm MinGapY=1mm MinGapZ=0.0099999983mm Objects=MeshRegion1_SubRegion ProximitySizeFunction CurvatureSizeFunction OptimizePCBMesh
  MeshRegion2:  MeshMethod=MesherHD MeshRegionResolution=5 MinGapX=1mm MinGapY=1mm MinGapZ=0.0099999983mm Objects=MeshRegion2_SubRegion ProximitySizeFunction CurvatureSizeFunction OptimizePCBMesh
  MeshRegion3:  MeshMethod=MesherHD MeshRegionResolution=5 GeometryBasedMeshing MinGapX=1mm MinGapY=1mm MinGapZ=0.71mm Objects=MeshRegion3_SubRegion ProximitySizeFunction CurvatureSizeFunction OptimizePCBMesh
setups:
  Setup1: IcepakSteadyState Flow_Regime=Laminar Include_Temperature=true Include_Flow=true Include_Gravity Solution_Initialization_-_Z_Velocity=0.000980665m_per_sec Convergence_Criteria_-_Flow=0.001 Convergence_Criteria_-_Energy=1e-07 Convergence_Criteria_-_Discrete_Ordinates=1e-06 GPU_Convergence_Criteria_-_Flow=0.001 GPU_Convergence_Criteria_-_Energy=1e-05 GPU_Convergence_Criteria_-_Discrete_Ordinates=1e-05 Radiation_Model="Discrete Ordinates Model" Flow_Iteration_Per_Radiation_Iteration=10 Time_Step_Interval=1 ThetaDivision=2 PhiDivision=2 ThetaPixels=2 PhiPixels=2 Under-relaxation_-_Pressure=0.7 Under-relaxation_-_Momentum=0.3 Under-relaxation_-_Temperature=1 Under-relaxation_-_Body_Force=1 Discretization_Scheme_-_Pressure=Standard Discretization_Scheme_-_Momentum=First Discretization_Scheme_-_Temperature=First Discretization_Scheme_-_Discrete_Ordinates=First Convergence_Criteria_-_Max_Iterations=200
field plots:
  Temperature1: Temperature on Setup1 : SteadyState

design 0.30_NaturalCooling_30W1 (Icepak, SteadyState TemperatureAndFlow, model units mm)
options: Default_Fluid_Material=air Default_Solid_Material=Al-Extruded Default_Surface_Material=Steel-oxidised-surface AmbientTemperature=20cel AmbientPressure=0n_per_meter_sq AmbientRadiationTemperature=20cel Gravity_Vector_CS_ID=Global Gravity_Vector_Axis=Z Positive=false Altitude=0meter OperatingPressure=101325n_per_meter_sq OperatingDensity=1.225kg_per_m3
geometry:
  plate_1, plate_2 [Material1] = imported_body(C:\Users\karlr\Documents\0.3_edgewise.step)
  Np1 [copper] = imported_body(C:\Users\karlr\Documents\0.3_edgewise.step)
  Np1_Section1 [copper] = Np1.section(plane=ZX)
  Np10 [copper] = imported_body(C:\Users\karlr\Documents\0.3_edgewise.step)
  Np10_Section1 [copper] = Np10.section(plane=ZX)
  Np11 [copper] = imported_body(C:\Users\karlr\Documents\0.3_edgewise.step)
  Np11_Section1 [copper] = Np11.section(plane=ZX)
  Np12 [copper] = imported_body(C:\Users\karlr\Documents\0.3_edgewise.step)
  Np12_Section1 [copper] = Np12.section(plane=ZX)
  Np2 [copper] = imported_body(C:\Users\karlr\Documents\0.3_edgewise.step)
  Np2_Section1 [copper] = Np2.section(plane=ZX)
  Np3 [copper] = imported_body(C:\Users\karlr\Documents\0.3_edgewise.step)
  Np3_Section1 [copper] = Np3.section(plane=ZX)
  Np4 [copper] = imported_body(C:\Users\karlr\Documents\0.3_edgewise.step)
  Np4_Section1 [copper] = Np4.section(plane=ZX)
  Np5 [copper] = imported_body(C:\Users\karlr\Documents\0.3_edgewise.step)
  Np5_Section1 [copper] = Np5.section(plane=ZX)
  Np6 [copper] = imported_body(C:\Users\karlr\Documents\0.3_edgewise.step)
  Np6_Section1 [copper] = Np6.section(plane=ZX)
  Np7 [copper] = imported_body(C:\Users\karlr\Documents\0.3_edgewise.step)
  Np7_Section1 [copper] = Np7.section(plane=ZX)
  Np8 [copper] = imported_body(C:\Users\karlr\Documents\0.3_edgewise.step)
  Np8_Section1 [copper] = Np8.section(plane=ZX)
  Np9 [copper] = imported_body(C:\Users\karlr\Documents\0.3_edgewise.step)
  Np9_Section1 [copper] = Np9.section(plane=ZX)
  Ns1 [copper] = imported_body(C:\Users\karlr\Documents\0.3_edgewise.step)
  Ns1_Section1 [copper] = Ns1.section(plane=ZX)
  Ns10 [copper] = imported_body(C:\Users\karlr\Documents\0.3_edgewise.step)
  Ns10_Section1 [copper] = Ns10.section(plane=ZX)
  Ns11 [copper] = imported_body(C:\Users\karlr\Documents\0.3_edgewise.step)
  Ns11_Section1 [copper] = Ns11.section(plane=ZX)
  Ns12 [copper] = imported_body(C:\Users\karlr\Documents\0.3_edgewise.step)
  Ns12_Section1 [copper] = Ns12.section(plane=ZX)
  Ns2 [copper] = imported_body(C:\Users\karlr\Documents\0.3_edgewise.step)
  Ns2_Section1 [copper] = Ns2.section(plane=ZX)
  Ns3 [copper] = imported_body(C:\Users\karlr\Documents\0.3_edgewise.step)
  Ns3_Section1 [copper] = Ns3.section(plane=ZX)
  Ns4 [copper] = imported_body(C:\Users\karlr\Documents\0.3_edgewise.step)
  Ns4_Section1 [copper] = Ns4.section(plane=ZX)
  Ns5 [copper] = imported_body(C:\Users\karlr\Documents\0.3_edgewise.step)
  Ns5_Section1 [copper] = Ns5.section(plane=ZX)
  Ns6 [copper] = imported_body(C:\Users\karlr\Documents\0.3_edgewise.step)
  Ns6_Section1 [copper] = Ns6.section(plane=ZX)
  Ns7 [copper] = imported_body(C:\Users\karlr\Documents\0.3_edgewise.step)
  Ns7_Section1 [copper] = Ns7.section(plane=ZX)
  Ns8 [copper] = imported_body(C:\Users\karlr\Documents\0.3_edgewise.step)
  Ns8_Section1 [copper] = Ns8.section(plane=ZX)
  Ns9 [copper] = imported_body(C:\Users\karlr\Documents\0.3_edgewise.step)
  Ns9_Section1 [copper] = Ns9.section(plane=ZX)
  Body1 [ferrite] = imported_body(C:\Users\karlr\Documents\0.3_edgewise.step)
  Body1_1, Body1_2 [aluminum] = imported_body(C:\Users\karlr\Documents\0.3_edgewise.step)
  Body1_3 [ferrite] = imported_body(C:\Users\karlr\Documents\0.3_edgewise.step)
  Body1_4, Body1_5 [aluminum] = imported_body(C:\Users\karlr\Documents\0.3_edgewise.step)
  Np1_Section1.separate_bodies()
  Np2_Section1.separate_bodies()
  Np3_Section1.separate_bodies()
  Np4_Section1.separate_bodies()
  Np5_Section1.separate_bodies()
  Np6_Section1.separate_bodies()
  Np7_Section1.separate_bodies()
  Np8_Section1.separate_bodies()
  Np9_Section1.separate_bodies()
  Np10_Section1.separate_bodies()
  Np11_Section1.separate_bodies()
  Np12_Section1.separate_bodies()
  Ns1_Section1.separate_bodies()
  Ns2_Section1.separate_bodies()
  Ns3_Section1.separate_bodies()
  Ns4_Section1.separate_bodies()
  Ns5_Section1.separate_bodies()
  Ns6_Section1.separate_bodies()
  Ns7_Section1.separate_bodies()
  Ns8_Section1.separate_bodies()
  Ns9_Section1.separate_bodies()
  Ns10_Section1.separate_bodies()
  Ns11_Section1.separate_bodies()
  Ns12_Section1.separate_bodies()
  Region [air] = region(percentage_offset=1000 on all sides)
  Rectangle1 [Al-Extruded, non-model] = rectangle(corner=(39.8mm, 7.09649239mm, 0mm), z_size=19.7mm, x_size=-39.8mm)
  group core_assembled_edgewise = plate_1, plate_2, Np1, Np10, Np11, Np12, Np2..Np9, Ns1, Ns10, Ns11, Ns12, Ns2..Ns9, Np1_Section1, Np2_Section1, Np3_Section1, Np4_Section1, Np5_Section1, Np6_Section1, Np7_Section1, Np8_Section1, Np9_Section1, Np10_Section1, Np11_Section1, Np12_Section1, Ns1_Section1, Ns2_Section1, Ns3_Section1, Ns4_Section1, Ns5_Section1, Ns6_Section1, Ns7_Section1, Ns8_Section1, Ns9_Section1, Ns10_Section1, Ns11_Section1, Ns12_Section1
  group core_together_1 = Body1, Body1_1, Body1_2
  group core_together = Body1_3, Body1_4, Body1_5
boundaries and excitations:
  Opening1: Opening Faces=Region.face(-y) Temperature=AmbientTemp External_Rad._Temperature=AmbientRadTemp Inlet_Type=Velocity Static_Pressure=AmbientPressure X_Velocity=0m_per_sec Y_Velocity=0m_per_sec Z_Velocity=0m_per_sec
  Opening2: Opening Faces=Region.face(+y) Temperature=AmbientTemp External_Rad._Temperature=AmbientRadTemp Inlet_Type=Pressure Total_Pressure=AmbientPressure
  Block1: Block Objects=[Np1..Np12, Ns1..Ns12] Block_Type=Solid Use_Total_Power Total_Power="(1.2/24) W"
  Block2: Block Objects=[Body1, Body1_3] Block_Type=Solid Use_Total_Power Total_Power=0.5W
  StationaryWall1: Stationary Wall Faces=Body1_4.face(at (19.9, -4.95, 0)) Body1_3.face(at (19.9, 7.09649, 0)) Body1_5.face(at (19.9, 19.143, 0)) Thickness=0mm Solid_Material=Al-Extruded External_Condition=Temperature Heat_Flux=0irrad_W_per_m2 Temperature=10cel Heat_Transfer_Coefficient=0w_per_m2kel Reference_Temperature=AmbientTemp Heat_Transfer_Data{Heat_Transfer_Convection_Type="Forced Convection"} Radiation{Radiate RadiateTo=AllObjects Surface_Material=Steel-oxidised-surface} External_Material=Steel-oxidised-surface External_Radiation_Reference_Temperature=AmbientTemp External_Radiation_View_Factor=1
mesh:
  Global:  MeshMethod=MesherHD ComputeGap MeshRegionResolution=5 MinGapX=1mm MinGapY=1mm MinGapZ=1mm Objects=Region FacetLevel=5 ProximitySizeFunction CurvatureSizeFunction OptimizePCBMesh
setups:
  Setup1: IcepakSteadyState Flow_Regime=Laminar Include_Temperature=true Include_Flow=true Include_Gravity Solution_Initialization_-_Z_Velocity=0.000980665m_per_sec Convergence_Criteria_-_Flow=0.001 Convergence_Criteria_-_Energy=1e-07 Convergence_Criteria_-_Discrete_Ordinates=1e-06 GPU_Convergence_Criteria_-_Flow=0.001 GPU_Convergence_Criteria_-_Energy=1e-05 GPU_Convergence_Criteria_-_Discrete_Ordinates=1e-05 Radiation_Model="Discrete Ordinates Model" Flow_Iteration_Per_Radiation_Iteration=10 Time_Step_Interval=1 ThetaDivision=2 PhiDivision=2 ThetaPixels=2 PhiPixels=2 Under-relaxation_-_Pressure=0.7 Under-relaxation_-_Momentum=0.3 Under-relaxation_-_Temperature=1 Under-relaxation_-_Body_Force=1 Discretization_Scheme_-_Pressure=Standard Discretization_Scheme_-_Momentum=First Discretization_Scheme_-_Temperature=First Discretization_Scheme_-_Discrete_Ordinates=First Convergence_Criteria_-_Max_Iterations=100
field plots:
  Temperature1: Temperature over plate_1.face(all 10) plate_2.face(all 10) Np1.face(all 10) Np10.face(all 10) Np11.face(all 10) Np12.face(all 10) Np2.face(all 10) Np3.face(all 10) Np4.face(all 10) Np5.face(all 10) Np6.face(all 10) Np7.face(all 10) Np8.face(all 10) Np9.face(all 10) Ns1.face(all 10) Ns10.face(all 10) Ns11.face(all 10) Ns12.face(all 10) Ns2.face(all 10) Ns3.face(all 10) Ns4.face(all 10) Ns5.face(all 10) Ns6.face(all 10) Ns7.face(all 10) Ns8.face(all 10) Ns9.face(all 10) Body1.face(all 14) Body1_1.face(all 10) Body1_2.face(all 10) Body1_3.face(all 14) Body1_4.face(all 10) Body1_5.face(all 10) on Setup1 : SteadyState
  Temperature2: Temperature over a plane on Setup1 : SteadyState

design 0.40_edgewise_3D_1MHz (Maxwell 3D, EddyCurrent, model units mm)
geometry:
  Region [vacuum] = region(percentage_offset=0 on all sides)
  plate_1, plate_2 [FR4_epoxy] = imported_body(C:\Users\karlr\Documents\0.4_edgewise.step)
  Np1, Np10, Np11, Np12, Np2..Np9, Ns1, Ns10, Ns11, Ns12, Ns2..Ns9 [copper] = imported_body(C:\Users\karlr\Documents\0.4_edgewise.step)
  Body1 [ferrite] = imported_body(C:\Users\karlr\Documents\0.4_edgewise.step)
  Body1_1, Body1_2 [aluminum] = imported_body(C:\Users\karlr\Documents\0.4_edgewise.step)
  Body1_3 [ferrite] = imported_body(C:\Users\karlr\Documents\0.4_edgewise.step)
  Body1_4, Body1_5 [aluminum] = imported_body(C:\Users\karlr\Documents\0.4_edgewise.step)
  Ns12_Section1 [copper] = Ns12.section(plane=ZX)
  Np1_Section1 [copper] = Np1.section(plane=ZX)
  Np2_Section1 [copper] = Np2.section(plane=ZX)
  Np3_Section1 [copper] = Np3.section(plane=ZX)
  Np4_Section1 [copper] = Np4.section(plane=ZX)
  Np5_Section1 [copper] = Np5.section(plane=ZX)
  Np6_Section1 [copper] = Np6.section(plane=ZX)
  Np7_Section1 [copper] = Np7.section(plane=ZX)
  Np8_Section1 [copper] = Np8.section(plane=ZX)
  Np9_Section1 [copper] = Np9.section(plane=ZX)
  Np10_Section1 [copper] = Np10.section(plane=ZX)
  Np11_Section1 [copper] = Np11.section(plane=ZX)
  Np12_Section1 [copper] = Np12.section(plane=ZX)
  Ns1_Section1 [copper] = Ns1.section(plane=ZX)
  Ns2_Section1 [copper] = Ns2.section(plane=ZX)
  Ns3_Section1 [copper] = Ns3.section(plane=ZX)
  Ns4_Section1 [copper] = Ns4.section(plane=ZX)
  Ns5_Section1 [copper] = Ns5.section(plane=ZX)
  Ns6_Section1 [copper] = Ns6.section(plane=ZX)
  Ns7_Section1 [copper] = Ns7.section(plane=ZX)
  Ns8_Section1 [copper] = Ns8.section(plane=ZX)
  Ns9_Section1 [copper] = Ns9.section(plane=ZX)
  Ns10_Section1 [copper] = Ns10.section(plane=ZX)
  Ns11_Section1 [copper] = Ns11.section(plane=ZX)
  Ns12_Section1.separate_bodies()
  Np1_Section1.separate_bodies()
  Np2_Section1.separate_bodies()
  Np3_Section1.separate_bodies()
  Np4_Section1.separate_bodies()
  Np5_Section1.separate_bodies()
  Np6_Section1.separate_bodies()
  Np7_Section1.separate_bodies()
  Np8_Section1.separate_bodies()
  Np9_Section1.separate_bodies()
  Np10_Section1.separate_bodies()
  Np11_Section1.separate_bodies()
  Np12_Section1.separate_bodies()
  Ns1_Section1.separate_bodies()
  Ns2_Section1.separate_bodies()
  Ns3_Section1.separate_bodies()
  Ns4_Section1.separate_bodies()
  Ns5_Section1.separate_bodies()
  Ns6_Section1.separate_bodies()
  Ns7_Section1.separate_bodies()
  Ns8_Section1.separate_bodies()
  Ns9_Section1.separate_bodies()
  Ns10_Section1.separate_bodies()
  Ns11_Section1.separate_bodies()
  group core_assembled_edgewise = plate_1, plate_2, Np1, Np10, Np11, Np12, Np2..Np9, Ns1, Ns10, Ns11, Ns12, Ns2..Ns9, Ns12_Section1, Np1_Section1, Np2_Section1, Np3_Section1, Np4_Section1, Np5_Section1, Np6_Section1, Np7_Section1, Np8_Section1, Np9_Section1, Np10_Section1, Np11_Section1, Np12_Section1, Ns1_Section1, Ns2_Section1, Ns3_Section1, Ns4_Section1, Ns5_Section1, Ns6_Section1, Ns7_Section1, Ns8_Section1, Ns9_Section1, Ns10_Section1, Ns11_Section1
  group core_together_1 = Body1, Body1_1, Body1_2
  group core_together = Body1_3, Body1_4, Body1_5
boundaries and excitations:
  Np_1: Coil Terminal Objects=Np1_Section1 Conductor_number=1 Winding=Primary Point_out_of_terminal=false
  Np_2: Coil Terminal Objects=Np2_Section1 Conductor_number=1 Winding=Primary Point_out_of_terminal=false
  Np_3: Coil Terminal Objects=Np3_Section1 Conductor_number=1 Winding=Primary Point_out_of_terminal=false
  Np_4: Coil Terminal Objects=Np4_Section1 Conductor_number=1 Winding=Primary Point_out_of_terminal=false
  Np_5: Coil Terminal Objects=Np5_Section1 Conductor_number=1 Winding=Primary Point_out_of_terminal=false
  Np_6: Coil Terminal Objects=Np6_Section1 Conductor_number=1 Winding=Primary Point_out_of_terminal=false
  Np_7: Coil Terminal Objects=Np7_Section1 Conductor_number=1 Winding=Primary Point_out_of_terminal=false
  Np_8: Coil Terminal Objects=Np8_Section1 Conductor_number=1 Winding=Primary Point_out_of_terminal=false
  Np_9: Coil Terminal Objects=Np9_Section1 Conductor_number=1 Winding=Primary Point_out_of_terminal=false
  Np_10: Coil Terminal Objects=Np10_Section1 Conductor_number=1 Winding=Primary Point_out_of_terminal=false
  Np_11: Coil Terminal Objects=Np11_Section1 Conductor_number=1 Winding=Primary Point_out_of_terminal=false
  Np_12: Coil Terminal Objects=Np12_Section1 Conductor_number=1 Winding=Primary Point_out_of_terminal=false
  Ns_1: Coil Terminal Objects=Ns1_Section1 Conductor_number=1 Winding=Secondary Point_out_of_terminal=true
  Ns_2: Coil Terminal Objects=Ns2_Section1 Conductor_number=1 Winding=Secondary Point_out_of_terminal=true
  Ns_3: Coil Terminal Objects=Ns3_Section1 Conductor_number=1 Winding=Secondary Point_out_of_terminal=true
  Ns_4: Coil Terminal Objects=Ns4_Section1 Conductor_number=1 Winding=Secondary Point_out_of_terminal=true
  Ns_5: Coil Terminal Objects=Ns5_Section1 Conductor_number=1 Winding=Secondary Point_out_of_terminal=true
  Ns_6: Coil Terminal Objects=Ns6_Section1 Conductor_number=1 Winding=Secondary Point_out_of_terminal=true
  Ns_7: Coil Terminal Objects=Ns7_Section1 Conductor_number=1 Winding=Secondary Point_out_of_terminal=true
  Ns_8: Coil Terminal Objects=Ns8_Section1 Conductor_number=1 Winding=Secondary Point_out_of_terminal=true
  Ns_9: Coil Terminal Objects=Ns9_Section1 Conductor_number=1 Winding=Secondary Point_out_of_terminal=true
  Ns_10: Coil Terminal Objects=Ns10_Section1 Conductor_number=1 Winding=Secondary Point_out_of_terminal=true
  Ns_11: Coil Terminal Objects=Ns11_Section1 Conductor_number=1 Winding=Secondary Point_out_of_terminal=true
  Ns_12: Coil Terminal Objects=Ns12_Section1 Conductor_number=1 Winding=Secondary Point_out_of_terminal=true
  Primary: Winding Group Type=Current IsSolid=true Current=14.142A ParallelBranchesNum=1 Phase=0deg
  Secondary: Winding Group Type=Current IsSolid=true Current=13.942A ParallelBranchesNum=1 Phase=2deg
parameters:
  Matrix1: Matrix Primary, Secondary:
mesh:
  Length1: LengthBased Objects=[Np1..Np12, Ns1..Ns12, plate_1, plate_2] MaxLength=3mm
  Length2: LengthBased Objects=[Body1, Body1_2, Body1_1, Body1_3, Body1_5, Body1_4] MaxLength=3mm
  initial mesh: GlobalCurvilinear{Apply} MeshMethod=AnsoftClassic
setups:
  Setup1: EddyCurrent MaximumPasses=15 MinimumPasses=2 MinimumConvergedPasses=1 PercentRefinement=30 PercentError=1 NonLinearResidual=0.0001 Frequency=1MHz LossAdaptiveCtrl=0.5

design 0.20_edgewise_3D_1MHz (Maxwell 3D, EddyCurrent, model units mm)
geometry:
  Region [vacuum] = region(percentage_offset=0 on all sides)
  Np1, Np10, Np11, Np12, Np2..Np9, Ns1, Ns10, Ns11, Ns12, Ns2..Ns9 [copper] = imported_body(C:\Users\karlr\Documents\0.2_edgewise.step)
  plate_1, plate_2 [FR4_epoxy] = imported_body(C:\Users\karlr\Documents\0.2_edgewise.step)
  Body1 [ferrite] = imported_body(C:\Users\karlr\Documents\0.2_edgewise.step)
  Body1_1, Body1_2 [aluminum] = imported_body(C:\Users\karlr\Documents\0.2_edgewise.step)
  Body1_3 [ferrite] = imported_body(C:\Users\karlr\Documents\0.2_edgewise.step)
  Body1_4, Body1_5 [aluminum] = imported_body(C:\Users\karlr\Documents\0.2_edgewise.step)
  Np1_Section1 [copper] = Np1.section(plane=ZX)
  Np2_Section1 [copper] = Np2.section(plane=ZX)
  Np3_Section1 [copper] = Np3.section(plane=ZX)
  Np4_Section1 [copper] = Np4.section(plane=ZX)
  Np5_Section1 [copper] = Np5.section(plane=ZX)
  Np6_Section1 [copper] = Np6.section(plane=ZX)
  Np7_Section1 [copper] = Np7.section(plane=ZX)
  Np8_Section1 [copper] = Np8.section(plane=ZX)
  Np9_Section1 [copper] = Np9.section(plane=ZX)
  Np10_Section1 [copper] = Np10.section(plane=ZX)
  Np11_Section1 [copper] = Np11.section(plane=ZX)
  Np12_Section1 [copper] = Np12.section(plane=ZX)
  Ns1_Section1 [copper] = Ns1.section(plane=ZX)
  Ns2_Section1 [copper] = Ns2.section(plane=ZX)
  Ns3_Section1 [copper] = Ns3.section(plane=ZX)
  Ns4_Section1 [copper] = Ns4.section(plane=ZX)
  Ns5_Section1 [copper] = Ns5.section(plane=ZX)
  Ns6_Section1 [copper] = Ns6.section(plane=ZX)
  Ns7_Section1 [copper] = Ns7.section(plane=ZX)
  Ns8_Section1 [copper] = Ns8.section(plane=ZX)
  Ns9_Section1 [copper] = Ns9.section(plane=ZX)
  Ns10_Section1 [copper] = Ns10.section(plane=ZX)
  Ns11_Section1 [copper] = Ns11.section(plane=ZX)
  Ns12_Section1 [copper] = Ns12.section(plane=ZX)
  Np1_Section1.separate_bodies()
  Np2_Section1.separate_bodies()
  Np3_Section1.separate_bodies()
  Np4_Section1.separate_bodies()
  Np5_Section1.separate_bodies()
  Np6_Section1.separate_bodies()
  Np7_Section1.separate_bodies()
  Np8_Section1.separate_bodies()
  Np9_Section1.separate_bodies()
  Np10_Section1.separate_bodies()
  Np11_Section1.separate_bodies()
  Np12_Section1.separate_bodies()
  Ns1_Section1.separate_bodies()
  Ns2_Section1.separate_bodies()
  Ns3_Section1.separate_bodies()
  Ns4_Section1.separate_bodies()
  Ns5_Section1.separate_bodies()
  Ns6_Section1.separate_bodies()
  Ns7_Section1.separate_bodies()
  Ns8_Section1.separate_bodies()
  Ns9_Section1.separate_bodies()
  Ns10_Section1.separate_bodies()
  Ns11_Section1.separate_bodies()
  Ns12_Section1.separate_bodies()
  group core_assembled_edgewise = Np1, Np10, Np11, Np12, Np2..Np9, Ns1, Ns10, Ns11, Ns12, Ns2..Ns9, plate_1, plate_2, Np1_Section1, Np2_Section1, Np3_Section1, Np4_Section1, Np5_Section1, Np6_Section1, Np7_Section1, Np8_Section1, Np9_Section1, Np10_Section1, Np11_Section1, Np12_Section1, Ns1_Section1, Ns2_Section1, Ns3_Section1, Ns4_Section1, Ns5_Section1, Ns6_Section1, Ns7_Section1, Ns8_Section1, Ns9_Section1, Ns10_Section1, Ns11_Section1, Ns12_Section1
  group core_together_1 = Body1, Body1_1, Body1_2
  group core_together = Body1_3, Body1_4, Body1_5
boundaries and excitations:
  Np_1: Coil Terminal Objects=Np1_Section1 Conductor_number=1 Winding=Primary Point_out_of_terminal=false
  Np_2: Coil Terminal Objects=Np2_Section1 Conductor_number=1 Winding=Primary Point_out_of_terminal=false
  Np_3: Coil Terminal Objects=Np3_Section1 Conductor_number=1 Winding=Primary Point_out_of_terminal=false
  Np_4: Coil Terminal Objects=Np4_Section1 Conductor_number=1 Winding=Primary Point_out_of_terminal=false
  Np_5: Coil Terminal Objects=Np5_Section1 Conductor_number=1 Winding=Primary Point_out_of_terminal=false
  Np_6: Coil Terminal Objects=Np6_Section1 Conductor_number=1 Winding=Primary Point_out_of_terminal=false
  Np_7: Coil Terminal Objects=Np7_Section1 Conductor_number=1 Winding=Primary Point_out_of_terminal=false
  Np_8: Coil Terminal Objects=Np8_Section1 Conductor_number=1 Winding=Primary Point_out_of_terminal=false
  Np_9: Coil Terminal Objects=Np9_Section1 Conductor_number=1 Winding=Primary Point_out_of_terminal=false
  Np_10: Coil Terminal Objects=Np10_Section1 Conductor_number=1 Winding=Primary Point_out_of_terminal=false
  Np_11: Coil Terminal Objects=Np11_Section1 Conductor_number=1 Winding=Primary Point_out_of_terminal=false
  Np_12: Coil Terminal Objects=Np12_Section1 Conductor_number=1 Winding=Primary Point_out_of_terminal=false
  Ns_1: Coil Terminal Objects=Ns1_Section1 Conductor_number=1 Winding=Secondary Point_out_of_terminal=true
  Ns_2: Coil Terminal Objects=Ns2_Section1 Conductor_number=1 Winding=Secondary Point_out_of_terminal=true
  Ns_3: Coil Terminal Objects=Ns3_Section1 Conductor_number=1 Winding=Secondary Point_out_of_terminal=true
  Ns_4: Coil Terminal Objects=Ns4_Section1 Conductor_number=1 Winding=Secondary Point_out_of_terminal=true
  Ns_5: Coil Terminal Objects=Ns5_Section1 Conductor_number=1 Winding=Secondary Point_out_of_terminal=true
  Ns_6: Coil Terminal Objects=Ns6_Section1 Conductor_number=1 Winding=Secondary Point_out_of_terminal=true
  Ns_7: Coil Terminal Objects=Ns7_Section1 Conductor_number=1 Winding=Secondary Point_out_of_terminal=true
  Ns_8: Coil Terminal Objects=Ns8_Section1 Conductor_number=1 Winding=Secondary Point_out_of_terminal=true
  Ns_9: Coil Terminal Objects=Ns9_Section1 Conductor_number=1 Winding=Secondary Point_out_of_terminal=true
  Ns_10: Coil Terminal Objects=Ns10_Section1 Conductor_number=1 Winding=Secondary Point_out_of_terminal=true
  Ns_11: Coil Terminal Objects=Ns11_Section1 Conductor_number=1 Winding=Secondary Point_out_of_terminal=true
  Ns_12: Coil Terminal Objects=Ns12_Section1 Conductor_number=1 Winding=Secondary Point_out_of_terminal=true
  Primary: Winding Group Type=Current IsSolid=true Current=14.14A ParallelBranchesNum=1 Phase=0deg
  Secondary: Winding Group Type=Current IsSolid=true Current=14.14A ParallelBranchesNum=1 Phase=0deg
parameters:
  Matrix1: Matrix Primary, Secondary:
mesh:
  Length1: LengthBased Objects=[Np1..Np12, Ns1..Ns12, plate_1, plate_2] MaxLength=3mm
  Length2: LengthBased Objects=[Body1_1, Body1_2, Body1, Body1_3, Body1_5, Body1_4] MaxLength=3mm
  initial mesh: GlobalCurvilinear{Apply} MeshMethod=AnsoftClassic
setups:
  Setup1: EddyCurrent MaximumPasses=15 MinimumPasses=2 MinimumConvergedPasses=1 PercentRefinement=30 PercentError=1 NonLinearResidual=0.0001 Frequency=1MHz LossAdaptiveCtrl=0.5

design 0.40_edgewise_3D_1MHz1 (Maxwell 3D, EddyCurrent, model units mm)
geometry:
  Region [vacuum] = region(percentage_offset=0 on all sides)
  plate_1, plate_2 [FR4_epoxy] = imported_body(C:\Users\karlr\Documents\0.4_edgewise.step)
  Np1, Np10, Np11, Np12, Np2..Np9, Ns1, Ns10, Ns11, Ns12, Ns2..Ns9 [copper] = imported_body(C:\Users\karlr\Documents\0.4_edgewise.step)
  Body1 [ferrite] = imported_body(C:\Users\karlr\Documents\0.4_edgewise.step)
  Body1_1, Body1_2 [aluminum] = imported_body(C:\Users\karlr\Documents\0.4_edgewise.step)
  Body1_3 [ferrite] = imported_body(C:\Users\karlr\Documents\0.4_edgewise.step)
  Body1_4, Body1_5 [aluminum] = imported_body(C:\Users\karlr\Documents\0.4_edgewise.step)
  Ns12_Section1 [copper] = Ns12.section(plane=ZX)
  Np1_Section1 [copper] = Np1.section(plane=ZX)
  Np2_Section1 [copper] = Np2.section(plane=ZX)
  Np3_Section1 [copper] = Np3.section(plane=ZX)
  Np4_Section1 [copper] = Np4.section(plane=ZX)
  Np5_Section1 [copper] = Np5.section(plane=ZX)
  Np6_Section1 [copper] = Np6.section(plane=ZX)
  Np7_Section1 [copper] = Np7.section(plane=ZX)
  Np8_Section1 [copper] = Np8.section(plane=ZX)
  Np9_Section1 [copper] = Np9.section(plane=ZX)
  Np10_Section1 [copper] = Np10.section(plane=ZX)
  Np11_Section1 [copper] = Np11.section(plane=ZX)
  Np12_Section1 [copper] = Np12.section(plane=ZX)
  Ns1_Section1 [copper] = Ns1.section(plane=ZX)
  Ns2_Section1 [copper] = Ns2.section(plane=ZX)
  Ns3_Section1 [copper] = Ns3.section(plane=ZX)
  Ns4_Section1 [copper] = Ns4.section(plane=ZX)
  Ns5_Section1 [copper] = Ns5.section(plane=ZX)
  Ns6_Section1 [copper] = Ns6.section(plane=ZX)
  Ns7_Section1 [copper] = Ns7.section(plane=ZX)
  Ns8_Section1 [copper] = Ns8.section(plane=ZX)
  Ns9_Section1 [copper] = Ns9.section(plane=ZX)
  Ns10_Section1 [copper] = Ns10.section(plane=ZX)
  Ns11_Section1 [copper] = Ns11.section(plane=ZX)
  Ns12_Section1.separate_bodies()
  Np1_Section1.separate_bodies()
  Np2_Section1.separate_bodies()
  Np3_Section1.separate_bodies()
  Np4_Section1.separate_bodies()
  Np5_Section1.separate_bodies()
  Np6_Section1.separate_bodies()
  Np7_Section1.separate_bodies()
  Np8_Section1.separate_bodies()
  Np9_Section1.separate_bodies()
  Np10_Section1.separate_bodies()
  Np11_Section1.separate_bodies()
  Np12_Section1.separate_bodies()
  Ns1_Section1.separate_bodies()
  Ns2_Section1.separate_bodies()
  Ns3_Section1.separate_bodies()
  Ns4_Section1.separate_bodies()
  Ns5_Section1.separate_bodies()
  Ns6_Section1.separate_bodies()
  Ns7_Section1.separate_bodies()
  Ns8_Section1.separate_bodies()
  Ns9_Section1.separate_bodies()
  Ns10_Section1.separate_bodies()
  Ns11_Section1.separate_bodies()
  Rectangle1 [non-model] = rectangle(corner=(36.6mm, 7.1075504mm, 0mm), z_size=22mm, x_size=-36.6mm)
  Rectangle2 [non-model] = rectangle(corner=(18.3mm, -8.3mm, 0mm), y_size=30.815101mm, z_size=22.1mm)
  group core_assembled_edgewise = plate_1, plate_2, Np1, Np10, Np11, Np12, Np2..Np9, Ns1, Ns10, Ns11, Ns12, Ns2..Ns9, Ns12_Section1, Np1_Section1, Np2_Section1, Np3_Section1, Np4_Section1, Np5_Section1, Np6_Section1, Np7_Section1, Np8_Section1, Np9_Section1, Np10_Section1, Np11_Section1, Np12_Section1, Ns1_Section1, Ns2_Section1, Ns3_Section1, Ns4_Section1, Ns5_Section1, Ns6_Section1, Ns7_Section1, Ns8_Section1, Ns9_Section1, Ns10_Section1, Ns11_Section1
  group core_together_1 = Body1, Body1_1, Body1_2
  group core_together = Body1_3, Body1_4, Body1_5
boundaries and excitations:
  Np_1: Coil Terminal Objects=Np1_Section1 Conductor_number=1 Winding=Primary Point_out_of_terminal=false
  Np_2: Coil Terminal Objects=Np2_Section1 Conductor_number=1 Winding=Primary Point_out_of_terminal=false
  Np_3: Coil Terminal Objects=Np3_Section1 Conductor_number=1 Winding=Primary Point_out_of_terminal=false
  Np_4: Coil Terminal Objects=Np4_Section1 Conductor_number=1 Winding=Primary Point_out_of_terminal=false
  Np_5: Coil Terminal Objects=Np5_Section1 Conductor_number=1 Winding=Primary Point_out_of_terminal=false
  Np_6: Coil Terminal Objects=Np6_Section1 Conductor_number=1 Winding=Primary Point_out_of_terminal=false
  Np_7: Coil Terminal Objects=Np7_Section1 Conductor_number=1 Winding=Primary Point_out_of_terminal=false
  Np_8: Coil Terminal Objects=Np8_Section1 Conductor_number=1 Winding=Primary Point_out_of_terminal=false
  Np_9: Coil Terminal Objects=Np9_Section1 Conductor_number=1 Winding=Primary Point_out_of_terminal=false
  Np_10: Coil Terminal Objects=Np10_Section1 Conductor_number=1 Winding=Primary Point_out_of_terminal=false
  Np_11: Coil Terminal Objects=Np11_Section1 Conductor_number=1 Winding=Primary Point_out_of_terminal=false
  Np_12: Coil Terminal Objects=Np12_Section1 Conductor_number=1 Winding=Primary Point_out_of_terminal=false
  Ns_1: Coil Terminal Objects=Ns1_Section1 Conductor_number=1 Winding=Secondary Point_out_of_terminal=true
  Ns_2: Coil Terminal Objects=Ns2_Section1 Conductor_number=1 Winding=Secondary Point_out_of_terminal=true
  Ns_3: Coil Terminal Objects=Ns3_Section1 Conductor_number=1 Winding=Secondary Point_out_of_terminal=true
  Ns_4: Coil Terminal Objects=Ns4_Section1 Conductor_number=1 Winding=Secondary Point_out_of_terminal=true
  Ns_5: Coil Terminal Objects=Ns5_Section1 Conductor_number=1 Winding=Secondary Point_out_of_terminal=true
  Ns_6: Coil Terminal Objects=Ns6_Section1 Conductor_number=1 Winding=Secondary Point_out_of_terminal=true
  Ns_7: Coil Terminal Objects=Ns7_Section1 Conductor_number=1 Winding=Secondary Point_out_of_terminal=true
  Ns_8: Coil Terminal Objects=Ns8_Section1 Conductor_number=1 Winding=Secondary Point_out_of_terminal=true
  Ns_9: Coil Terminal Objects=Ns9_Section1 Conductor_number=1 Winding=Secondary Point_out_of_terminal=true
  Ns_10: Coil Terminal Objects=Ns10_Section1 Conductor_number=1 Winding=Secondary Point_out_of_terminal=true
  Ns_11: Coil Terminal Objects=Ns11_Section1 Conductor_number=1 Winding=Secondary Point_out_of_terminal=true
  Ns_12: Coil Terminal Objects=Ns12_Section1 Conductor_number=1 Winding=Secondary Point_out_of_terminal=true
  Primary: Winding Group Type=Current IsSolid=true Current=14.142A ParallelBranchesNum=1 Phase=0deg
  Secondary: Winding Group Type=Current IsSolid=true Current=13.942A ParallelBranchesNum=1 Phase=2deg
parameters:
  Matrix1: Matrix Primary, Secondary:
mesh:
  Length1: LengthBased Objects=[Np1..Np12, Ns1..Ns12, plate_1, plate_2] MaxLength=3mm
  Length2: LengthBased Objects=[Body1, Body1_2, Body1_1, Body1_3, Body1_5, Body1_4] MaxLength=3mm
  initial mesh: GlobalCurvilinear{Apply} MeshMethod=AnsoftClassic
setups:
  Setup1: EddyCurrent MaximumPasses=15 MinimumPasses=2 MinimumConvergedPasses=1 PercentRefinement=30 PercentError=2 NonLinearResidual=0.0001 Frequency=1MHz LossAdaptiveCtrl=0.5
field plots:
  Mag_J2: J over a plane on Setup1 : LastAdaptive at Freq=1MHz Phase=45deg
  Mag_B1, Mag_B2: B over a plane on Setup1 : LastAdaptive at Freq=1MHz Phase=0deg
  Mag_H1: H over a plane on Setup1 : LastAdaptive at Freq=1MHz Phase=45deg

design 0.30_edgewise_3D_1.5 (Maxwell 3D, EddyCurrent, model units mm)
geometry:
  Region [vacuum] = region(percentage_offset=0 on all sides)
  plate_1, plate_2 [FR4_epoxy] = imported_body(C:\Users\karlr\Documents\0.3_edgewise.step)
  Np1, Np10, Np11, Np12, Np2..Np9, Ns1, Ns10, Ns11, Ns12, Ns2..Ns9 [copper] = imported_body(C:\Users\karlr\Documents\0.3_edgewise.step)
  Body1 [ferrite] = imported_body(C:\Users\karlr\Documents\0.3_edgewise.step)
  Body1_1, Body1_2 [aluminum] = imported_body(C:\Users\karlr\Documents\0.3_edgewise.step)
  Body1_3 [ferrite] = imported_body(C:\Users\karlr\Documents\0.3_edgewise.step)
  Body1_4, Body1_5 [aluminum] = imported_body(C:\Users\karlr\Documents\0.3_edgewise.step)
  Np1_Section1 [copper] = Np1.section(plane=ZX)
  Np2_Section1 [copper] = Np2.section(plane=ZX)
  Np3_Section1 [copper] = Np3.section(plane=ZX)
  Np4_Section1 [copper] = Np4.section(plane=ZX)
  Np5_Section1 [copper] = Np5.section(plane=ZX)
  Np6_Section1 [copper] = Np6.section(plane=ZX)
  Np7_Section1 [copper] = Np7.section(plane=ZX)
  Np8_Section1 [copper] = Np8.section(plane=ZX)
  Np9_Section1 [copper] = Np9.section(plane=ZX)
  Np10_Section1 [copper] = Np10.section(plane=ZX)
  Np11_Section1 [copper] = Np11.section(plane=ZX)
  Np12_Section1 [copper] = Np12.section(plane=ZX)
  Ns1_Section1 [copper] = Ns1.section(plane=ZX)
  Ns2_Section1 [copper] = Ns2.section(plane=ZX)
  Ns3_Section1 [copper] = Ns3.section(plane=ZX)
  Ns4_Section1 [copper] = Ns4.section(plane=ZX)
  Ns5_Section1 [copper] = Ns5.section(plane=ZX)
  Ns6_Section1 [copper] = Ns6.section(plane=ZX)
  Ns7_Section1 [copper] = Ns7.section(plane=ZX)
  Ns8_Section1 [copper] = Ns8.section(plane=ZX)
  Ns9_Section1 [copper] = Ns9.section(plane=ZX)
  Ns10_Section1 [copper] = Ns10.section(plane=ZX)
  Ns11_Section1 [copper] = Ns11.section(plane=ZX)
  Ns12_Section1 [copper] = Ns12.section(plane=ZX)
  Np1_Section1.separate_bodies()
  Np2_Section1.separate_bodies()
  Np3_Section1.separate_bodies()
  Np4_Section1.separate_bodies()
  Np5_Section1.separate_bodies()
  Np6_Section1.separate_bodies()
  Np7_Section1.separate_bodies()
  Np8_Section1.separate_bodies()
  Np9_Section1.separate_bodies()
  Np10_Section1.separate_bodies()
  Np11_Section1.separate_bodies()
  Np12_Section1.separate_bodies()
  Ns1_Section1.separate_bodies()
  Ns2_Section1.separate_bodies()
  Ns3_Section1.separate_bodies()
  Ns4_Section1.separate_bodies()
  Ns5_Section1.separate_bodies()
  Ns6_Section1.separate_bodies()
  Ns7_Section1.separate_bodies()
  Ns8_Section1.separate_bodies()
  Ns9_Section1.separate_bodies()
  Ns10_Section1.separate_bodies()
  Ns11_Section1.separate_bodies()
  Ns12_Section1.separate_bodies()
  Rectangle1 [non-model] = rectangle(corner=(18mm, -10mm, 0mm), y_size=34mm, z_size=20mm)
  Rectangle2 [non-model] = rectangle(corner=(39.8mm, 7.09649239mm, 0mm), z_size=19.7mm, x_size=-39.8mm)
  Rectangle3 [non-model] = rectangle(corner=(5.2mm, -9.7mm, 11.65mm), x_size=29.4mm, y_size=33.59298478mm)
  group core_assembled_edgewise = plate_1, plate_2, Np1, Np10, Np11, Np12, Np2..Np9, Ns1, Ns10, Ns11, Ns12, Ns2..Ns9, Np1_Section1, Np2_Section1, Np3_Section1, Np4_Section1, Np5_Section1, Np6_Section1, Np7_Section1, Np8_Section1, Np9_Section1, Np10_Section1, Np11_Section1, Np12_Section1, Ns1_Section1, Ns2_Section1, Ns3_Section1, Ns4_Section1, Ns5_Section1, Ns6_Section1, Ns7_Section1, Ns8_Section1, Ns9_Section1, Ns10_Section1, Ns11_Section1, Ns12_Section1
  group core_together_1 = Body1, Body1_1, Body1_2
  group core_together = Body1_3, Body1_4, Body1_5
boundaries and excitations:
  Np_1: Coil Terminal Objects=Np1_Section1 Conductor_number=1 Winding=Primary Point_out_of_terminal=false
  Np_2: Coil Terminal Objects=Np2_Section1 Conductor_number=1 Winding=Primary Point_out_of_terminal=false
  Np_3: Coil Terminal Objects=Np3_Section1 Conductor_number=1 Winding=Primary Point_out_of_terminal=false
  Np_4: Coil Terminal Objects=Np4_Section1 Conductor_number=1 Winding=Primary Point_out_of_terminal=false
  Np_5: Coil Terminal Objects=Np5_Section1 Conductor_number=1 Winding=Primary Point_out_of_terminal=false
  Np_6: Coil Terminal Objects=Np6_Section1 Conductor_number=1 Winding=Primary Point_out_of_terminal=false
  Np_7: Coil Terminal Objects=Np7_Section1 Conductor_number=1 Winding=Primary Point_out_of_terminal=false
  Np_8: Coil Terminal Objects=Np8_Section1 Conductor_number=1 Winding=Primary Point_out_of_terminal=false
  Np_9: Coil Terminal Objects=Np9_Section1 Conductor_number=1 Winding=Primary Point_out_of_terminal=false
  Np_10: Coil Terminal Objects=Np10_Section1 Conductor_number=1 Winding=Primary Point_out_of_terminal=false
  Np_11: Coil Terminal Objects=Np11_Section1 Conductor_number=1 Winding=Primary Point_out_of_terminal=false
  Np_12: Coil Terminal Objects=Np12_Section1 Conductor_number=1 Winding=Primary Point_out_of_terminal=false
  Ns_1: Coil Terminal Objects=Ns1_Section1 Conductor_number=1 Winding=Secondary Point_out_of_terminal=true
  Ns_2: Coil Terminal Objects=Ns2_Section1 Conductor_number=1 Winding=Secondary Point_out_of_terminal=true
  Ns_3: Coil Terminal Objects=Ns3_Section1 Conductor_number=1 Winding=Secondary Point_out_of_terminal=true
  Ns_4: Coil Terminal Objects=Ns4_Section1 Conductor_number=1 Winding=Secondary Point_out_of_terminal=true
  Ns_5: Coil Terminal Objects=Ns5_Section1 Conductor_number=1 Winding=Secondary Point_out_of_terminal=true
  Ns_6: Coil Terminal Objects=Ns6_Section1 Conductor_number=1 Winding=Secondary Point_out_of_terminal=true
  Ns_7: Coil Terminal Objects=Ns7_Section1 Conductor_number=1 Winding=Secondary Point_out_of_terminal=true
  Ns_8: Coil Terminal Objects=Ns8_Section1 Conductor_number=1 Winding=Secondary Point_out_of_terminal=true
  Ns_9: Coil Terminal Objects=Ns9_Section1 Conductor_number=1 Winding=Secondary Point_out_of_terminal=true
  Ns_10: Coil Terminal Objects=Ns10_Section1 Conductor_number=1 Winding=Secondary Point_out_of_terminal=true
  Ns_11: Coil Terminal Objects=Ns11_Section1 Conductor_number=1 Winding=Secondary Point_out_of_terminal=true
  Ns_12: Coil Terminal Objects=Ns12_Section1 Conductor_number=1 Winding=Secondary Point_out_of_terminal=true
  Primary: Winding Group Type=Current IsSolid=true Current=14.142A ParallelBranchesNum=1 Phase=0deg
  Secondary: Winding Group Type=Current IsSolid=true Current=13.942A ParallelBranchesNum=1 Phase=0deg
parameters:
  Matrix1: Matrix Primary, Secondary:
mesh:
  Length1: LengthBased Objects=[Np1..Np12, Ns1..Ns12, plate_1, plate_2] MaxLength=3mm
  Length2: LengthBased Objects=[Body1_4, Body1_5, Body1_3, Body1_1, Body1_2, Body1] MaxLength=3mm
  initial mesh: GlobalSurfApproximation{CurvedSurfaceApproxChoice=UseSlider SliderMeshSettings=9} GlobalCurvilinear{Apply}
setups:
  Setup1: EddyCurrent MaximumPasses=15 MinimumPasses=2 MinimumConvergedPasses=1 PercentRefinement=30 PercentError=1.5 NonLinearResidual=0.0001 Frequency=30000Hz SweepRanges{1Hz to 300001Hz step 10000Hz} SaveAllFields LossAdaptiveCtrl=0.5
field plots:
  Mag_J1: J over a plane on Setup1 : LastAdaptive at Freq=1Hz Phase=45deg
reports:
  Coupling Coeff Table1: Matrix1.CplCoef(Primary,Primary), Matrix1.L(Primary,Primary), Matrix1.R(Primary,Primary), Matrix1.R(Primary,Secondary), Matrix1.R(Secondary,Secondary) vs Freq on Setup1 : LastAdaptive
