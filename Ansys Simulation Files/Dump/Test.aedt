# Ansys Electronics Desktop project, version 2025.1
materials:
  aluminum: permeability=1.000021 conductivity=38000000
  copper: permeability=0.999991 conductivity=58000000
  ferrite - Copy: core_loss_curve{25kHz (0, 0) (0.050633, 1) (0.0590114, 1.50406) (0.0691674, 2.34392) (0.0792528, 3.65275) (0.088772, 5.02746) (0.0939521, 6.11121) (0.1, 7.16954) (0.109499, 8.56175) (0.121957, 11.5767) (0.138164, 16.5092) (0.153013, 23.1293) (0.173347, 32.9841) (0.195272, 44.5991) (0.21382, 61.3838) (0.235462, 78.6962) (0.259294, 104.536) (0.280722, 138.862) (0.295422, 151.746)} core_loss_curve{100kHz (0, 0) (0.0263744, 1.03613) (0.0293752, 1.42608) (0.0332788, 2.03369) (0.0396755, 3.1693) (0.0449479, 4.44016) (0.0523856, 6.91954) (0.0628101, 11.373) (0.0753091, 20.068) (0.0882699, 32.4039) (0.103461, 49.6099) (0.118547, 74.6161) (0.142138, 118.363) (0.165658, 191.122) (0.184506, 245.025) (0.1975, 325.48) (0.215037, 409.937) (0.242235, 554.291) (0.26827, 762.898) (0.287163, 911.04)} core_loss_curve{200kHz (0, 0) (0.0153013, 1.07357) (0.0196383, 2.03369) (0.0260769, 4.28533) (0.0305648, 7.42858) (0.0396755, 14.0722) (0.0481134, 22.7224) (0.059347, 38.6962) (0.0757374, 74.6161) (0.0994345, 162.909) (0.110748, 216.401) (0.130546, 319.755) (0.147894, 472.47) (0.164721, 605.722) (0.183462, 848.612) (0.194168, 1013.4) (0.210213, 1167.99) (0.235462, 1607.55) (0.252045, 2024.69) (0.274425, 2333.54) (0.290439, 2939.06)} core_loss_curve{500kHz (0, 0) (0.0101716, 5.89811) (0.01199, 8.71505) (0.0149581, 13.5815) (0.0170423, 18.6929) (0.0202031, 30.1834) (0.0235462, 38.6962) (0.0266752, 55.1837) (0.0309135, 72.0142) (0.0356225, 99.1166) (0.0401281, 129.346) (0.0465037, 187.76) (0.0515018, 236.481) (0.0580159, 319.755) (0.067616, 447.974) (0.0761681, 574.318) (0.0892769, 776.557) (0.101141, 1068.81) (0.1199, 1524.21) (0.142138, 2292.49) (0.174333, 3327.81) (0.199753, 5186.04) (0.22248, 6531.74) (0.249202, 8373.92)} permittivity=12 permeability=3300 conductivity=0.25 core_loss_type="Power Ferrite" core_loss_cm=0.062032234 core_loss_x=1.7066326 core_loss_y=2.5354555 mass_density=4800 core_loss_equiv_cut_depth=0.001meter
  silicon - Copy: permittivity=9
  vacuum: permittivity=1
  ferrite - Copy (2): core_loss_curve{25kHz (0, 0) (0.050633, 1) (0.0590114, 1.50406) (0.0691674, 2.34392) (0.0792528, 3.65275) (0.088772, 5.02746) (0.0939521, 6.11121) (0.1, 7.16954) (0.109499, 8.56175) (0.121957, 11.5767) (0.138164, 16.5092) (0.153013, 23.1293) (0.173347, 32.9841) (0.195272, 44.5991) (0.21382, 61.3838) (0.235462, 78.6962) (0.259294, 104.536) (0.280722, 138.862) (0.295422, 151.746)} core_loss_curve{100kHz (0, 0) (0.0263744, 1.03613) (0.0293752, 1.42608) (0.0332788, 2.03369) (0.0396755, 3.1693) (0.0449479, 4.44016) (0.0523856, 6.91954) (0.0628101, 11.373) (0.0753091, 20.068) (0.0882699, 32.4039) (0.103461, 49.6099) (0.118547, 74.6161) (0.142138, 118.363) (0.165658, 191.122) (0.184506, 245.025) (0.1975, 325.48) (0.215037, 409.937) (0.242235, 554.291) (0.26827, 762.898) (0.287163, 911.04)} core_loss_curve{200kHz (0, 0) (0.0153013, 1.07357) (0.0196383, 2.03369) (0.0260769, 4.28533) (0.0305648, 7.42858) (0.0396755, 14.0722) (0.0481134, 22.7224) (0.059347, 38.6962) (0.0757374, 74.6161) (0.0994345, 162.909) (0.110748, 216.401) (0.130546, 319.755) (0.147894, 472.47) (0.164721, 605.722) (0.183462, 848.612) (0.194168, 1013.4) (0.210213, 1167.99) (0.235462, 1607.55) (0.252045, 2024.69) (0.274425, 2333.54) (0.290439, 2939.06)} core_loss_curve{500kHz (0, 0) (0.0101716, 5.89811) (0.01199, 8.71505) (0.0149581, 13.5815) (0.0170423, 18.6929) (0.0202031, 30.1834) (0.0235462, 38.6962) (0.0266752, 55.1837) (0.0309135, 72.0142) (0.0356225, 99.1166) (0.0401281, 129.346) (0.0465037, 187.76) (0.0515018, 236.481) (0.0580159, 319.755) (0.067616, 447.974) (0.0761681, 574.318) (0.0892769, 776.557) (0.101141, 1068.81) (0.1199, 1524.21) (0.142138, 2292.49) (0.174333, 3327.81) (0.199753, 5186.04) (0.22248, 6531.74) (0.249202, 8373.92)} permittivity=12 permeability=3400 conductivity=0.25 core_loss_type="Power Ferrite" core_loss_cm=0.062032234 core_loss_x=1.7066326 core_loss_y=2.5354555 mass_density=4800 core_loss_equiv_cut_depth=0.001meter

design 8turns_3D_WindingLoss_FullInterleaved_Flatwise (Maxwell 3D, EddyCurrent, model units mm)
geometry:
  Np1..Np8, Ns1..Ns8 [copper] = imported_body(C:\Users\karlr\Documents\flatwise_v3\Flatwise_1kW_final.step)
  plate_1, plate_2 [silicon - Copy] = imported_body(C:\Users\karlr\Documents\flatwise_v3\Flatwise_1kW_final.step)
  Body1 [ferrite - Copy (2)] = imported_body(C:\Users\karlr\Documents\flatwise_v3\Flatwise_1kW_final.step)
  Body1_1, Body1_2 [aluminum] = imported_body(C:\Users\karlr\Documents\flatwise_v3\Flatwise_1kW_final.step)
  Body1_3 [ferrite - Copy (2)] = imported_body(C:\Users\karlr\Documents\flatwise_v3\Flatwise_1kW_final.step)
  Body1_4, Body1_5 [aluminum] = imported_body(C:\Users\karlr\Documents\flatwise_v3\Flatwise_1kW_final.step)
  Np1_Section1 = Np1.section(plane=ZX)
  Np2_Section1 = Np2.section(plane=ZX)
  Np3_Section1 [copper] = Np3.section(plane=ZX)
  Np4_Section1 [copper] = Np4.section(plane=ZX)
  Np5_Section1 [copper] = Np5.section(plane=ZX)
  Np6_Section1 [copper] = Np6.section(plane=ZX)
  Np7_Section1 [copper] = Np7.section(plane=ZX)
  Np8_Section1 [copper] = Np8.section(plane=ZX)
  Ns1_Section1 = Ns1.section(plane=ZX)
  Ns2_Section1 = Ns2.section(plane=ZX)
  Ns3_Section1 [copper] = Ns3.section(plane=ZX)
  Ns4_Section1 [copper] = Ns4.section(plane=ZX)
  Ns5_Section1 [copper] = Ns5.section(plane=ZX)
  Ns6_Section1 [copper] = Ns6.section(plane=ZX)
  Ns7_Section1 [copper] = Ns7.section(plane=ZX)
  Ns8_Section1 [copper] = Ns8.section(plane=ZX)
  Np1_Section1_Separate1 [copper] = Np1_Section1.separate_bodies()
  Np1_Section1.delete()
  Np2_Section1_Separate1 [copper] = Np2_Section1.separate_bodies()
  Np2_Section1.delete()
  Np3_Section1.separate_bodies()
  Np4_Section1.separate_bodies()
  Np5_Section1.separate_bodies()
  Np6_Section1.separate_bodies()
  Np7_Section1.separate_bodies()
  Np8_Section1.separate_bodies()
  Ns1_Section1_Separate1 [copper] = Ns1_Section1.separate_bodies()
  Ns1_Section1.delete()
  Ns2_Section1_Separate1 [copper] = Ns2_Section1.separate_bodies()
  Ns2_Section1.delete()
  Ns3_Section1.separate_bodies()
  Ns4_Section1.separate_bodies()
  Ns5_Section1.separate_bodies()
  Ns6_Section1.separate_bodies()
  Ns7_Section1.separate_bodies()
  Ns8_Section1.separate_bodies()
  Region [vacuum] = region(percentage_offset=0 on all sides)
  Rectangle1 [non-model] = rectangle(corner=(0mm, 30mm, 0mm), z_size=25mm, x_size=65mm)
  group core_assembled_flatwise = Np1..Np8, Ns1..Ns8, plate_1, plate_2, Np3_Section1, Np4_Section1, Np5_Section1, Np6_Section1, Np7_Section1, Np8_Section1, Ns3_Section1, Ns4_Section1, Ns5_Section1, Ns6_Section1, Ns7_Section1, Ns8_Section1, Np1_Section1_Separate1, Np2_Section1_Separate1, Ns1_Section1_Separate1, Ns2_Section1_Separate1
  group core_together_1 = Body1, Body1_1, Body1_2
  group core_together = Body1_3, Body1_4, Body1_5
boundaries and excitations:
  Np_1: Coil Terminal Objects=Np1_Section1_Separate1 Conductor_number=1 Winding=Np Point_out_of_terminal=false
  Np_2: Coil Terminal Objects=Np2_Section1_Separate1 Conductor_number=1 Winding=Np Point_out_of_terminal=false
  Np_3: Coil Terminal Objects=Np3_Section1 Conductor_number=1 Winding=Np Point_out_of_terminal=false
  Np_4: Coil Terminal Objects=Np4_Section1 Conductor_number=1 Winding=Np Point_out_of_terminal=false
  Np_5: Coil Terminal Objects=Np5_Section1 Conductor_number=1 Winding=Np Point_out_of_terminal=false
  Np_6: Coil Terminal Objects=Np6_Section1 Conductor_number=1 Winding=Np Point_out_of_terminal=false
  Np_7: Coil Terminal Objects=Np7_Section1 Conductor_number=1 Winding=Np Point_out_of_terminal=false
  Np_8: Coil Terminal Objects=Np8_Section1 Conductor_number=1 Winding=Np Point_out_of_terminal=false
  Ns_1: Coil Terminal Objects=Ns1_Section1_Separate1 Conductor_number=1 Winding=Ns Point_out_of_terminal=true
  Ns_2: Coil Terminal Objects=Ns2_Section1_Separate1 Conductor_number=1 Winding=Ns Point_out_of_terminal=true
  Ns_3: Coil Terminal Objects=Ns3_Section1 Conductor_number=1 Winding=Ns Point_out_of_terminal=true
  Ns_4: Coil Terminal Objects=Ns4_Section1 Conductor_number=1 Winding=Ns Point_out_of_terminal=true
  Ns_5: Coil Terminal Objects=Ns5_Section1 Conductor_number=1 Winding=Ns Point_out_of_terminal=true
  Ns_6: Coil Terminal Objects=Ns6_Section1 Conductor_number=1 Winding=Ns Point_out_of_terminal=true
  Ns_7: Coil Terminal Objects=Ns7_Section1 Conductor_number=1 Winding=Ns Point_out_of_terminal=true
  Ns_8: Coil Terminal Objects=Ns8_Section1 Conductor_number=1 Winding=Ns Point_out_of_terminal=true
  Np: Winding Group Type=Voltage IsSolid=true Current=16.36A Resistance=0ohm Inductance=0nH Voltage=141.42V ParallelBranchesNum=1 Phase=0rad
  Ns: Winding Group Type=Current IsSolid=true Current="(11*1.4) A" ParallelBranchesNum=1 Phase=0.1522rad
  eddy effects on: Np1..Np8, Ns1..Ns8, Body1_1, Body1_2, Body1_4, Body1_5
  core loss on: Body1, Body1_3
parameters:
  Matrix1: Matrix Np, Ns:
mesh:
  Length1: LengthBased Objects=[plate_1, plate_2, Np1..Np8, Ns1..Ns8] MaxLength=1.5mm
  Length2: LengthBased Objects=[Body1_1, Body1_2, Body1, Body1_4, Body1_5, Body1_3] MaxLength=4.5mm
  initial mesh: GlobalSurfApproximation{CurvedSurfaceApproxChoice=UseSlider SliderMeshSettings=9} GlobalCurvilinear{Apply}
setups:
  Setup1: EddyCurrent MaximumPasses=20 MinimumPasses=2 MinimumConvergedPasses=1 PercentRefinement=30 PercentError=1 NonLinearResidual=0.0001 SmoothBHCurve Frequency=28.5kHz LossAdaptiveCtrl=0.5
field plots:
  Mag_B1: B over Body1.face(at (27.5, 30, 19), at (27.5, 0, 14.275), at (55, 30, 14.275), at (0, 30, 14.275)) Body1_3.face(at (55, 30, 4.725)) on Setup1 : LastAdaptive at Freq=28.5kHz Phase=45deg
  Mag_J1: J over Np1..Np8, Ns1..Ns8 on Setup1 : LastAdaptive at Freq=28.5kHz Phase=45deg
  Mag_J2: J over a plane on Setup1 : LastAdaptive at Freq=28.5kHz Phase=45deg
  Mag_B2: B over a plane on Setup1 : LastAdaptive at Freq=28.5kHz Phase=45deg

design 8turns_3D_WindingLoss_FullInterleaved_Flatwise1 (Maxwell 3D, EddyCurrent, model units mm)
geometry:
  Np1..Np8, Ns1..Ns8 [copper] = imported_body(C:\Users\karlr\Documents\flatwise_v3\Flatwise_1kW_final.step)
  plate_1, plate_2 [silicon - Copy] = imported_body(C:\Users\karlr\Documents\flatwise_v3\Flatwise_1kW_final.step)
  Body1 [ferrite - Copy] = imported_body(C:\Users\karlr\Documents\flatwise_v3\Flatwise_1kW_final.step)
  Body1_1, Body1_2 [aluminum] = imported_body(C:\Users\karlr\Documents\flatwise_v3\Flatwise_1kW_final.step)
  Body1_3 [ferrite - Copy] = imported_body(C:\Users\karlr\Documents\flatwise_v3\Flatwise_1kW_final.step)
  Body1_4, Body1_5 [aluminum] = imported_body(C:\Users\karlr\Documents\flatwise_v3\Flatwise_1kW_final.step)
  Np1_Section1 = Np1.section(plane=ZX)
  Np2_Section1 = Np2.section(plane=ZX)
  Np3_Section1 [copper] = Np3.section(plane=ZX)
  Np4_Section1 [copper] = Np4.section(plane=ZX)
  Np5_Section1 [copper] = Np5.section(plane=ZX)
  Np6_Section1 [copper] = Np6.section(plane=ZX)
  Np7_Section1 [copper] = Np7.section(plane=ZX)
  Np8_Section1 [copper] = Np8.section(plane=ZX)
  Ns1_Section1 = Ns1.section(plane=ZX)
  Ns2_Section1 = Ns2.section(plane=ZX)
  Ns3_Section1 [copper] = Ns3.section(plane=ZX)
  Ns4_Section1 [copper] = Ns4.section(plane=ZX)
  Ns5_Section1 [copper] = Ns5.section(plane=ZX)
  Ns6_Section1 [copper] = Ns6.section(plane=ZX)
  Ns7_Section1 [copper] = Ns7.section(plane=ZX)
  Ns8_Section1 [copper] = Ns8.section(plane=ZX)
  Np1_Section1_Separate1 [copper] = Np1_Section1.separate_bodies()
  Np1_Section1.delete()
  Np2_Section1_Separate1 [copper] = Np2_Section1.separate_bodies()
  Np2_Section1.delete()
  Np3_Section1.separate_bodies()
  Np4_Section1.separate_bodies()
  Np5_Section1.separate_bodies()
  Np6_Section1.separate_bodies()
  Np7_Section1.separate_bodies()
  Np8_Section1.separate_bodies()
  Ns1_Section1_Separate1 [copper] = Ns1_Section1.separate_bodies()
  Ns1_Section1.delete()
  Ns2_Section1_Separate1 [copper] = Ns2_Section1.separate_bodies()
  Ns2_Section1.delete()
  Ns3_Section1.separate_bodies()
  Ns4_Section1.separate_bodies()
  Ns5_Section1.separate_bodies()
  Ns6_Section1.separate_bodies()
  Ns7_Section1.separate_bodies()
  Ns8_Section1.separate_bodies()
  Region [vacuum] = region(percentage_offset=0 on all sides)
  Rectangle1 [non-model] = rectangle(corner=(0mm, 30mm, 0mm), z_size=25mm, x_size=65mm)
  group core_assembled_flatwise = Np1..Np8, Ns1..Ns8, plate_1, plate_2, Np3_Section1, Np4_Section1, Np5_Section1, Np6_Section1, Np7_Section1, Np8_Section1, Ns3_Section1, Ns4_Section1, Ns5_Section1, Ns6_Section1, Ns7_Section1, Ns8_Section1, Np1_Section1_Separate1, Np2_Section1_Separate1, Ns1_Section1_Separate1, Ns2_Section1_Separate1
  group core_together_1 = Body1, Body1_1, Body1_2
  group core_together = Body1_3, Body1_4, Body1_5
boundaries and excitations:
  Np_1: Coil Terminal Objects=Np1_Section1_Separate1 Conductor_number=1 Winding=Np Point_out_of_terminal=false
  Np_2: Coil Terminal Objects=Np2_Section1_Separate1 Conductor_number=1 Winding=Np Point_out_of_terminal=false
  Np_3: Coil Terminal Objects=Np3_Section1 Conductor_number=1 Winding=Np Point_out_of_terminal=false
  Np_4: Coil Terminal Objects=Np4_Section1 Conductor_number=1 Winding=Np Point_out_of_terminal=false
  Np_5: Coil Terminal Objects=Np5_Section1 Conductor_number=1 Winding=Np Point_out_of_terminal=false
  Np_6: Coil Terminal Objects=Np6_Section1 Conductor_number=1 Winding=Np Point_out_of_terminal=false
  Np_7: Coil Terminal Objects=Np7_Section1 Conductor_number=1 Winding=Np Point_out_of_terminal=false
  Np_8: Coil Terminal Objects=Np8_Section1 Conductor_number=1 Winding=Np Point_out_of_terminal=false
  Ns_1: Coil Terminal Objects=Ns1_Section1_Separate1 Conductor_number=1 Winding=Ns Point_out_of_terminal=true
  Ns_2: Coil Terminal Objects=Ns2_Section1_Separate1 Conductor_number=1 Winding=Ns Point_out_of_terminal=true
  Ns_3: Coil Terminal Objects=Ns3_Section1 Conductor_number=1 Winding=Ns Point_out_of_terminal=true
  Ns_4: Coil Terminal Objects=Ns4_Section1 Conductor_number=1 Winding=Ns Point_out_of_terminal=true
  Ns_5: Coil Terminal Objects=Ns5_Section1 Conductor_number=1 Winding=Ns Point_out_of_terminal=true
  Ns_6: Coil Terminal Objects=Ns6_Section1 Conductor_number=1 Winding=Ns Point_out_of_terminal=true
  Ns_7: Coil Terminal Objects=Ns7_Section1 Conductor_number=1 Winding=Ns Point_out_of_terminal=true
  Ns_8: Coil Terminal Objects=Ns8_Section1 Conductor_number=1 Winding=Ns Point_out_of_terminal=true
  Np: Winding Group Type=Current IsSolid=true Current=16.36A ParallelBranchesNum=1 Phase=0rad
  Ns: Winding Group Type=Current IsSolid=true Current=16.36A ParallelBranchesNum=1 Phase=0rad
  eddy effects on: Np1..Np8, Ns1..Ns8, Body1_1, Body1_2, Body1_4, Body1_5
  core loss on: Body1, Body1_3
parameters:
  Matrix1: Matrix Np, Ns:
mesh:
  Length1: LengthBased Objects=[plate_1, plate_2, Np1..Np8, Ns1..Ns8] MaxLength=1.5mm
  Length2: LengthBased Objects=[Body1_1, Body1_2, Body1, Body1_4, Body1_5, Body1_3] MaxLength=4.5mm
  initial mesh: GlobalSurfApproximation{CurvedSurfaceApproxChoice=UseSlider SliderMeshSettings=9} GlobalCurvilinear{Apply}
setups:
  Setup1: EddyCurrent MaximumPasses=20 MinimumPasses=2 MinimumConvergedPasses=1 PercentRefinement=30 PercentError=1 NonLinearResidual=0.0001 SmoothBHCurve Frequency=28.5kHz LossAdaptiveCtrl=0.5
field plots:
  Mag_B1: B over Body1.face(at (27.5, 30, 19), at (27.5, 0, 14.275), at (55, 30, 14.275), at (0, 30, 14.275)) Body1_3.face(at (55, 30, 4.725)) on Setup1 : LastAdaptive at Freq=28.5kHz Phase=90deg
  Mag_J1: J over Np1..Np8, Ns1..Ns8 on Setup1 : LastAdaptive at Freq=28.5kHz Phase=45deg
  Mag_J2: J over a plane on Setup1 : LastAdaptive at Freq=28.5kHz Phase=45deg
  Mag_B2: B over a plane on Setup1 : LastAdaptive at Freq=28.5kHz Phase=45deg
