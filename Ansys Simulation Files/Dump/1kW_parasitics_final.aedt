# Ansys Electronics Desktop project, version 2025.1
materials:
  Al_N: permittivity=8.8
  aluminum: permeability=1.000021 conductivity=38000000
  copper: permeability=0.999991 conductivity=58000000
  ferrite - Copy: core_loss_curve{25kHz (0, 0) (0.050633, 1) (0.0590114, 1.50406) (0.0691674, 2.34392) (0.0792528, 3.65275) (0.088772, 5.02746) (0.0939521, 6.11121) (0.1, 7.16954) (0.109499, 8.56175) (0.121957, 11.5767) (0.138164, 16.5092) (0.153013, 23.1293) (0.173347, 32.9841) (0.195272, 44.5991) (0.21382, 61.3838) (0.235462, 78.6962) (0.259294, 104.536) (0.280722, 138.862) (0.295422, 151.746)} core_loss_curve{100kHz (0, 0) (0.0263744, 1.03613) (0.0293752, 1.42608) (0.0332788, 2.03369) (0.0396755, 3.1693) (0.0449479, 4.44016) (0.0523856, 6.91954) (0.0628101, 11.373) (0.0753091, 20.068) (0.0882699, 32.4039) (0.103461, 49.6099) (0.118547, 74.6161) (0.142138, 118.363) (0.165658, 191.122) (0.184506, 245.025) (0.1975, 325.48) (0.215037, 409.937) (0.242235, 554.291) (0.26827, 762.898) (0.287163, 911.04)} core_loss_curve{200kHz (0, 0) (0.0153013, 1.07357) (0.0196383, 2.03369) (0.0260769, 4.28533) (0.0305648, 7.42858) (0.0396755, 14.0722) (0.0481134, 22.7224) (0.059347, 38.6962) (0.0757374, 74.6161) (0.0994345, 162.909) (0.110748, 216.401) (0.130546, 319.755) (0.147894, 472.47) (0.164721, 605.722) (0.183462, 848.612) (0.194168, 1013.4) (0.210213, 1167.99) (0.235462, 1607.55) (0.252045, 2024.69) (0.274425, 2333.54) (0.290439, 2939.06)} core_loss_curve{500kHz (0, 0) (0.0101716, 5.89811) (0.01199, 8.71505) (0.0149581, 13.5815) (0.0170423, 18.6929) (0.0202031, 30.1834) (0.0235462, 38.6962) (0.0266752, 55.1837) (0.0309135, 72.0142) (0.0356225, 99.1166) (0.0401281, 129.346) (0.0465037, 187.76) (0.0515018, 236.481) (0.0580159, 319.755) (0.067616, 447.974) (0.0761681, 574.318) (0.0892769, 776.557) (0.101141, 1068.81) (0.1199, 1524.21) (0.142138, 2292.49) (0.174333, 3327.81) (0.199753, 5186.04) (0.22248, 6531.74) (0.249202, 8373.92)} permittivity=12 permeability=3300 conductivity=0.25 core_loss_type="Power Ferrite" core_loss_cm=0.062032234 core_loss_x=1.7066326 core_loss_y=2.5354555 mass_density=4800 core_loss_equiv_cut_depth=0.001meter
  vacuum: permittivity=1
  silicon - Copy: permittivity=9

design 12turns_3D_FullInterleaved_parasitics_Np1Ns0_GNDBoth (Maxwell 3D, Electrostatic, model units mm)
geometry:
  Region [vacuum] = region(percentage_offset=0 on all sides)
  Np1 [copper] = imported_body(C:\Users\karlr\Documents\core_assembled_flatwise_12turns.step)
  Np1_Section1 = Np1.section(plane=ZX)
  Np10 [copper] = imported_body(C:\Users\karlr\Documents\core_assembled_flatwise_12turns.step)
  Np10_Section1 = Np10.section(plane=ZX)
  Np11 [copper] = imported_body(C:\Users\karlr\Documents\core_assembled_flatwise_12turns.step)
  Np11_Section1 = Np11.section(plane=ZX)
  Np12 [copper] = imported_body(C:\Users\karlr\Documents\core_assembled_flatwise_12turns.step)
  Np12_Section1 = Np12.section(plane=ZX)
  Np2 [copper] = imported_body(C:\Users\karlr\Documents\core_assembled_flatwise_12turns.step)
  Np2_Section1 = Np2.section(plane=ZX)
  Np3 [copper] = imported_body(C:\Users\karlr\Documents\core_assembled_flatwise_12turns.step)
  Np3_Section1 = Np3.section(plane=ZX)
  Np4 [copper] = imported_body(C:\Users\karlr\Documents\core_assembled_flatwise_12turns.step)
  Np4_Section1 = Np4.section(plane=ZX)
  Np5 [copper] = imported_body(C:\Users\karlr\Documents\core_assembled_flatwise_12turns.step)
  Np5_Section1 = Np5.section(plane=ZX)
  Np6 [copper] = imported_body(C:\Users\karlr\Documents\core_assembled_flatwise_12turns.step)
  Np6_Section1 = Np6.section(plane=ZX)
  Np7 [copper] = imported_body(C:\Users\karlr\Documents\core_assembled_flatwise_12turns.step)
  Np7_Section1 = Np7.section(plane=ZX)
  Np8 [copper] = imported_body(C:\Users\karlr\Documents\core_assembled_flatwise_12turns.step)
  Np8_Section1 = Np8.section(plane=ZX)
  Np9 [copper] = imported_body(C:\Users\karlr\Documents\core_assembled_flatwise_12turns.step)
  Np9_Section1 = Np9.section(plane=ZX)
  Ns1 [copper] = imported_body(C:\Users\karlr\Documents\core_assembled_flatwise_12turns.step)
  Ns1_Section1 = Ns1.section(plane=ZX)
  Ns10 [copper] = imported_body(C:\Users\karlr\Documents\core_assembled_flatwise_12turns.step)
  Ns10_Section1 = Ns10.section(plane=ZX)
  Ns11 [copper] = imported_body(C:\Users\karlr\Documents\core_assembled_flatwise_12turns.step)
  Ns11_Section1 = Ns11.section(plane=ZX)
  Ns12 [copper] = imported_body(C:\Users\karlr\Documents\core_assembled_flatwise_12turns.step)
  Ns12_Section1 = Ns12.section(plane=ZX)
  Ns2 [copper] = imported_body(C:\Users\karlr\Documents\core_assembled_flatwise_12turns.step)
  Ns2_Section1 = Ns2.section(plane=ZX)
  Ns3 [copper] = imported_body(C:\Users\karlr\Documents\core_assembled_flatwise_12turns.step)
  Ns3_Section1 = Ns3.section(plane=ZX)
  Ns4 [copper] = imported_body(C:\Users\karlr\Documents\core_assembled_flatwise_12turns.step)
  Ns4_Section1 = Ns4.section(plane=ZX)
  Ns5 [copper] = imported_body(C:\Users\karlr\Documents\core_assembled_flatwise_12turns.step)
  Ns5_Section1 = Ns5.section(plane=ZX)
  Ns6 [copper] = imported_body(C:\Users\karlr\Documents\core_assembled_flatwise_12turns.step)
  Ns6_Section1 = Ns6.section(plane=ZX)
  Ns7 [copper] = imported_body(C:\Users\karlr\Documents\core_assembled_flatwise_12turns.step)
  Ns7_Section1 = Ns7.section(plane=ZX)
  Ns8 [copper] = imported_body(C:\Users\karlr\Documents\core_assembled_flatwise_12turns.step)
  Ns8_Section1 = Ns8.section(plane=ZX)
  Ns9 [copper] = imported_body(C:\Users\karlr\Documents\core_assembled_flatwise_12turns.step)
  Ns9_Section1 = Ns9.section(plane=ZX)
  plate_1, plate_2 [Al_N] = imported_body(C:\Users\karlr\Documents\core_assembled_flatwise_12turns.step)
  Body1 [ferrite - Copy] = imported_body(C:\Users\karlr\Documents\core_assembled_flatwise_12turns.step)
  Body1_1, Body1_2 [aluminum] = imported_body(C:\Users\karlr\Documents\core_assembled_flatwise_12turns.step)
  Body1_3 [ferrite - Copy] = imported_body(C:\Users\karlr\Documents\core_assembled_flatwise_12turns.step)
  Body1_4, Body1_5 [aluminum] = imported_body(C:\Users\karlr\Documents\core_assembled_flatwise_12turns.step)
  Np1_Section1.separate_bodies()
  Np2_Section1.separate_bodies()
  Np3_Section1.separate_bodies()
  Np4_Section1.separate_bodies()
  Np5_Section1.separate_bodies()
  Np6_Section1.separate_bodies()
  Np7_Section1.separate_bodies()
  Np8_Section1.separate_bodies()
  Np9_Section1.separate_bodies()
  Np10_Section1.separate_bodies()
  Np11_Section1.separate_bodies()
  Np12_Section1.separate_bodies()
  Ns1_Section1.separate_bodies()
  Ns2_Section1.separate_bodies()
  Ns3_Section1.separate_bodies()
  Ns4_Section1.separate_bodies()
  Ns5_Section1.separate_bodies()
  Ns6_Section1.separate_bodies()
  Ns7_Section1.separate_bodies()
  Ns8_Section1.separate_bodies()
  Ns9_Section1.separate_bodies()
  Ns10_Section1.separate_bodies()
  Ns11_Section1.separate_bodies()
  Ns12_Section1_Separate1 = Ns12_Section1.separate_bodies()
  Ns12_Section1.delete()
  group core_assembled_flatwise = Np1, Np10, Np11, Np12, Np2..Np9, Ns1, Ns10, Ns11, Ns12, Ns2..Ns9, plate_1, plate_2, Np1_Section1, Np2_Section1, Np3_Section1, Np4_Section1, Np5_Section1, Np6_Section1, Np7_Section1, Np8_Section1, Np9_Section1, Np10_Section1, Np11_Section1, Np12_Section1, Ns1_Section1, Ns2_Section1, Ns3_Section1, Ns4_Section1, Ns5_Section1, Ns6_Section1, Ns7_Section1, Ns8_Section1, Ns9_Section1, Ns10_Section1, Ns11_Section1, Ns12_Section1_Separate1
  group core_together_1 = Body1, Body1_1, Body1_2
  group core_together = Body1_3, Body1_4, Body1_5
boundaries and excitations:
  Voltage1: Voltage Objects=[Np1..Np12] Voltage=1V
  Voltage2: Voltage Objects=[Ns1..Ns12] Voltage=0mV
  Voltage3: Voltage Objects=[Body1, Body1_1..Body1_5, plate_1, plate_2] Voltage=0mV
parameters:
  Matrix1: Matrix Voltage1, Voltage2, Voltage3: NumberOfTurns=1
mesh:
  Length1: LengthBased Objects=[plate_2, Np1..Np12, Ns1..Ns12, plate_1] MaxLength=2mm
  Length2: LengthBased Objects=[Body1_1, Body1_2, Body1, Body1_3, Body1_4, Body1_5] MaxLength=5mm
  initial mesh: GlobalSurfApproximation{CurvedSurfaceApproxChoice=UseSlider SliderMeshSettings=9} GlobalCurvilinear{Apply} MeshMethod=AnsoftClassic
setups:
  Setup1: Electrostatic MaximumPasses=20 MinimumPasses=2 MinimumConvergedPasses=1 PercentRefinement=30 PercentError=1 NonLinearResidual=0.001

design 12turns_3D_NoInterleaving_parasitics_Np1Ns0_GNDBoth (Maxwell 3D, Electrostatic, model units mm)
geometry:
  Region [vacuum] = region(percentage_offset=0 on all sides)
  Np1 [copper] = imported_body(C:\Users\karlr\Documents\core_assembled_flatwise_12turns.step)
  Np1_Section1 = Np1.section(plane=ZX)
  Np10 [copper] = imported_body(C:\Users\karlr\Documents\core_assembled_flatwise_12turns.step)
  Np10_Section1 = Np10.section(plane=ZX)
  Np11 [copper] = imported_body(C:\Users\karlr\Documents\core_assembled_flatwise_12turns.step)
  Np11_Section1 = Np11.section(plane=ZX)
  Np12 [copper] = imported_body(C:\Users\karlr\Documents\core_assembled_flatwise_12turns.step)
  Np12_Section1 = Np12.section(plane=ZX)
  Np2 [copper] = imported_body(C:\Users\karlr\Documents\core_assembled_flatwise_12turns.step)
  Np2_Section1 = Np2.section(plane=ZX)
  Np3 [copper] = imported_body(C:\Users\karlr\Documents\core_assembled_flatwise_12turns.step)
  Np3_Section1 = Np3.section(plane=ZX)
  Np4 [copper] = imported_body(C:\Users\karlr\Documents\core_assembled_flatwise_12turns.step)
  Np4_Section1 = Np4.section(plane=ZX)
  Np5 [copper] = imported_body(C:\Users\karlr\Documents\core_assembled_flatwise_12turns.step)
  Np5_Section1 = Np5.section(plane=ZX)
  Np6 [copper] = imported_body(C:\Users\karlr\Documents\core_assembled_flatwise_12turns.step)
  Np6_Section1 = Np6.section(plane=ZX)
  Np7 [copper] = imported_body(C:\Users\karlr\Documents\core_assembled_flatwise_12turns.step)
  Np7_Section1 = Np7.section(plane=ZX)
  Np8 [copper] = imported_body(C:\Users\karlr\Documents\core_assembled_flatwise_12turns.step)
  Np8_Section1 = Np8.section(plane=ZX)
  Np9 [copper] = imported_body(C:\Users\karlr\Documents\core_assembled_flatwise_12turns.step)
  Np9_Section1 = Np9.section(plane=ZX)
  Ns1 [copper] = imported_body(C:\Users\karlr\Documents\core_assembled_flatwise_12turns.step)
  Ns1_Section1 = Ns1.section(plane=ZX)
  Ns10 [copper] = imported_body(C:\Users\karlr\Documents\core_assembled_flatwise_12turns.step)
  Ns10_Section1 = Ns10.section(plane=ZX)
  Ns11 [copper] = imported_body(C:\Users\karlr\Documents\core_assembled_flatwise_12turns.step)
  Ns11_Section1 = Ns11.section(plane=ZX)
  Ns12 [copper] = imported_body(C:\Users\karlr\Documents\core_assembled_flatwise_12turns.step)
  Ns12_Section1 = Ns12.section(plane=ZX)
  Ns2 [copper] = imported_body(C:\Users\karlr\Documents\core_assembled_flatwise_12turns.step)
  Ns2_Section1 = Ns2.section(plane=ZX)
  Ns3 [copper] = imported_body(C:\Users\karlr\Documents\core_assembled_flatwise_12turns.step)
  Ns3_Section1 = Ns3.section(plane=ZX)
  Ns4 [copper] = imported_body(C:\Users\karlr\Documents\core_assembled_flatwise_12turns.step)
  Ns4_Section1 = Ns4.section(plane=ZX)
  Ns5 [copper] = imported_body(C:\Users\karlr\Documents\core_assembled_flatwise_12turns.step)
  Ns5_Section1 = Ns5.section(plane=ZX)
  Ns6 [copper] = imported_body(C:\Users\karlr\Documents\core_assembled_flatwise_12turns.step)
  Ns6_Section1 = Ns6.section(plane=ZX)
  Ns7 [copper] = imported_body(C:\Users\karlr\Documents\core_assembled_flatwise_12turns.step)
  Ns7_Section1 = Ns7.section(plane=ZX)
  Ns8 [copper] = imported_body(C:\Users\karlr\Documents\core_assembled_flatwise_12turns.step)
  Ns8_Section1 = Ns8.section(plane=ZX)
  Ns9 [copper] = imported_body(C:\Users\karlr\Documents\core_assembled_flatwise_12turns.step)
  Ns9_Section1 = Ns9.section(plane=ZX)
  plate_1, plate_2 [Al_N] = imported_body(C:\Users\karlr\Documents\core_assembled_flatwise_12turns.step)
  Body1 [ferrite - Copy] = imported_body(C:\Users\karlr\Documents\core_assembled_flatwise_12turns.step)
  Body1_1, Body1_2 [aluminum] = imported_body(C:\Users\karlr\Documents\core_assembled_flatwise_12turns.step)
  Body1_3 [ferrite - Copy] = imported_body(C:\Users\karlr\Documents\core_assembled_flatwise_12turns.step)
  Body1_4, Body1_5 [aluminum] = imported_body(C:\Users\karlr\Documents\core_assembled_flatwise_12turns.step)
  Np1_Section1.separate_bodies()
  Np2_Section1.separate_bodies()
  Np3_Section1.separate_bodies()
  Np4_Section1.separate_bodies()
  Np5_Section1.separate_bodies()
  Np6_Section1.separate_bodies()
  Np7_Section1.separate_bodies()
  Np8_Section1.separate_bodies()
  Np9_Section1.separate_bodies()
  Np10_Section1.separate_bodies()
  Np11_Section1.separate_bodies()
  Np12_Section1.separate_bodies()
  Ns1_Section1.separate_bodies()
  Ns2_Section1.separate_bodies()
  Ns3_Section1.separate_bodies()
  Ns4_Section1.separate_bodies()
  Ns5_Section1.separate_bodies()
  Ns6_Section1.separate_bodies()
  Ns7_Section1.separate_bodies()
  Ns8_Section1.separate_bodies()
  Ns9_Section1.separate_bodies()
  Ns10_Section1.separate_bodies()
  Ns11_Section1.separate_bodies()
  Ns12_Section1_Separate1 = Ns12_Section1.separate_bodies()
  Ns12_Section1.delete()
  group core_assembled_flatwise = Np1, Np10, Np11, Np12, Np2..Np9, Ns1, Ns10, Ns11, Ns12, Ns2..Ns9, plate_1, plate_2, Np1_Section1, Np2_Section1, Np3_Section1, Np4_Section1, Np5_Section1, Np6_Section1, Np7_Section1, Np8_Section1, Np9_Section1, Np10_Section1, Np11_Section1, Np12_Section1, Ns1_Section1, Ns2_Section1, Ns3_Section1, Ns4_Section1, Ns5_Section1, Ns6_Section1, Ns7_Section1, Ns8_Section1, Ns9_Section1, Ns10_Section1, Ns11_Section1, Ns12_Section1_Separate1
  group core_together_1 = Body1, Body1_1, Body1_2
  group core_together = Body1_3, Body1_4, Body1_5
boundaries and excitations:
  Voltage3: Voltage Objects=[Body1, Body1_1..Body1_5, plate_1, plate_2] Voltage=0mV
  Primary: Voltage Objects=[Np1..Np6, Ns1..Ns6] Voltage=1V
  Secondary: Voltage Objects=[Np7..Np12, Ns7..Ns12] Voltage=0mV
parameters:
  Matrix1: Matrix Primary, Secondary, Voltage3: NumberOfTurns=1
mesh:
  initial mesh: GlobalSurfApproximation{CurvedSurfaceApproxChoice=UseSlider SliderMeshSettings=9} GlobalCurvilinear{Apply} MeshMethod=AnsoftClassic
setups:
  Setup1: Electrostatic MaximumPasses=20 MinimumPasses=2 MinimumConvergedPasses=1 PercentRefinement=30 PercentError=2.5 NonLinearResidual=0.001

design 12turns_3D_PSSP_parasitics_Np1Ns0_GNDBoth (Maxwell 3D, Electrostatic, model units mm)
geometry:
  Region [vacuum] = region(percentage_offset=0 on all sides)
  Np1 [copper] = imported_body(C:\Users\karlr\Documents\core_assembled_flatwise_12turns.step)
  Np1_Section1 = Np1.section(plane=ZX)
  Np10 [copper] = imported_body(C:\Users\karlr\Documents\core_assembled_flatwise_12turns.step)
  Np10_Section1 = Np10.section(plane=ZX)
  Np11 [copper] = imported_body(C:\Users\karlr\Documents\core_assembled_flatwise_12turns.step)
  Np11_Section1 = Np11.section(plane=ZX)
  Np12 [copper] = imported_body(C:\Users\karlr\Documents\core_assembled_flatwise_12turns.step)
  Np12_Section1 = Np12.section(plane=ZX)
  Np2 [copper] = imported_body(C:\Users\karlr\Documents\core_assembled_flatwise_12turns.step)
  Np2_Section1 = Np2.section(plane=ZX)
  Np3 [copper] = imported_body(C:\Users\karlr\Documents\core_assembled_flatwise_12turns.step)
  Np3_Section1 = Np3.section(plane=ZX)
  Np4 [copper] = imported_body(C:\Users\karlr\Documents\core_assembled_flatwise_12turns.step)
  Np4_Section1 = Np4.section(plane=ZX)
  Np5 [copper] = imported_body(C:\Users\karlr\Documents\core_assembled_flatwise_12turns.step)
  Np5_Section1 = Np5.section(plane=ZX)
  Np6 [copper] = imported_body(C:\Users\karlr\Documents\core_assembled_flatwise_12turns.step)
  Np6_Section1 = Np6.section(plane=ZX)
  Np7 [copper] = imported_body(C:\Users\karlr\Documents\core_assembled_flatwise_12turns.step)
  Np7_Section1 = Np7.section(plane=ZX)
  Np8 [copper] = imported_body(C:\Users\karlr\Documents\core_assembled_flatwise_12turns.step)
  Np8_Section1 = Np8.section(plane=ZX)
  Np9 [copper] = imported_body(C:\Users\karlr\Documents\core_assembled_flatwise_12turns.step)
  Np9_Section1 = Np9.section(plane=ZX)
  Ns1 [copper] = imported_body(C:\Users\karlr\Documents\core_assembled_flatwise_12turns.step)
  Ns1_Section1 = Ns1.section(plane=ZX)
  Ns10 [copper] = imported_body(C:\Users\karlr\Documents\core_assembled_flatwise_12turns.step)
  Ns10_Section1 = Ns10.section(plane=ZX)
  Ns11 [copper] = imported_body(C:\Users\karlr\Documents\core_assembled_flatwise_12turns.step)
  Ns11_Section1 = Ns11.section(plane=ZX)
  Ns12 [copper] = imported_body(C:\Users\karlr\Documents\core_assembled_flatwise_12turns.step)
  Ns12_Section1 = Ns12.section(plane=ZX)
  Ns2 [copper] = imported_body(C:\Users\karlr\Documents\core_assembled_flatwise_12turns.step)
  Ns2_Section1 = Ns2.section(plane=ZX)
  Ns3 [copper] = imported_body(C:\Users\karlr\Documents\core_assembled_flatwise_12turns.step)
  Ns3_Section1 = Ns3.section(plane=ZX)
  Ns4 [copper] = imported_body(C:\Users\karlr\Documents\core_assembled_flatwise_12turns.step)
  Ns4_Section1 = Ns4.section(plane=ZX)
  Ns5 [copper] = imported_body(C:\Users\karlr\Documents\core_assembled_flatwise_12turns.step)
  Ns5_Section1 = Ns5.section(plane=ZX)
  Ns6 [copper] = imported_body(C:\Users\karlr\Documents\core_assembled_flatwise_12turns.step)
  Ns6_Section1 = Ns6.section(plane=ZX)
  Ns7 [copper] = imported_body(C:\Users\karlr\Documents\core_assembled_flatwise_12turns.step)
  Ns7_Section1 = Ns7.section(plane=ZX)
  Ns8 [copper] = imported_body(C:\Users\karlr\Documents\core_assembled_flatwise_12turns.step)
  Ns8_Section1 = Ns8.section(plane=ZX)
  Ns9 [copper] = imported_body(C:\Users\karlr\Documents\core_assembled_flatwise_12turns.step)
  Ns9_Section1 = Ns9.section(plane=ZX)
  plate_1, plate_2 [Al_N] = imported_body(C:\Users\karlr\Documents\core_assembled_flatwise_12turns.step)
  Body1 [ferrite - Copy] = imported_body(C:\Users\karlr\Documents\core_assembled_flatwise_12turns.step)
  Body1_1, Body1_2 [aluminum] = imported_body(C:\Users\karlr\Documents\core_assembled_flatwise_12turns.step)
  Body1_3 [ferrite - Copy] = imported_body(C:\Users\karlr\Documents\core_assembled_flatwise_12turns.step)
  Body1_4, Body1_5 [aluminum] = imported_body(C:\Users\karlr\Documents\core_assembled_flatwise_12turns.step)
  Np1_Section1.separate_bodies()
  Np2_Section1.separate_bodies()
  Np3_Section1.separate_bodies()
  Np4_Section1.separate_bodies()
  Np5_Section1.separate_bodies()
  Np6_Section1.separate_bodies()
  Np7_Section1.separate_bodies()
  Np8_Section1.separate_bodies()
  Np9_Section1.separate_bodies()
  Np10_Section1.separate_bodies()
  Np11_Section1.separate_bodies()
  Np12_Section1.separate_bodies()
  Ns1_Section1.separate_bodies()
  Ns2_Section1.separate_bodies()
  Ns3_Section1.separate_bodies()
  Ns4_Section1.separate_bodies()
  Ns5_Section1.separate_bodies()
  Ns6_Section1.separate_bodies()
  Ns7_Section1.separate_bodies()
  Ns8_Section1.separate_bodies()
  Ns9_Section1.separate_bodies()
  Ns10_Section1.separate_bodies()
  Ns11_Section1.separate_bodies()
  Ns12_Section1_Separate1 = Ns12_Section1.separate_bodies()
  Ns12_Section1.delete()
  group core_assembled_flatwise = Np1, Np10, Np11, Np12, Np2..Np9, Ns1, Ns10, Ns11, Ns12, Ns2..Ns9, plate_1, plate_2, Np1_Section1, Np2_Section1, Np3_Section1, Np4_Section1, Np5_Section1, Np6_Section1, Np7_Section1, Np8_Section1, Np9_Section1, Np10_Section1, Np11_Section1, Np12_Section1, Ns1_Section1, Ns2_Section1, Ns3_Section1, Ns4_Section1, Ns5_Section1, Ns6_Section1, Ns7_Section1, Ns8_Section1, Ns9_Section1, Ns10_Section1, Ns11_Section1, Ns12_Section1_Separate1
  group core_together_1 = Body1, Body1_1, Body1_2
  group core_together = Body1_3, Body1_4, Body1_5
boundaries and excitations:
  Voltage3: Voltage Objects=[Body1, Body1_1..Body1_5, plate_1, plate_2] Voltage=0mV
  Primary: Voltage Objects=[Np1, Np3, Np5, Np7, Np9, Np11, Ns2, Ns4, Ns6, Ns8, Ns10, Ns12] Voltage=1V
  Secondary: Voltage Objects=[Np2, Np4, Np6, Np8, Np10, Np12, Ns1, Ns3, Ns5, Ns7, Ns9, Ns11] Voltage=0mV
parameters:
  Matrix1: Matrix Primary, Secondary, Voltage3: NumberOfTurns=1
mesh:
  Length1: LengthBased Objects=[plate_2, Np1..Np12, Ns1..Ns12, plate_1] MaxLength=2mm
  Length2: LengthBased Objects=[Body1_1, Body1_2, Body1, Body1_3, Body1_4, Body1_5] MaxLength=5mm
  initial mesh: GlobalSurfApproximation{CurvedSurfaceApproxChoice=UseSlider SliderMeshSettings=9} GlobalCurvilinear{Apply} MeshMethod=AnsoftClassic
setups:
  Setup1: Electrostatic MaximumPasses=20 MinimumPasses=2 MinimumConvergedPasses=1 PercentRefinement=30 PercentError=1 NonLinearResidual=0.001

design 12turns_3D_FullInterleaved_parasitics_Np1Ns0_GNDBoth1 (Maxwell 3D, Electrostatic, model units mm)
geometry:
  Np1, Np10, Np11, Np12, Np2..Np9, Ns1, Ns10, Ns11, Ns12, Ns2..Ns9 [copper] = imported_body(C:\Users\karlr\Documents\core_assembled_flatwise_12turns.step)
  Body1 [ferrite - Copy] = imported_body(C:\Users\karlr\Documents\core_assembled_flatwise_12turns.step)
  Body1_1, Body1_2 [aluminum] = imported_body(C:\Users\karlr\Documents\core_assembled_flatwise_12turns.step)
  Body1_3 [ferrite - Copy] = imported_body(C:\Users\karlr\Documents\core_assembled_flatwise_12turns.step)
  Body1_4, Body1_5 [aluminum] = imported_body(C:\Users\karlr\Documents\core_assembled_flatwise_12turns.step)
  Np1_Section1 [copper] = Np1.section(plane=ZX)
  Np2_Section1 [copper] = Np2.section(plane=ZX)
  Np3_Section1 [copper] = Np3.section(plane=ZX)
  Np4_Section1 [copper] = Np4.section(plane=ZX)
  Np5_Section1 [copper] = Np5.section(plane=ZX)
  Np6_Section1 [copper] = Np6.section(plane=ZX)
  Np7_Section1 [copper] = Np7.section(plane=ZX)
  Np8_Section1 [copper] = Np8.section(plane=ZX)
  Np9_Section1 [copper] = Np9.section(plane=ZX)
  Np10_Section1 [copper] = Np10.section(plane=ZX)
  Np11_Section1 [copper] = Np11.section(plane=ZX)
  Np12_Section1 [copper] = Np12.section(plane=ZX)
  Ns1_Section1 [copper] = Ns1.section(plane=ZX)
  Ns2_Section1 [copper] = Ns2.section(plane=ZX)
  Ns3_Section1 [copper] = Ns3.section(plane=ZX)
  Ns4_Section1 [copper] = Ns4.section(plane=ZX)
  Ns5_Section1 [copper] = Ns5.section(plane=ZX)
  Ns6_Section1 [copper] = Ns6.section(plane=ZX)
  Ns7_Section1 [copper] = Ns7.section(plane=ZX)
  Ns8_Section1 [copper] = Ns8.section(plane=ZX)
  Ns9_Section1 [copper] = Ns9.section(plane=ZX)
  Ns10_Section1 [copper] = Ns10.section(plane=ZX)
  Ns11_Section1 [copper] = Ns11.section(plane=ZX)
  Ns12_Section1 = Ns12.section(plane=ZX)
  Np1_Section1.separate_bodies()
  Np2_Section1.separate_bodies()
  Np3_Section1.separate_bodies()
  Np4_Section1.separate_bodies()
  Np5_Section1.separate_bodies()
  Np6_Section1.separate_bodies()
  Np7_Section1.separate_bodies()
  Np8_Section1.separate_bodies()
  Np9_Section1.separate_bodies()
  Np10_Section1.separate_bodies()
  Np11_Section1.separate_bodies()
  Np12_Section1.separate_bodies()
  Ns1_Section1.separate_bodies()
  Ns2_Section1.separate_bodies()
  Ns3_Section1.separate_bodies()
  Ns4_Section1.separate_bodies()
  Ns5_Section1.separate_bodies()
  Ns6_Section1.separate_bodies()
  Ns7_Section1.separate_bodies()
  Ns8_Section1.separate_bodies()
  Ns9_Section1.separate_bodies()
  Ns10_Section1.separate_bodies()
  Ns11_Section1.separate_bodies()
  Ns12_Section1_Separate1 [copper] = Ns12_Section1.separate_bodies()
  Ns12_Section1.delete()
  Region [vacuum] = region(percentage_offset=0 on all sides)
  Rectangle1 [non-model] = rectangle(corner=(45.8mm, 22.75mm, 0mm), z_size=20mm, x_size=-45.8mm)
  group core_assembled_flatwise = Np1, Np10, Np11, Np12, Np2..Np9, Ns1, Ns10, Ns11, Ns12, Ns2..Ns9, Np1_Section1, Np2_Section1, Np3_Section1, Np4_Section1, Np5_Section1, Np6_Section1, Np7_Section1, Np8_Section1, Np9_Section1, Np10_Section1, Np11_Section1, Np12_Section1, Ns1_Section1, Ns2_Section1, Ns3_Section1, Ns4_Section1, Ns5_Section1, Ns6_Section1, Ns7_Section1, Ns8_Section1, Ns9_Section1, Ns10_Section1, Ns11_Section1, Ns12_Section1_Separate1
  group core_together_1 = Body1, Body1_1, Body1_2
  group core_together = Body1_3, Body1_4, Body1_5
boundaries and excitations:
  Voltage1: Voltage Objects=[Np1..Np12] Voltage=1V
  Voltage2: Voltage Objects=[Ns1..Ns12] Voltage=1V
  Voltage3: Voltage Objects=[Body1_4, Body1_5, Body1_3, Body1_1, Body1_2, Body1] Voltage=0mV
parameters:
  Matrix1: Matrix Voltage1, Voltage2, Voltage3: NumberOfTurns=1
mesh:
  initial mesh: GlobalSurfApproximation{CurvedSurfaceApproxChoice=UseSlider SliderMeshSettings=9} GlobalCurvilinear{Apply} MeshMethod=AnsoftClassic
setups:
  Setup1: Electrostatic MaximumPasses=20 MinimumPasses=2 MinimumConvergedPasses=1 PercentRefinement=30 PercentError=1 NonLinearResidual=0.001

design 12turns_3D_FullInterleaved_parasitics_Np1Ns0_GND_Efield (Maxwell 3D, Electrostatic, model units mm)
geometry:
  Region [vacuum] = region(percentage_offset=0 on all sides)
  Np1 [copper] = imported_body(C:\Users\karlr\Documents\core_assembled_flatwise_12turns.step)
  Np1_Section1 = Np1.section(plane=ZX)
  Np10 [copper] = imported_body(C:\Users\karlr\Documents\core_assembled_flatwise_12turns.step)
  Np10_Section1 = Np10.section(plane=ZX)
  Np11 [copper] = imported_body(C:\Users\karlr\Documents\core_assembled_flatwise_12turns.step)
  Np11_Section1 = Np11.section(plane=ZX)
  Np12 [copper] = imported_body(C:\Users\karlr\Documents\core_assembled_flatwise_12turns.step)
  Np12_Section1 = Np12.section(plane=ZX)
  Np2 [copper] = imported_body(C:\Users\karlr\Documents\core_assembled_flatwise_12turns.step)
  Np2_Section1 = Np2.section(plane=ZX)
  Np3 [copper] = imported_body(C:\Users\karlr\Documents\core_assembled_flatwise_12turns.step)
  Np3_Section1 = Np3.section(plane=ZX)
  Np4 [copper] = imported_body(C:\Users\karlr\Documents\core_assembled_flatwise_12turns.step)
  Np4_Section1 = Np4.section(plane=ZX)
  Np5 [copper] = imported_body(C:\Users\karlr\Documents\core_assembled_flatwise_12turns.step)
  Np5_Section1 = Np5.section(plane=ZX)
  Np6 [copper] = imported_body(C:\Users\karlr\Documents\core_assembled_flatwise_12turns.step)
  Np6_Section1 = Np6.section(plane=ZX)
  Np7 [copper] = imported_body(C:\Users\karlr\Documents\core_assembled_flatwise_12turns.step)
  Np7_Section1 = Np7.section(plane=ZX)
  Np8 [copper] = imported_body(C:\Users\karlr\Documents\core_assembled_flatwise_12turns.step)
  Np8_Section1 = Np8.section(plane=ZX)
  Np9 [copper] = imported_body(C:\Users\karlr\Documents\core_assembled_flatwise_12turns.step)
  Np9_Section1 = Np9.section(plane=ZX)
  Ns1 [copper] = imported_body(C:\Users\karlr\Documents\core_assembled_flatwise_12turns.step)
  Ns1_Section1 = Ns1.section(plane=ZX)
  Ns10 [copper] = imported_body(C:\Users\karlr\Documents\core_assembled_flatwise_12turns.step)
  Ns10_Section1 = Ns10.section(plane=ZX)
  Ns11 [copper] = imported_body(C:\Users\karlr\Documents\core_assembled_flatwise_12turns.step)
  Ns11_Section1 = Ns11.section(plane=ZX)
  Ns12 [copper] = imported_body(C:\Users\karlr\Documents\core_assembled_flatwise_12turns.step)
  Ns12_Section1 = Ns12.section(plane=ZX)
  Ns2 [copper] = imported_body(C:\Users\karlr\Documents\core_assembled_flatwise_12turns.step)
  Ns2_Section1 = Ns2.section(plane=ZX)
  Ns3 [copper] = imported_body(C:\Users\karlr\Documents\core_assembled_flatwise_12turns.step)
  Ns3_Section1 = Ns3.section(plane=ZX)
  Ns4 [copper] = imported_body(C:\Users\karlr\Documents\core_assembled_flatwise_12turns.step)
  Ns4_Section1 = Ns4.section(plane=ZX)
  Ns5 [copper] = imported_body(C:\Users\karlr\Documents\core_assembled_flatwise_12turns.step)
  Ns5_Section1 = Ns5.section(plane=ZX)
  Ns6 [copper] = imported_body(C:\Users\karlr\Documents\core_assembled_flatwise_12turns.step)
  Ns6_Section1 = Ns6.section(plane=ZX)
  Ns7 [copper] = imported_body(C:\Users\karlr\Documents\core_assembled_flatwise_12turns.step)
  Ns7_Section1 = Ns7.section(plane=ZX)
  Ns8 [copper] = imported_body(C:\Users\karlr\Documents\core_assembled_flatwise_12turns.step)
  Ns8_Section1 = Ns8.section(plane=ZX)
  Ns9 [copper] = imported_body(C:\Users\karlr\Documents\core_assembled_flatwise_12turns.step)
  Ns9_Section1 = Ns9.section(plane=ZX)
  plate_1, plate_2 [Al_N] = imported_body(C:\Users\karlr\Documents\core_assembled_flatwise_12turns.step)
  Body1 [ferrite - Copy] = imported_body(C:\Users\karlr\Documents\core_assembled_flatwise_12turns.step)
  Body1_1, Body1_2 [aluminum] = imported_body(C:\Users\karlr\Documents\core_assembled_flatwise_12turns.step)
  Body1_3 [ferrite - Copy] = imported_body(C:\Users\karlr\Documents\core_assembled_flatwise_12turns.step)
  Body1_4, Body1_5 [aluminum] = imported_body(C:\Users\karlr\Documents\core_assembled_flatwise_12turns.step)
  Np1_Section1.separate_bodies()
  Np2_Section1.separate_bodies()
  Np3_Section1.separate_bodies()
  Np4_Section1.separate_bodies()
  Np5_Section1.separate_bodies()
  Np6_Section1.separate_bodies()
  Np7_Section1.separate_bodies()
  Np8_Section1.separate_bodies()
  Np9_Section1.separate_bodies()
  Np10_Section1.separate_bodies()
  Np11_Section1.separate_bodies()
  Np12_Section1.separate_bodies()
  Ns1_Section1.separate_bodies()
  Ns2_Section1.separate_bodies()
  Ns3_Section1.separate_bodies()
  Ns4_Section1.separate_bodies()
  Ns5_Section1.separate_bodies()
  Ns6_Section1.separate_bodies()
  Ns7_Section1.separate_bodies()
  Ns8_Section1.separate_bodies()
  Ns9_Section1.separate_bodies()
  Ns10_Section1.separate_bodies()
  Ns11_Section1.separate_bodies()
  Ns12_Section1_Separate1 = Ns12_Section1.separate_bodies()
  Ns12_Section1.delete()
  group core_assembled_flatwise = Np1, Np10, Np11, Np12, Np2..Np9, Ns1, Ns10, Ns11, Ns12, Ns2..Ns9, plate_1, plate_2, Np1_Section1, Np2_Section1, Np3_Section1, Np4_Section1, Np5_Section1, Np6_Section1, Np7_Section1, Np8_Section1, Np9_Section1, Np10_Section1, Np11_Section1, Np12_Section1, Ns1_Section1, Ns2_Section1, Ns3_Section1, Ns4_Section1, Ns5_Section1, Ns6_Section1, Ns7_Section1, Ns8_Section1, Ns9_Section1, Ns10_Section1, Ns11_Section1, Ns12_Section1_Separate1
  group core_together_1 = Body1, Body1_1, Body1_2
  group core_together = Body1_3, Body1_4, Body1_5
boundaries and excitations:
  Voltage3: Voltage Objects=[Body1, Body1_1..Body1_5, plate_1, plate_2] Voltage=0mV
parameters:
  Matrix1: Matrix Voltage3: NumberOfTurns=1
mesh:
  Length1: LengthBased Objects=[plate_2, Np1..Np12, Ns1..Ns12, plate_1] MaxLength=2mm
  Length2: LengthBased Objects=[Body1_1, Body1_2, Body1, Body1_3, Body1_4, Body1_5] MaxLength=5mm
  initial mesh: GlobalSurfApproximation{CurvedSurfaceApproxChoice=UseSlider SliderMeshSettings=9} GlobalCurvilinear{Apply} MeshMethod=AnsoftClassic
setups:
  Setup1: Electrostatic MaximumPasses=20 MinimumPasses=2 MinimumConvergedPasses=1 PercentRefinement=30 PercentError=1 NonLinearResidual=0.001

design 10turns_3D_FullInterleaved_parasitics_Np1Ns0_GNDBoth (Maxwell 3D, Electrostatic, model units mm)
geometry:
  Region [vacuum] = region(percentage_offset=0 on all sides)
  Np1, Np10, Np2..Np9, Ns1, Ns10, Ns2..Ns9 [copper] = imported_body(C:\Users\karlr\Documents\flatwise_corrected.step)
  plate_1, plate_2 [silicon - Copy] = imported_body(C:\Users\karlr\Documents\flatwise_corrected.step)
  Body1 [ferrite - Copy] = imported_body(C:\Users\karlr\Documents\flatwise_corrected.step)
  Body1_1, Body1_2 [aluminum] = imported_body(C:\Users\karlr\Documents\flatwise_corrected.step)
  Body1_3 [ferrite - Copy] = imported_body(C:\Users\karlr\Documents\flatwise_corrected.step)
  Body1_4, Body1_5 [aluminum] = imported_body(C:\Users\karlr\Documents\flatwise_corrected.step)
  group core_assembled_flatwise = Np1, Np10, Np2..Np9, Ns1, Ns10, Ns2..Ns9, plate_1, plate_2
  group core_together_1 = Body1, Body1_1, Body1_2
  group core_together = Body1_3, Body1_4, Body1_5
boundaries and excitations:
  Voltage3: Voltage Objects=[Body1, Body1_1..Body1_5, plate_1, plate_2] Voltage=0mV
  Np: Voltage Objects=[Np1..Np10] Voltage=1V
  Ns: Voltage Objects=[Ns1..Ns10] Voltage=0mV
parameters:
  Matrix1: Matrix Np, Ns, Voltage3: NumberOfTurns=1
mesh:
  Length1: LengthBased Objects=[Np1..Np10, Ns1..Ns10, plate_1, plate_2] MaxLength=1.5mm
  Length2: LengthBased Objects=[Body1_4, Body1_5, Body1_3, Body1_1, Body1_2, Body1] MaxLength=4.5mm
  initial mesh: GlobalSurfApproximation{CurvedSurfaceApproxChoice=UseSlider SliderMeshSettings=9} GlobalCurvilinear{Apply} MeshMethod=AnsoftClassic
setups:
  Setup1: Electrostatic MaximumPasses=20 MinimumPasses=2 MinimumConvergedPasses=1 PercentRefinement=30 PercentError=2.5 NonLinearResidual=0.001

design 10turns_3D_PSSP_parasitics_Np1Ns0_GNDBoth (Maxwell 3D, Electrostatic, model units mm)
geometry:
  Region [vacuum] = region(percentage_offset=0 on all sides)
  Np1, Np10, Np2..Np9, Ns1, Ns10, Ns2..Ns9 [copper] = imported_body(C:\Users\karlr\Documents\flatwise_corrected.step)
  plate_1, plate_2 [silicon - Copy] = imported_body(C:\Users\karlr\Documents\flatwise_corrected.step)
  Body1 [ferrite - Copy] = imported_body(C:\Users\karlr\Documents\flatwise_corrected.step)
  Body1_1, Body1_2 [aluminum] = imported_body(C:\Users\karlr\Documents\flatwise_corrected.step)
  Body1_3 [ferrite - Copy] = imported_body(C:\Users\karlr\Documents\flatwise_corrected.step)
  Body1_4, Body1_5 [aluminum] = imported_body(C:\Users\karlr\Documents\flatwise_corrected.step)
  group core_assembled_flatwise = Np1, Np10, Np2..Np9, Ns1, Ns10, Ns2..Ns9, plate_1, plate_2
  group core_together_1 = Body1, Body1_1, Body1_2
  group core_together = Body1_3, Body1_4, Body1_5
boundaries and excitations:
  Voltage3: Voltage Objects=[Body1, Body1_1..Body1_5, plate_1, plate_2] Voltage=0mV
  Np: Voltage Objects=[Np1, Np3, Np5, Np7, Np9, Ns2, Ns4, Ns6, Ns8, Ns10] Voltage=1V
  Ns: Voltage Objects=[Np2, Np4, Np6, Np8, Np10, Ns1, Ns3, Ns5, Ns7, Ns9] Voltage=0mV
parameters:
  Matrix1: Matrix Voltage3, Np, Ns: NumberOfTurns=1
mesh:
  Length1: LengthBased disabled Objects=[Np1..Np10, Ns1..Ns10, plate_1, plate_2] MaxLength=1.5mm
  Length2: LengthBased disabled Objects=[Body1_4, Body1_5, Body1_3, Body1_1, Body1_2, Body1] MaxLength=4.5mm
  initial mesh: GlobalSurfApproximation{CurvedSurfaceApproxChoice=UseSlider SliderMeshSettings=9} GlobalCurvilinear{Apply} MeshMethod=AnsoftClassic
setups:
  Setup1: Electrostatic MaximumPasses=20 MinimumPasses=2 MinimumConvergedPasses=1 PercentRefinement=30 PercentError=2.5 NonLinearResidual=0.001

design 10turns_3D_NoInterleave_parasitics_Np1Ns0_GNDBoth (Maxwell 3D, Electrostatic, model units mm)
geometry:
  Region [vacuum] = region(percentage_offset=0 on all sides)
  Np1, Np10, Np2..Np9, Ns1, Ns10, Ns2..Ns9 [copper] = imported_body(C:\Users\karlr\Documents\flatwise_corrected.step)
  plate_1, plate_2 [silicon - Copy] = imported_body(C:\Users\karlr\Documents\flatwise_corrected.step)
  Body1 [ferrite - Copy] = imported_body(C:\Users\karlr\Documents\flatwise_corrected.step)
  Body1_1, Body1_2 [aluminum] = imported_body(C:\Users\karlr\Documents\flatwise_corrected.step)
  Body1_3 [ferrite - Copy] = imported_body(C:\Users\karlr\Documents\flatwise_corrected.step)
  Body1_4, Body1_5 [aluminum] = imported_body(C:\Users\karlr\Documents\flatwise_corrected.step)
  group core_assembled_flatwise = Np1, Np10, Np2..Np9, Ns1, Ns10, Ns2..Ns9, plate_1, plate_2
  group core_together_1 = Body1, Body1_1, Body1_2
  group core_together = Body1_3, Body1_4, Body1_5
boundaries and excitations:
  Voltage3: Voltage Objects=[Body1, Body1_1..Body1_5, plate_1, plate_2] Voltage=0mV
  Np: Voltage Objects=[Np1..Np5, Ns1..Ns5] Voltage=1V
  Ns: Voltage Objects=[Np6..Np10, Ns6..Ns10] Voltage=0mV
parameters:
  Matrix1: Matrix Voltage3, Np, Ns: NumberOfTurns=1
mesh:
  Length1: LengthBased Objects=[Np1..Np10, Ns1..Ns10, plate_1, plate_2] MaxLength=1.5mm
  Length2: LengthBased Objects=[Body1_4, Body1_5, Body1_3, Body1_1, Body1_2, Body1] MaxLength=4.5mm
  initial mesh: GlobalSurfApproximation{CurvedSurfaceApproxChoice=UseSlider SliderMeshSettings=9} GlobalCurvilinear{Apply} MeshMethod=AnsoftClassic
setups:
  Setup1: Electrostatic MaximumPasses=20 MinimumPasses=2 MinimumConvergedPasses=1 PercentRefinement=30 PercentError=2.5 NonLinearResidual=0.001
