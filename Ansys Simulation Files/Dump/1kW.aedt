# Ansys Electronics Desktop project, version 2025.1
project datasets:
  $Xaxis_25kHz_Yaxis_Pcv: (50.633, 1) (59.0114, 1.50406) (69.1674, 2.34392) (79.2528, 3.65275) (88.772, 5.02746) (93.9521, 6.11121) (100, 7.16954) (109.499, 8.56175) (121.957, 11.5767) (138.164, 16.5092) (153.013, 23.1293) (173.347, 32.9841) (195.272, 44.5991) (213.82, 61.3838) (235.462, 78.6962) (259.294, 104.536) (280.722, 138.862) (295.422, 151.746)
  $Xaxis_100kHz_Yaxis_Pcv: (26.3744, 1.03613) (29.3752, 1.42608) (33.2788, 2.03369) (39.6755, 3.1693) (44.9479, 4.44016) (52.3856, 6.91954) (62.8101, 11.373) (75.3091, 20.068) (88.2699, 32.4039) (103.461, 49.6099) (118.547, 74.6161) (142.138, 118.363) (165.658, 191.122) (184.506, 245.025) (197.5, 325.48) (215.037, 409.937) (242.235, 554.291) (268.27, 762.898) (287.163, 911.04)
  $Xaxis_200kHz_Yaxis_Pcv: (15.3013, 1.07357) (19.6383, 2.03369) (26.0769, 4.28533) (30.5648, 7.42858) (39.6755, 14.0722) (48.1134, 22.7224) (59.347, 38.6962) (75.7374, 74.6161) (99.4345, 162.909) (110.748, 216.401) (130.546, 319.755) (147.894, 472.47) (164.721, 605.722) (183.462, 848.612) (194.168, 1013.4) (210.213, 1167.99) (235.462, 1607.55) (252.045, 2024.69) (274.425, 2333.54) (290.439, 2939.06)
  $Xaxis_500kHz_Yaxis_Pcv: (10.1716, 5.89811) (11.99, 8.71505) (14.9581, 13.5815) (17.0423, 18.6929) (20.2031, 30.1834) (23.5462, 38.6962) (26.6752, 55.1837) (30.9135, 72.0142) (35.6225, 99.1166) (40.1281, 129.346) (46.5037, 187.76) (51.5018, 236.481) (58.0159, 319.755) (67.616, 447.974) (76.1681, 574.318) (89.2769, 776.557) (101.141, 1068.81) (119.9, 1524.21) (142.138, 2292.49) (174.333, 3327.81) (199.753, 5186.04) (222.48, 6531.74) (249.202, 8373.92)
  $Temp_Mu_r: (-31.6889, 2723.71) (0.680437, 3065.95) (20.3645, 3379.68) (40.0486, 3778.97) (59.7327, 4178.25) (81.6039, 4520.5) (120.535, 4520.5) (141.531, 4534.76) (180.024, 4705.88) (212.831, 5090.91) (223.329, 4805.7) (226.391, 3992.87) (230.328, 2766.49) (236.015, 926.916) (239.951, 28.5205)
materials:
  vacuum: permittivity=1
  aluminum: permeability=1.000021 conductivity=38000000 thermal_conductivity=237.5 mass_density=2689 specific_heat=951 youngs_modulus=69000000000 poissons_ratio=0.31 thermal_expansion_coefficient=2.33e-05
  ferrite - Copy: core_loss_curve{25kHz (0, 0) (0.050633, 1) (0.0590114, 1.50406) (0.0691674, 2.34392) (0.0792528, 3.65275) (0.088772, 5.02746) (0.0939521, 6.11121) (0.1, 7.16954) (0.109499, 8.56175) (0.121957, 11.5767) (0.138164, 16.5092) (0.153013, 23.1293) (0.173347, 32.9841) (0.195272, 44.5991) (0.21382, 61.3838) (0.235462, 78.6962) (0.259294, 104.536) (0.280722, 138.862) (0.295422, 151.746)} core_loss_curve{100kHz (0, 0) (0.0263744, 1.03613) (0.0293752, 1.42608) (0.0332788, 2.03369) (0.0396755, 3.1693) (0.0449479, 4.44016) (0.0523856, 6.91954) (0.0628101, 11.373) (0.0753091, 20.068) (0.0882699, 32.4039) (0.103461, 49.6099) (0.118547, 74.6161) (0.142138, 118.363) (0.165658, 191.122) (0.184506, 245.025) (0.1975, 325.48) (0.215037, 409.937) (0.242235, 554.291) (0.26827, 762.898) (0.287163, 911.04)} core_loss_curve{200kHz (0, 0) (0.0153013, 1.07357) (0.0196383, 2.03369) (0.0260769, 4.28533) (0.0305648, 7.42858) (0.0396755, 14.0722) (0.0481134, 22.7224) (0.059347, 38.6962) (0.0757374, 74.6161) (0.0994345, 162.909) (0.110748, 216.401) (0.130546, 319.755) (0.147894, 472.47) (0.164721, 605.722) (0.183462, 848.612) (0.194168, 1013.4) (0.210213, 1167.99) (0.235462, 1607.55) (0.252045, 2024.69) (0.274425, 2333.54) (0.290439, 2939.06)} core_loss_curve{500kHz (0, 0) (0.0101716, 5.89811) (0.01199, 8.71505) (0.0149581, 13.5815) (0.0170423, 18.6929) (0.0202031, 30.1834) (0.0235462, 38.6962) (0.0266752, 55.1837) (0.0309135, 72.0142) (0.0356225, 99.1166) (0.0401281, 129.346) (0.0465037, 187.76) (0.0515018, 236.481) (0.0580159, 319.755) (0.067616, 447.974) (0.0761681, 574.318) (0.0892769, 776.557) (0.101141, 1068.81) (0.1199, 1524.21) (0.142138, 2292.49) (0.174333, 3327.81) (0.199753, 5186.04) (0.22248, 6531.74) (0.249202, 8373.92)} permittivity=12 permeability=3300 conductivity=0.25 thermal_conductivity=4 core_loss_type="Power Ferrite" core_loss_cm=0.062032234 core_loss_x=1.7066326 core_loss_y=2.5354555 mass_density=4800 specific_heat=750 youngs_modulus=119000000000 thermal_expansion_coefficient=1e-05 core_loss_equiv_cut_depth=0.001meter
  copper: permeability=0.999991 conductivity=58000000 thermal_conductivity=400 mass_density=8933 specific_heat=385 youngs_modulus=120000000000 poissons_ratio=0.38 thermal_expansion_coefficient=1.77e-05
  Al_N: permittivity=8.8 thermal_conductivity=120 mass_density=3250 specific_heat=734.3 youngs_modulus=305000000000 thermal_expansion_coefficient=5.2e-06
  Al-Extruded: thermal_conductivity=205 mass_density=2800 specific_heat=900 youngs_modulus=69000000000 poissons_ratio=0.33 thermal_expansion_coefficient=2.277e-06 thermal_material_type=Solid
  air: permittivity=1.0006 permeability=1.0000004 thermal_conductivity=0.0261 mass_density=1.1614 specific_heat=1005 thermal_expansion_coefficient=0.00333 thermal_material_type=Fluid diffusivity=2.88e-05 molecular_mass=0.028966 viscosity=1.84e-05 material_refractive_index=1.000293
  ferrite_tempdependent: core_loss_curve{25kHz (0, 0) (0.050633, 1) (0.0590114, 1.50406) (0.0691674, 2.34392) (0.0792528, 3.65275) (0.088772, 5.02746) (0.0939521, 6.11121) (0.1, 7.16954) (0.109499, 8.56175) (0.121957, 11.5767) (0.138164, 16.5092) (0.153013, 23.1293) (0.173347, 32.9841) (0.195272, 44.5991) (0.21382, 61.3838) (0.235462, 78.6962) (0.259294, 104.536) (0.280722, 138.862) (0.295422, 151.746)} core_loss_curve{100kHz (0, 0) (0.0263744, 1.03613) (0.0293752, 1.42608) (0.0332788, 2.03369) (0.0396755, 3.1693) (0.0449479, 4.44016) (0.0523856, 6.91954) (0.0628101, 11.373) (0.0753091, 20.068) (0.0882699, 32.4039) (0.103461, 49.6099) (0.118547, 74.6161) (0.142138, 118.363) (0.165658, 191.122) (0.184506, 245.025) (0.1975, 325.48) (0.215037, 409.937) (0.242235, 554.291) (0.26827, 762.898) (0.287163, 911.04)} core_loss_curve{200kHz (0, 0) (0.0153013, 1.07357) (0.0196383, 2.03369) (0.0260769, 4.28533) (0.0305648, 7.42858) (0.0396755, 14.0722) (0.0481134, 22.7224) (0.059347, 38.6962) (0.0757374, 74.6161) (0.0994345, 162.909) (0.110748, 216.401) (0.130546, 319.755) (0.147894, 472.47) (0.164721, 605.722) (0.183462, 848.612) (0.194168, 1013.4) (0.210213, 1167.99) (0.235462, 1607.55) (0.252045, 2024.69) (0.274425, 2333.54) (0.290439, 2939.06)} core_loss_curve{500kHz (0, 0) (0.0101716, 5.89811) (0.01199, 8.71505) (0.0149581, 13.5815) (0.0170423, 18.6929) (0.0202031, 30.1834) (0.0235462, 38.6962) (0.0266752, 55.1837) (0.0309135, 72.0142) (0.0356225, 99.1166) (0.0401281, 129.346) (0.0465037, 187.76) (0.0515018, 236.481) (0.0580159, 319.755) (0.067616, 447.974) (0.0761681, 574.318) (0.0892769, 776.557) (0.101141, 1068.81) (0.1199, 1524.21) (0.142138, 2292.49) (0.174333, 3327.81) (0.199753, 5186.04) (0.22248, 6531.74) (0.249202, 8373.92)} thermal_modifier{Property=permeability free_form_value=pwl($Temp_Mu_r,Temp)} permittivity=12 permeability=3300 conductivity=0.25 thermal_conductivity=4 core_loss_type="Power Ferrite" core_loss_cm=0.062032234 core_loss_x=1.7066326 core_loss_y=2.5354555 mass_density=4800 specific_heat=750 youngs_modulus=119000000000 thermal_expansion_coefficient=1e-05 core_loss_equiv_cut_depth=0.001meter
  copper - tempDependent: thermal_modifier{Property=conductivity free_form_value="if(Temp <=22, 1, 1/(1+0.0039*(Temp-22)))"} permeability=0.999991 conductivity=58000000 thermal_conductivity=400 mass_density=8933 specific_heat=385 youngs_modulus=120000000000 poissons_ratio=0.38 thermal_expansion_coefficient=1.77e-05
  ferrite: permittivity=12 permeability=1000 conductivity=0.01 thermal_conductivity=4 mass_density=4600 specific_heat=750 youngs_modulus=119000000000 thermal_expansion_coefficient=1e-05
  silicon: permittivity=11.9 thermal_conductivity=148 mass_density=2330 specific_heat=712 youngs_modulus=135000000000 poissons_ratio=0.25 thermal_expansion_coefficient=2.54e-06
  silicon - Copy: permittivity=9 thermal_conductivity=148 mass_density=3400 specific_heat=712 youngs_modulus=135000000000 poissons_ratio=0.25 thermal_expansion_coefficient=2.54e-06
  silicon - Copy (2): permittivity=9 thermal_conductivity=10 mass_density=3400 specific_heat=800 youngs_modulus=135000000000 poissons_ratio=0.25 thermal_expansion_coefficient=0.002
surface materials:
  Steel-oxidised-surface: surface_emissivity=0.8

design 12turns_3D_CoreLoss_FullInterleaved (Maxwell 3D, EddyCurrent, model units mm)
geometry:
  Region [vacuum] = region(percentage_offset=0 on all sides)
  Np1 [copper] = imported_body(C:\Users\karlr\Documents\core_assembled_flatwise_12turns.step)
  Np1_Section1 = Np1.section(plane=ZX)
  Np10 [copper] = imported_body(C:\Users\karlr\Documents\core_assembled_flatwise_12turns.step)
  Np10_Section1 = Np10.section(plane=ZX)
  Np11 [copper] = imported_body(C:\Users\karlr\Documents\core_assembled_flatwise_12turns.step)
  Np11_Section1 = Np11.section(plane=ZX)
  Np12 [copper] = imported_body(C:\Users\karlr\Documents\core_assembled_flatwise_12turns.step)
  Np12_Section1 = Np12.section(plane=ZX)
  Np2 [copper] = imported_body(C:\Users\karlr\Documents\core_assembled_flatwise_12turns.step)
  Np2_Section1 = Np2.section(plane=ZX)
  Np3 [copper] = imported_body(C:\Users\karlr\Documents\core_assembled_flatwise_12turns.step)
  Np3_Section1 = Np3.section(plane=ZX)
  Np4 [copper] = imported_body(C:\Users\karlr\Documents\core_assembled_flatwise_12turns.step)
  Np4_Section1 = Np4.section(plane=ZX)
  Np5 [copper] = imported_body(C:\Users\karlr\Documents\core_assembled_flatwise_12turns.step)
  Np5_Section1 = Np5.section(plane=ZX)
  Np6 [copper] = imported_body(C:\Users\karlr\Documents\core_assembled_flatwise_12turns.step)
  Np6_Section1 = Np6.section(plane=ZX)
  Np7 [copper] = imported_body(C:\Users\karlr\Documents\core_assembled_flatwise_12turns.step)
  Np7_Section1 = Np7.section(plane=ZX)
  Np8 [copper] = imported_body(C:\Users\karlr\Documents\core_assembled_flatwise_12turns.step)
  Np8_Section1 = Np8.section(plane=ZX)
  Np9 [copper] = imported_body(C:\Users\karlr\Documents\core_assembled_flatwise_12turns.step)
  Np9_Section1 = Np9.section(plane=ZX)
  Ns1 [copper] = imported_body(C:\Users\karlr\Documents\core_assembled_flatwise_12turns.step)
  Ns1_Section1 = Ns1.section(plane=ZX)
  Ns10 [copper] = imported_body(C:\Users\karlr\Documents\core_assembled_flatwise_12turns.step)
  Ns10_Section1 = Ns10.section(plane=ZX)
  Ns11 [copper] = imported_body(C:\Users\karlr\Documents\core_assembled_flatwise_12turns.step)
  Ns11_Section1 = Ns11.section(plane=ZX)
  Ns12 [copper] = imported_body(C:\Users\karlr\Documents\core_assembled_flatwise_12turns.step)
  Ns12_Section1 = Ns12.section(plane=ZX)
  Ns2 [copper] = imported_body(C:\Users\karlr\Documents\core_assembled_flatwise_12turns.step)
  Ns2_Section1 = Ns2.section(plane=ZX)
  Ns3 [copper] = imported_body(C:\Users\karlr\Documents\core_assembled_flatwise_12turns.step)
  Ns3_Section1 = Ns3.section(plane=ZX)
  Ns4 [copper] = imported_body(C:\Users\karlr\Documents\core_assembled_flatwise_12turns.step)
  Ns4_Section1 = Ns4.section(plane=ZX)
  Ns5 [copper] = imported_body(C:\Users\karlr\Documents\core_assembled_flatwise_12turns.step)
  Ns5_Section1 = Ns5.section(plane=ZX)
  Ns6 [copper] = imported_body(C:\Users\karlr\Documents\core_assembled_flatwise_12turns.step)
  Ns6_Section1 = Ns6.section(plane=ZX)
  Ns7 [copper] = imported_body(C:\Users\karlr\Documents\core_assembled_flatwise_12turns.step)
  Ns7_Section1 = Ns7.section(plane=ZX)
  Ns8 [copper] = imported_body(C:\Users\karlr\Documents\core_assembled_flatwise_12turns.step)
  Ns8_Section1 = Ns8.section(plane=ZX)
  Ns9 [copper] = imported_body(C:\Users\karlr\Documents\core_assembled_flatwise_12turns.step)
  Ns9_Section1 = Ns9.section(plane=ZX)
  plate_1, plate_2 [Al_N] = imported_body(C:\Users\karlr\Documents\core_assembled_flatwise_12turns.step)
  Body1 [ferrite - Copy] = imported_body(C:\Users\karlr\Documents\core_assembled_flatwise_12turns.step)
  Body1_1, Body1_2 [aluminum] = imported_body(C:\Users\karlr\Documents\core_assembled_flatwise_12turns.step)
  Body1_3 [ferrite - Copy] = imported_body(C:\Users\karlr\Documents\core_assembled_flatwise_12turns.step)
  Body1_4, Body1_5 [aluminum] = imported_body(C:\Users\karlr\Documents\core_assembled_flatwise_12turns.step)
  Np1_Section1.separate_bodies()
  Np2_Section1.separate_bodies()
  Np3_Section1.separate_bodies()
  Np4_Section1.separate_bodies()
  Np5_Section1.separate_bodies()
  Np6_Section1.separate_bodies()
  Np7_Section1.separate_bodies()
  Np8_Section1.separate_bodies()
  Np9_Section1.separate_bodies()
  Np10_Section1.separate_bodies()
  Np11_Section1.separate_bodies()
  Np12_Section1.separate_bodies()
  Ns1_Section1.separate_bodies()
  Ns2_Section1.separate_bodies()
  Ns3_Section1.separate_bodies()
  Ns4_Section1.separate_bodies()
  Ns5_Section1.separate_bodies()
  Ns6_Section1.separate_bodies()
  Ns7_Section1.separate_bodies()
  Ns8_Section1.separate_bodies()
  Ns9_Section1.separate_bodies()
  Ns10_Section1.separate_bodies()
  Ns11_Section1.separate_bodies()
  Ns12_Section1_Separate1 = Ns12_Section1.separate_bodies()
  Ns12_Section1.delete()
  group core_assembled_flatwise = Np1, Np10, Np11, Np12, Np2..Np9, Ns1, Ns10, Ns11, Ns12, Ns2..Ns9, plate_1, plate_2, Np1_Section1, Np2_Section1, Np3_Section1, Np4_Section1, Np5_Section1, Np6_Section1, Np7_Section1, Np8_Section1, Np9_Section1, Np10_Section1, Np11_Section1, Np12_Section1, Ns1_Section1, Ns2_Section1, Ns3_Section1, Ns4_Section1, Ns5_Section1, Ns6_Section1, Ns7_Section1, Ns8_Section1, Ns9_Section1, Ns10_Section1, Ns11_Section1, Ns12_Section1_Separate1
  group core_together_1 = Body1, Body1_1, Body1_2
  group core_together = Body1_3, Body1_4, Body1_5
boundaries and excitations:
  Np_1: Coil Terminal Objects=Np1_Section1 Conductor_number=1 Winding=Np Point_out_of_terminal=false
  Np_2: Coil Terminal Objects=Np2_Section1 Conductor_number=1 Winding=Np Point_out_of_terminal=false
  Np_3: Coil Terminal Objects=Np3_Section1 Conductor_number=1 Winding=Np Point_out_of_terminal=false
  Np_4: Coil Terminal Objects=Np4_Section1 Conductor_number=1 Winding=Np Point_out_of_terminal=false
  Np_5: Coil Terminal Objects=Np5_Section1 Conductor_number=1 Winding=Np Point_out_of_terminal=false
  Np_6: Coil Terminal Objects=Np6_Section1 Conductor_number=1 Winding=Np Point_out_of_terminal=false
  Np_7: Coil Terminal Objects=Np7_Section1 Conductor_number=1 Winding=Np Point_out_of_terminal=false
  Np_8: Coil Terminal Objects=Np8_Section1 Conductor_number=1 Winding=Np Point_out_of_terminal=false
  Np_9: Coil Terminal Objects=Np9_Section1 Conductor_number=1 Winding=Np Point_out_of_terminal=false
  Np_10: Coil Terminal Objects=Np10_Section1 Conductor_number=1 Winding=Np Point_out_of_terminal=false
  Np_11: Coil Terminal Objects=Np11_Section1 Conductor_number=1 Winding=Np Point_out_of_terminal=false
  Np_12: Coil Terminal Objects=Np12_Section1 Conductor_number=1 Winding=Np Point_out_of_terminal=false
  Ns_1: Coil Terminal Objects=Ns1_Section1 Conductor_number=1 Winding=Ns Point_out_of_terminal=true
  Ns_2: Coil Terminal Objects=Ns2_Section1 Conductor_number=1 Winding=Ns Point_out_of_terminal=true
  Ns_3: Coil Terminal Objects=Ns3_Section1 Conductor_number=1 Winding=Ns Point_out_of_terminal=true
  Ns_4: Coil Terminal Objects=Ns4_Section1 Conductor_number=1 Winding=Ns Point_out_of_terminal=true
  Ns_5: Coil Terminal Objects=Ns5_Section1 Conductor_number=1 Winding=Ns Point_out_of_terminal=true
  Ns_6: Coil Terminal Objects=Ns6_Section1 Conductor_number=1 Winding=Ns Point_out_of_terminal=true
  Ns_7: Coil Terminal Objects=Ns7_Section1 Conductor_number=1 Winding=Ns Point_out_of_terminal=true
  Ns_8: Coil Terminal Objects=Ns8_Section1 Conductor_number=1 Winding=Ns Point_out_of_terminal=true
  Ns_9: Coil Terminal Objects=Ns9_Section1 Conductor_number=1 Winding=Ns Point_out_of_terminal=true
  Ns_10: Coil Terminal Objects=Ns10_Section1 Conductor_number=1 Winding=Ns Point_out_of_terminal=true
  Ns_11: Coil Terminal Objects=Ns11_Section1 Conductor_number=1 Winding=Ns Point_out_of_terminal=true
  Ns_12: Coil Terminal Objects=Ns12_Section1_Separate1 Conductor_number=1 Winding=Ns Point_out_of_terminal=true
  Np: Winding Group Type=Voltage IsSolid=true Current=0A Resistance=0ohm Inductance=0nH Voltage=141V ParallelBranchesNum=1 Phase=0rad
  Ns: Winding Group Type=Current IsSolid=true Current=0mA ParallelBranchesNum=1 Phase=0deg
  eddy effects on: Np1, Np10, Np11, Np12, Np2..Np9, Ns1, Ns10, Ns11, Ns12, Ns2..Ns9, Body1_1, Body1_2, Body1_4, Body1_5
  core loss on: Body1, Body1_3
parameters:
  Matrix1: Matrix Np, Ns:
mesh:
  Length1: LengthBased Objects=[plate_2, Np1..Np12, Ns1..Ns12, plate_1] MaxLength=2mm
  Length2: LengthBased Objects=[Body1_1, Body1_2, Body1, Body1_3, Body1_4, Body1_5] MaxLength=5mm
  initial mesh: GlobalSurfApproximation{CurvedSurfaceApproxChoice=UseSlider SliderMeshSettings=9} GlobalCurvilinear{Apply} MeshMethod=AnsoftClassic
setups:
  Setup1: EddyCurrent MaximumPasses=20 MinimumPasses=2 MinimumConvergedPasses=1 PercentRefinement=30 PercentError=1 NonLinearResidual=0.0001 Frequency=28.5kHz LossAdaptiveCtrl=0.5

design 12turns1 (Maxwell 3D, EddyCurrent, model units mm)
geometry:
  Np1, Np10, Np11, Np12, Np2..Np9, Ns1, Ns10, Ns11, Ns12, Ns2..Ns9 [copper] = imported_body(C:\Users\karlr\Documents\core_assembled_flatwise_12turns.step)
  plate_1, plate_2 [Al_N] = imported_body(C:\Users\karlr\Documents\core_assembled_flatwise_12turns.step)
  Body1 [ferrite - Copy] = imported_body(C:\Users\karlr\Documents\core_assembled_flatwise_12turns.step)
  Body1_1, Body1_2 [aluminum] = imported_body(C:\Users\karlr\Documents\core_assembled_flatwise_12turns.step)
  Body1_3 [ferrite - Copy] = imported_body(C:\Users\karlr\Documents\core_assembled_flatwise_12turns.step)
  Body1_4, Body1_5 [aluminum] = imported_body(C:\Users\karlr\Documents\core_assembled_flatwise_12turns.step)
  Np1_Section1 [copper] = Np1.section(plane=ZX)
  Np2_Section1 [copper] = Np2.section(plane=ZX)
  Np3_Section1 [copper] = Np3.section(plane=ZX)
  Np4_Section1 [copper] = Np4.section(plane=ZX)
  Np5_Section1 [copper] = Np5.section(plane=ZX)
  Np6_Section1 [copper] = Np6.section(plane=ZX)
  Np7_Section1 [copper] = Np7.section(plane=ZX)
  Np8_Section1 [copper] = Np8.section(plane=ZX)
  Np9_Section1 [copper] = Np9.section(plane=ZX)
  Np10_Section1 [copper] = Np10.section(plane=ZX)
  Np11_Section1 [copper] = Np11.section(plane=ZX)
  Np12_Section1 [copper] = Np12.section(plane=ZX)
  Ns1_Section1 [copper] = Ns1.section(plane=ZX)
  Ns2_Section1 [copper] = Ns2.section(plane=ZX)
  Ns3_Section1 [copper] = Ns3.section(plane=ZX)
  Ns4_Section1 [copper] = Ns4.section(plane=ZX)
  Ns5_Section1 [copper] = Ns5.section(plane=ZX)
  Ns6_Section1 [copper] = Ns6.section(plane=ZX)
  Ns7_Section1 [copper] = Ns7.section(plane=ZX)
  Ns8_Section1 [copper] = Ns8.section(plane=ZX)
  Ns9_Section1 [copper] = Ns9.section(plane=ZX)
  Ns10_Section1 [copper] = Ns10.section(plane=ZX)
  Ns11_Section1 [copper] = Ns11.section(plane=ZX)
  Ns12_Section1 = Ns12.section(plane=ZX)
  Np1_Section1.separate_bodies()
  Np2_Section1.separate_bodies()
  Np3_Section1.separate_bodies()
  Np4_Section1.separate_bodies()
  Np5_Section1.separate_bodies()
  Np6_Section1.separate_bodies()
  Np7_Section1.separate_bodies()
  Np8_Section1.separate_bodies()
  Np9_Section1.separate_bodies()
  Np10_Section1.separate_bodies()
  Np11_Section1.separate_bodies()
  Np12_Section1.separate_bodies()
  Ns1_Section1.separate_bodies()
  Ns2_Section1.separate_bodies()
  Ns3_Section1.separate_bodies()
  Ns4_Section1.separate_bodies()
  Ns5_Section1.separate_bodies()
  Ns6_Section1.separate_bodies()
  Ns7_Section1.separate_bodies()
  Ns8_Section1.separate_bodies()
  Ns9_Section1.separate_bodies()
  Ns10_Section1.separate_bodies()
  Ns11_Section1.separate_bodies()
  Ns12_Section1_Separate1 [copper] = Ns12_Section1.separate_bodies()
  Ns12_Section1.delete()
  Region [vacuum] = region(percentage_offset=0 on all sides)
  Rectangle1 [non-model] = rectangle(corner=(45.8mm, 22.75mm, 0mm), z_size=20mm, x_size=-45.8mm)
  group core_assembled_flatwise = Np1, Np10, Np11, Np12, Np2..Np9, Ns1, Ns10, Ns11, Ns12, Ns2..Ns9, plate_1, plate_2, Np1_Section1, Np2_Section1, Np3_Section1, Np4_Section1, Np5_Section1, Np6_Section1, Np7_Section1, Np8_Section1, Np9_Section1, Np10_Section1, Np11_Section1, Np12_Section1, Ns1_Section1, Ns2_Section1, Ns3_Section1, Ns4_Section1, Ns5_Section1, Ns6_Section1, Ns7_Section1, Ns8_Section1, Ns9_Section1, Ns10_Section1, Ns11_Section1, Ns12_Section1_Separate1
  group core_together_1 = Body1, Body1_1, Body1_2
  group core_together = Body1_3, Body1_4, Body1_5
boundaries and excitations:
  Np_1: Coil Terminal Objects=Np1_Section1 Conductor_number=1 Winding=Primary Point_out_of_terminal=false
  Np_2: Coil Terminal Objects=Np2_Section1 Conductor_number=1 Winding=Primary Point_out_of_terminal=false
  Np_3: Coil Terminal Objects=Np3_Section1 Conductor_number=1 Winding=Primary Point_out_of_terminal=false
  Np_4: Coil Terminal Objects=Np4_Section1 Conductor_number=1 Winding=Primary Point_out_of_terminal=false
  Np_5: Coil Terminal Objects=Np5_Section1 Conductor_number=1 Winding=Primary Point_out_of_terminal=false
  Np_6: Coil Terminal Objects=Np6_Section1 Conductor_number=1 Winding=Primary Point_out_of_terminal=false
  Np_7: Coil Terminal Objects=Np7_Section1 Conductor_number=1 Winding=Primary Point_out_of_terminal=false
  Np_8: Coil Terminal Objects=Np8_Section1 Conductor_number=1 Winding=Primary Point_out_of_terminal=false
  Np_9: Coil Terminal Objects=Np9_Section1 Conductor_number=1 Winding=Primary Point_out_of_terminal=false
  Np_10: Coil Terminal Objects=Np10_Section1 Conductor_number=1 Winding=Primary Point_out_of_terminal=false
  Np_11: Coil Terminal Objects=Np11_Section1 Conductor_number=1 Winding=Primary Point_out_of_terminal=false
  Np_12: Coil Terminal Objects=Np12_Section1 Conductor_number=1 Winding=Primary Point_out_of_terminal=false
  Ns_1: Coil Terminal Objects=Ns1_Section1 Conductor_number=1 Winding=Winding1 Point_out_of_terminal=true
  Ns_2: Coil Terminal Objects=Ns2_Section1 Conductor_number=1 Winding=Winding1 Point_out_of_terminal=true
  Ns_3: Coil Terminal Objects=Ns3_Section1 Conductor_number=1 Winding=Winding1 Point_out_of_terminal=true
  Ns_4: Coil Terminal Objects=Ns4_Section1 Conductor_number=1 Winding=Winding1 Point_out_of_terminal=true
  Ns_5: Coil Terminal Objects=Ns5_Section1 Conductor_number=1 Winding=Winding1 Point_out_of_terminal=true
  Ns_6: Coil Terminal Objects=Ns6_Section1 Conductor_number=1 Winding=Winding1 Point_out_of_terminal=true
  Ns_7: Coil Terminal Objects=Ns7_Section1 Conductor_number=1 Winding=Winding1 Point_out_of_terminal=true
  Ns_8: Coil Terminal Objects=Ns8_Section1 Conductor_number=1 Winding=Winding1 Point_out_of_terminal=true
  Ns_9: Coil Terminal Objects=Ns9_Section1 Conductor_number=1 Winding=Winding1 Point_out_of_terminal=true
  Ns_10: Coil Terminal Objects=Ns10_Section1 Conductor_number=1 Winding=Winding1 Point_out_of_terminal=true
  Ns_11: Coil Terminal Objects=Ns11_Section1 Conductor_number=1 Winding=Winding1 Point_out_of_terminal=true
  Ns_12: Coil Terminal Objects=Ns12_Section1_Separate1 Conductor_number=1 Winding=Winding1 Point_out_of_terminal=true
  Primary: Winding Group Type=Voltage IsSolid=true Current=0A Resistance=0ohm Inductance=0nH Voltage=141V ParallelBranchesNum=1 Phase=0rad
  Winding1: Winding Group Type=Current IsSolid=true Current=0mA ParallelBranchesNum=1 Phase=0deg
  eddy effects on: Np1, Np10, Np11, Np12, Np2..Np9, Ns1, Ns10, Ns11, Ns12, Ns2..Ns9, Body1_1, Body1_2, Body1_4, Body1_5
  core loss on: Body1, Body1_3
parameters:
  Matrix1: Matrix Primary, Winding1:
mesh:
  Length1: LengthBased Objects=[plate_1, plate_2, Np1..Np12, Ns1..Ns12] MaxLength=2mm
  Length2: LengthBased Objects=[Body1, Body1_1..Body1_5] MaxLength=5mm
  initial mesh: GlobalSurfApproximation{CurvedSurfaceApproxChoice=UseSlider SliderMeshSettings=9} GlobalCurvilinear{Apply} MeshMethod=AnsoftClassic
setups:
  Setup1: EddyCurrent MaximumPasses=20 MinimumPasses=2 MinimumConvergedPasses=1 PercentRefinement=30 PercentError=1 NonLinearResidual=0.0001 Frequency=500kHz LossAdaptiveCtrl=0.5
field plots:
  Mag_B1: B over Body1_3, Body1 on Setup1 : LastAdaptive at Freq=500kHz Phase=50deg
  Mag_J1: J over a plane on Setup1 : LastAdaptive at Freq=500kHz Phase=0deg
  Mesh1: MeshPlots in Body1_4, Body1_5, Body1_3, Body1_1, Body1_2, Body1 on Setup1 : LastAdaptive at Freq=500kHz Phase=0deg

design 12turns_3D_CoreLoss_PSSP (Maxwell 3D, EddyCurrent, model units mm)
geometry:
  Np1, Np10, Np11, Np12, Np2..Np9, Ns1, Ns10, Ns11, Ns12, Ns2..Ns9 [copper] = imported_body(C:\Users\karlr\Documents\core_assembled_flatwise_12turns.step)
  plate_1, plate_2 [Al_N] = imported_body(C:\Users\karlr\Documents\core_assembled_flatwise_12turns.step)
  Body1 [ferrite - Copy] = imported_body(C:\Users\karlr\Documents\core_assembled_flatwise_12turns.step)
  Body1_1, Body1_2 [aluminum] = imported_body(C:\Users\karlr\Documents\core_assembled_flatwise_12turns.step)
  Body1_3 [ferrite - Copy] = imported_body(C:\Users\karlr\Documents\core_assembled_flatwise_12turns.step)
  Body1_4, Body1_5 [aluminum] = imported_body(C:\Users\karlr\Documents\core_assembled_flatwise_12turns.step)
  Region [vacuum] = region(percentage_offset=0 on all sides)
  Np1_Section1 = Np1.section(plane=ZX)
  Np2_Section1 = Np2.section(plane=ZX)
  Np3_Section1 = Np3.section(plane=ZX)
  Np4_Section1 = Np4.section(plane=ZX)
  Np5_Section1 = Np5.section(plane=ZX)
  Np6_Section1 = Np6.section(plane=ZX)
  Np7_Section1 = Np7.section(plane=ZX)
  Np8_Section1 = Np8.section(plane=ZX)
  Np9_Section1 = Np9.section(plane=ZX)
  Np10_Section1 = Np10.section(plane=ZX)
  Np11_Section1 = Np11.section(plane=ZX)
  Np12_Section1 = Np12.section(plane=ZX)
  Ns1_Section1 = Ns1.section(plane=ZX)
  Ns2_Section1 = Ns2.section(plane=ZX)
  Ns3_Section1 = Ns3.section(plane=ZX)
  Ns4_Section1 = Ns4.section(plane=ZX)
  Ns5_Section1 = Ns5.section(plane=ZX)
  Ns6_Section1 = Ns6.section(plane=ZX)
  Ns7_Section1 = Ns7.section(plane=ZX)
  Ns8_Section1 = Ns8.section(plane=ZX)
  Ns9_Section1 = Ns9.section(plane=ZX)
  Ns10_Section1 = Ns10.section(plane=ZX)
  Ns11_Section1 = Ns11.section(plane=ZX)
  Ns12_Section1 = Ns12.section(plane=ZX)
  Np1_Section1.separate_bodies()
  Np2_Section1.separate_bodies()
  Np3_Section1.separate_bodies()
  Np4_Section1.separate_bodies()
  Np5_Section1.separate_bodies()
  Np6_Section1.separate_bodies()
  Np7_Section1.separate_bodies()
  Np8_Section1.separate_bodies()
  Np9_Section1.separate_bodies()
  Np10_Section1.separate_bodies()
  Np11_Section1.separate_bodies()
  Np12_Section1.separate_bodies()
  Ns1_Section1.separate_bodies()
  Ns2_Section1.separate_bodies()
  Ns3_Section1.separate_bodies()
  Ns4_Section1.separate_bodies()
  Ns5_Section1.separate_bodies()
  Ns6_Section1.separate_bodies()
  Ns7_Section1.separate_bodies()
  Ns8_Section1.separate_bodies()
  Ns9_Section1.separate_bodies()
  Ns10_Section1.separate_bodies()
  Ns11_Section1.separate_bodies()
  Ns12_Section1_Separate1 = Ns12_Section1.separate_bodies()
  Ns12_Section1.delete()
  group core_assembled_flatwise = Np1, Np10, Np11, Np12, Np2..Np9, Ns1, Ns10, Ns11, Ns12, Ns2..Ns9, plate_1, plate_2, Np1_Section1, Np2_Section1, Np3_Section1, Np4_Section1, Np5_Section1, Np6_Section1, Np7_Section1, Np8_Section1, Np9_Section1, Np10_Section1, Np11_Section1, Np12_Section1, Ns1_Section1, Ns2_Section1, Ns3_Section1, Ns4_Section1, Ns5_Section1, Ns6_Section1, Ns7_Section1, Ns8_Section1, Ns9_Section1, Ns10_Section1, Ns11_Section1, Ns12_Section1_Separate1
  group core_together_1 = Body1, Body1_1, Body1_2
  group core_together = Body1_3, Body1_4, Body1_5
boundaries and excitations:
  Np_1: Coil Terminal Objects=Np1_Section1 Conductor_number=1 Winding=Np Point_out_of_terminal=false
  Np_2: Coil Terminal Objects=Ns2_Section1 Conductor_number=1 Winding=Np Point_out_of_terminal=false
  Np_3: Coil Terminal Objects=Np3_Section1 Conductor_number=1 Winding=Np Point_out_of_terminal=false
  Np_4: Coil Terminal Objects=Ns4_Section1 Conductor_number=1 Winding=Np Point_out_of_terminal=false
  Np_5: Coil Terminal Objects=Np5_Section1 Conductor_number=1 Winding=Np Point_out_of_terminal=false
  Np_6: Coil Terminal Objects=Ns6_Section1 Conductor_number=1 Winding=Np Point_out_of_terminal=false
  Np_7: Coil Terminal Objects=Ns8_Section1 Conductor_number=1 Winding=Np Point_out_of_terminal=false
  Np_8: Coil Terminal Objects=Ns10_Section1 Conductor_number=1 Winding=Np Point_out_of_terminal=false
  Np_9: Coil Terminal Objects=Ns12_Section1_Separate1 Conductor_number=1 Winding=Np Point_out_of_terminal=false
  Np_10: Coil Terminal Objects=Np7_Section1 Conductor_number=1 Winding=Np Point_out_of_terminal=false
  Np_11: Coil Terminal Objects=Np9_Section1 Conductor_number=1 Winding=Np Point_out_of_terminal=false
  Np_12: Coil Terminal Objects=Np11_Section1 Conductor_number=1 Winding=Np Point_out_of_terminal=false
  Ns_1: Coil Terminal Objects=Np2_Section1 Conductor_number=1 Winding=Ns Point_out_of_terminal=true
  Ns_2: Coil Terminal Objects=Np4_Section1 Conductor_number=1 Winding=Ns Point_out_of_terminal=true
  Ns_3: Coil Terminal Objects=Np6_Section1 Conductor_number=1 Winding=Ns Point_out_of_terminal=true
  Ns_4: Coil Terminal Objects=Np8_Section1 Conductor_number=1 Winding=Ns Point_out_of_terminal=true
  Ns_5: Coil Terminal Objects=Np10_Section1 Conductor_number=1 Winding=Ns Point_out_of_terminal=true
  Ns_6: Coil Terminal Objects=Np12_Section1 Conductor_number=1 Winding=Ns Point_out_of_terminal=true
  Ns_7: Coil Terminal Objects=Ns1_Section1 Conductor_number=1 Winding=Ns Point_out_of_terminal=true
  Ns_8: Coil Terminal Objects=Ns3_Section1 Conductor_number=1 Winding=Ns Point_out_of_terminal=true
  Ns_9: Coil Terminal Objects=Ns5_Section1 Conductor_number=1 Winding=Ns Point_out_of_terminal=true
  Ns_10: Coil Terminal Objects=Ns7_Section1 Conductor_number=1 Winding=Ns Point_out_of_terminal=true
  Ns_11: Coil Terminal Objects=Ns9_Section1 Conductor_number=1 Winding=Ns Point_out_of_terminal=true
  Ns_12: Coil Terminal Objects=Ns11_Section1 Conductor_number=1 Winding=Ns Point_out_of_terminal=true
  Np: Winding Group Type=Voltage IsSolid=true Current=0mA Resistance=0ohm Inductance=0nH Voltage=141V ParallelBranchesNum=1 Phase=0deg
  Ns: Winding Group Type=Current IsSolid=true Current=0mA ParallelBranchesNum=1 Phase=0deg
  eddy effects on: Np1, Np10, Np11, Np12, Np2..Np9, Ns1, Ns10, Ns11, Ns12, Ns2..Ns9, Body1_1, Body1_2, Body1_4, Body1_5
  core loss on: Body1, Body1_3
parameters:
  Matrix1: Matrix Np, Ns:
mesh:
  Length1: LengthBased Objects=[plate_2, Np1..Np12, Ns1..Ns12, plate_1] MaxLength=2mm
  Length2: LengthBased Objects=[Body1_1, Body1_2, Body1, Body1_3, Body1_4, Body1_5] MaxLength=5mm
  initial mesh: GlobalSurfApproximation{CurvedSurfaceApproxChoice=UseSlider SliderMeshSettings=9} GlobalCurvilinear{Apply} MeshMethod=AnsoftClassic
setups:
  Setup1: EddyCurrent MaximumPasses=20 MinimumPasses=2 MinimumConvergedPasses=1 PercentRefinement=30 PercentError=1 NonLinearResidual=0.0001 Frequency=28.5kHz LossAdaptiveCtrl=0.5

design 12turns_3D_CoreLoss_NoInterleaving (Maxwell 3D, EddyCurrent, model units mm)
geometry:
  Region [vacuum] = region(percentage_offset=0 on all sides)
  Np1, Np10, Np11, Np12, Np2..Np9, Ns1, Ns10, Ns11, Ns12, Ns2..Ns9 [copper] = imported_body(C:\Users\karlr\Documents\core_assembled_flatwise_12turns.step)
  plate_1, plate_2 [Al_N] = imported_body(C:\Users\karlr\Documents\core_assembled_flatwise_12turns.step)
  Body1 [ferrite - Copy] = imported_body(C:\Users\karlr\Documents\core_assembled_flatwise_12turns.step)
  Body1_1, Body1_2 [aluminum] = imported_body(C:\Users\karlr\Documents\core_assembled_flatwise_12turns.step)
  Body1_3 [ferrite - Copy] = imported_body(C:\Users\karlr\Documents\core_assembled_flatwise_12turns.step)
  Body1_4, Body1_5 [aluminum] = imported_body(C:\Users\karlr\Documents\core_assembled_flatwise_12turns.step)
  Np1_Section1 [copper] = Np1.section(plane=ZX)
  Np2_Section1 [copper] = Np2.section(plane=ZX)
  Np3_Section1 [copper] = Np3.section(plane=ZX)
  Np4_Section1 [copper] = Np4.section(plane=ZX)
  Np5_Section1 [copper] = Np5.section(plane=ZX)
  Np6_Section1 [copper] = Np6.section(plane=ZX)
  Np7_Section1 [copper] = Np7.section(plane=ZX)
  Np8_Section1 [copper] = Np8.section(plane=ZX)
  Np9_Section1 [copper] = Np9.section(plane=ZX)
  Np10_Section1 [copper] = Np10.section(plane=ZX)
  Np11_Section1 [copper] = Np11.section(plane=ZX)
  Np12_Section1 [copper] = Np12.section(plane=ZX)
  Ns1_Section1 [copper] = Ns1.section(plane=ZX)
  Ns2_Section1 [copper] = Ns2.section(plane=ZX)
  Ns3_Section1 [copper] = Ns3.section(plane=ZX)
  Ns4_Section1 [copper] = Ns4.section(plane=ZX)
  Ns5_Section1 [copper] = Ns5.section(plane=ZX)
  Ns6_Section1 [copper] = Ns6.section(plane=ZX)
  Ns7_Section1 [copper] = Ns7.section(plane=ZX)
  Ns8_Section1 [copper] = Ns8.section(plane=ZX)
  Ns9_Section1 [copper] = Ns9.section(plane=ZX)
  Ns10_Section1 [copper] = Ns10.section(plane=ZX)
  Ns11_Section1 [copper] = Ns11.section(plane=ZX)
  Ns12_Section1 = Ns12.section(plane=ZX)
  Np1_Section1.separate_bodies()
  Np2_Section1.separate_bodies()
  Np3_Section1.separate_bodies()
  Np4_Section1.separate_bodies()
  Np5_Section1.separate_bodies()
  Np6_Section1.separate_bodies()
  Np7_Section1.separate_bodies()
  Np8_Section1.separate_bodies()
  Np9_Section1.separate_bodies()
  Np10_Section1.separate_bodies()
  Np11_Section1.separate_bodies()
  Np12_Section1.separate_bodies()
  Ns1_Section1.separate_bodies()
  Ns2_Section1.separate_bodies()
  Ns3_Section1.separate_bodies()
  Ns4_Section1.separate_bodies()
  Ns5_Section1.separate_bodies()
  Ns6_Section1.separate_bodies()
  Ns7_Section1.separate_bodies()
  Ns8_Section1.separate_bodies()
  Ns9_Section1.separate_bodies()
  Ns10_Section1.separate_bodies()
  Ns11_Section1.separate_bodies()
  Ns12_Section1_Separate1 [copper] = Ns12_Section1.separate_bodies()
  Ns12_Section1.delete()
  group core_assembled_flatwise = Np1, Np10, Np11, Np12, Np2..Np9, Ns1, Ns10, Ns11, Ns12, Ns2..Ns9, plate_1, plate_2, Np1_Section1, Np2_Section1, Np3_Section1, Np4_Section1, Np5_Section1, Np6_Section1, Np7_Section1, Np8_Section1, Np9_Section1, Np10_Section1, Np11_Section1, Np12_Section1, Ns1_Section1, Ns2_Section1, Ns3_Section1, Ns4_Section1, Ns5_Section1, Ns6_Section1, Ns7_Section1, Ns8_Section1, Ns9_Section1, Ns10_Section1, Ns11_Section1, Ns12_Section1_Separate1
  group core_together_1 = Body1, Body1_1, Body1_2
  group core_together = Body1_3, Body1_4, Body1_5
boundaries and excitations:
  Np_1: Coil Terminal Objects=Np1_Section1 Conductor_number=1 Winding=Np Point_out_of_terminal=false
  Np_2: Coil Terminal Objects=Np2_Section1 Conductor_number=1 Winding=Np Point_out_of_terminal=false
  Np_3: Coil Terminal Objects=Np3_Section1 Conductor_number=1 Winding=Np Point_out_of_terminal=false
  Np_4: Coil Terminal Objects=Np4_Section1 Conductor_number=1 Winding=Np Point_out_of_terminal=false
  Np_5: Coil Terminal Objects=Np5_Section1 Conductor_number=1 Winding=Np Point_out_of_terminal=false
  Np_6: Coil Terminal Objects=Np6_Section1 Conductor_number=1 Winding=Np Point_out_of_terminal=false
  Np_7: Coil Terminal Objects=Ns1_Section1 Conductor_number=1 Winding=Np Point_out_of_terminal=false
  Np_8: Coil Terminal Objects=Ns2_Section1 Conductor_number=1 Winding=Np Point_out_of_terminal=false
  Np_9: Coil Terminal Objects=Ns3_Section1 Conductor_number=1 Winding=Np Point_out_of_terminal=false
  Np_10: Coil Terminal Objects=Ns4_Section1 Conductor_number=1 Winding=Np Point_out_of_terminal=false
  Np_11: Coil Terminal Objects=Ns5_Section1 Conductor_number=1 Winding=Np Point_out_of_terminal=false
  Np_12: Coil Terminal Objects=Ns6_Section1 Conductor_number=1 Winding=Np Point_out_of_terminal=false
  Ns_1: Coil Terminal Objects=Ns12_Section1_Separate1 Conductor_number=1 Winding=Ns Point_out_of_terminal=true
  Ns_2: Coil Terminal Objects=Np7_Section1 Conductor_number=1 Winding=Ns Point_out_of_terminal=true
  Ns_3: Coil Terminal Objects=Np8_Section1 Conductor_number=1 Winding=Ns Point_out_of_terminal=true
  Ns_4: Coil Terminal Objects=Np9_Section1 Conductor_number=1 Winding=Ns Point_out_of_terminal=true
  Ns_5: Coil Terminal Objects=Np10_Section1 Conductor_number=1 Winding=Ns Point_out_of_terminal=true
  Ns_6: Coil Terminal Objects=Np11_Section1 Conductor_number=1 Winding=Ns Point_out_of_terminal=true
  Ns_7: Coil Terminal Objects=Np12_Section1 Conductor_number=1 Winding=Ns Point_out_of_terminal=true
  Ns_8: Coil Terminal Objects=Ns7_Section1 Conductor_number=1 Winding=Ns Point_out_of_terminal=true
  Ns_9: Coil Terminal Objects=Ns8_Section1 Conductor_number=1 Winding=Ns Point_out_of_terminal=true
  Ns_10: Coil Terminal Objects=Ns9_Section1 Conductor_number=1 Winding=Ns Point_out_of_terminal=true
  Ns_11: Coil Terminal Objects=Ns10_Section1 Conductor_number=1 Winding=Ns Point_out_of_terminal=true
  Ns_12: Coil Terminal Objects=Ns11_Section1 Conductor_number=1 Winding=Ns Point_out_of_terminal=true
  Np: Winding Group Type=Voltage IsSolid=true Current=0A Resistance=0ohm Inductance=0nH Voltage=141V ParallelBranchesNum=1 Phase=0rad
  Ns: Winding Group Type=Current IsSolid=true Current=0mA ParallelBranchesNum=1 Phase=0deg
  eddy effects on: Np1, Np10, Np11, Np12, Np2..Np9, Ns1, Ns10, Ns11, Ns12, Ns2..Ns9, Body1_1, Body1_2, Body1_4, Body1_5
  core loss on: Body1, Body1_3
parameters:
  Matrix1: Matrix Np, Ns:
mesh:
  Length1: LengthBased Objects=[plate_2, Np1..Np12, Ns1..Ns12, plate_1] MaxLength=2mm
  Length2: LengthBased Objects=[Body1_1, Body1_2, Body1, Body1_3, Body1_4, Body1_5] MaxLength=5mm
  initial mesh: GlobalSurfApproximation{CurvedSurfaceApproxChoice=UseSlider SliderMeshSettings=9} GlobalCurvilinear{Apply} MeshMethod=AnsoftClassic
setups:
  Setup1: EddyCurrent MaximumPasses=20 MinimumPasses=2 MinimumConvergedPasses=1 PercentRefinement=30 PercentError=1 NonLinearResidual=0.0001 Frequency=28.5kHz LossAdaptiveCtrl=0.5

design 12turns_3D_WindingLoss_FullInterleaved (Maxwell 3D, EddyCurrent, model units mm)
geometry:
  Region [vacuum] = region(percentage_offset=0 on all sides)
  Np1 [copper] = imported_body(C:\Users\karlr\Documents\core_assembled_flatwise_12turns.step)
  Np1_Section1 = Np1.section(plane=ZX)
  Np10 [copper] = imported_body(C:\Users\karlr\Documents\core_assembled_flatwise_12turns.step)
  Np10_Section1 = Np10.section(plane=ZX)
  Np11 [copper] = imported_body(C:\Users\karlr\Documents\core_assembled_flatwise_12turns.step)
  Np11_Section1 = Np11.section(plane=ZX)
  Np12 [copper] = imported_body(C:\Users\karlr\Documents\core_assembled_flatwise_12turns.step)
  Np12_Section1 = Np12.section(plane=ZX)
  Np2 [copper] = imported_body(C:\Users\karlr\Documents\core_assembled_flatwise_12turns.step)
  Np2_Section1 = Np2.section(plane=ZX)
  Np3 [copper] = imported_body(C:\Users\karlr\Documents\core_assembled_flatwise_12turns.step)
  Np3_Section1 = Np3.section(plane=ZX)
  Np4 [copper] = imported_body(C:\Users\karlr\Documents\core_assembled_flatwise_12turns.step)
  Np4_Section1 = Np4.section(plane=ZX)
  Np5 [copper] = imported_body(C:\Users\karlr\Documents\core_assembled_flatwise_12turns.step)
  Np5_Section1 = Np5.section(plane=ZX)
  Np6 [copper] = imported_body(C:\Users\karlr\Documents\core_assembled_flatwise_12turns.step)
  Np6_Section1 = Np6.section(plane=ZX)
  Np7 [copper] = imported_body(C:\Users\karlr\Documents\core_assembled_flatwise_12turns.step)
  Np7_Section1 = Np7.section(plane=ZX)
  Np8 [copper] = imported_body(C:\Users\karlr\Documents\core_assembled_flatwise_12turns.step)
  Np8_Section1 = Np8.section(plane=ZX)
  Np9 [copper] = imported_body(C:\Users\karlr\Documents\core_assembled_flatwise_12turns.step)
  Np9_Section1 = Np9.section(plane=ZX)
  Ns1 [copper] = imported_body(C:\Users\karlr\Documents\core_assembled_flatwise_12turns.step)
  Ns1_Section1 = Ns1.section(plane=ZX)
  Ns10 [copper] = imported_body(C:\Users\karlr\Documents\core_assembled_flatwise_12turns.step)
  Ns10_Section1 = Ns10.section(plane=ZX)
  Ns11 [copper] = imported_body(C:\Users\karlr\Documents\core_assembled_flatwise_12turns.step)
  Ns11_Section1 = Ns11.section(plane=ZX)
  Ns12 [copper] = imported_body(C:\Users\karlr\Documents\core_assembled_flatwise_12turns.step)
  Ns12_Section1 = Ns12.section(plane=ZX)
  Ns2 [copper] = imported_body(C:\Users\karlr\Documents\core_assembled_flatwise_12turns.step)
  Ns2_Section1 = Ns2.section(plane=ZX)
  Ns3 [copper] = imported_body(C:\Users\karlr\Documents\core_assembled_flatwise_12turns.step)
  Ns3_Section1 = Ns3.section(plane=ZX)
  Ns4 [copper] = imported_body(C:\Users\karlr\Documents\core_assembled_flatwise_12turns.step)
  Ns4_Section1 = Ns4.section(plane=ZX)
  Ns5 [copper] = imported_body(C:\Users\karlr\Documents\core_assembled_flatwise_12turns.step)
  Ns5_Section1 = Ns5.section(plane=ZX)
  Ns6 [copper] = imported_body(C:\Users\karlr\Documents\core_assembled_flatwise_12turns.step)
  Ns6_Section1 = Ns6.section(plane=ZX)
  Ns7 [copper] = imported_body(C:\Users\karlr\Documents\core_assembled_flatwise_12turns.step)
  Ns7_Section1 = Ns7.section(plane=ZX)
  Ns8 [copper] = imported_body(C:\Users\karlr\Documents\core_assembled_flatwise_12turns.step)
  Ns8_Section1 = Ns8.section(plane=ZX)
  Ns9 [copper] = imported_body(C:\Users\karlr\Documents\core_assembled_flatwise_12turns.step)
  Ns9_Section1 = Ns9.section(plane=ZX)
  plate_1, plate_2 [Al_N] = imported_body(C:\Users\karlr\Documents\core_assembled_flatwise_12turns.step)
  Body1 [ferrite - Copy] = imported_body(C:\Users\karlr\Documents\core_assembled_flatwise_12turns.step)
  Body1_1, Body1_2 [aluminum] = imported_body(C:\Users\karlr\Documents\core_assembled_flatwise_12turns.step)
  Body1_3 [ferrite - Copy] = imported_body(C:\Users\karlr\Documents\core_assembled_flatwise_12turns.step)
  Body1_4, Body1_5 [aluminum] = imported_body(C:\Users\karlr\Documents\core_assembled_flatwise_12turns.step)
  Np1_Section1.separate_bodies()
  Np2_Section1.separate_bodies()
  Np3_Section1.separate_bodies()
  Np4_Section1.separate_bodies()
  Np5_Section1.separate_bodies()
  Np6_Section1.separate_bodies()
  Np7_Section1.separate_bodies()
  Np8_Section1.separate_bodies()
  Np9_Section1.separate_bodies()
  Np10_Section1.separate_bodies()
  Np11_Section1.separate_bodies()
  Np12_Section1.separate_bodies()
  Ns1_Section1.separate_bodies()
  Ns2_Section1.separate_bodies()
  Ns3_Section1.separate_bodies()
  Ns4_Section1.separate_bodies()
  Ns5_Section1.separate_bodies()
  Ns6_Section1.separate_bodies()
  Ns7_Section1.separate_bodies()
  Ns8_Section1.separate_bodies()
  Ns9_Section1.separate_bodies()
  Ns10_Section1.separate_bodies()
  Ns11_Section1.separate_bodies()
  Ns12_Section1_Separate1 = Ns12_Section1.separate_bodies()
  Ns12_Section1.delete()
  group core_assembled_flatwise = Np1, Np10, Np11, Np12, Np2..Np9, Ns1, Ns10, Ns11, Ns12, Ns2..Ns9, plate_1, plate_2, Np1_Section1, Np2_Section1, Np3_Section1, Np4_Section1, Np5_Section1, Np6_Section1, Np7_Section1, Np8_Section1, Np9_Section1, Np10_Section1, Np11_Section1, Np12_Section1, Ns1_Section1, Ns2_Section1, Ns3_Section1, Ns4_Section1, Ns5_Section1, Ns6_Section1, Ns7_Section1, Ns8_Section1, Ns9_Section1, Ns10_Section1, Ns11_Section1, Ns12_Section1_Separate1
  group core_together_1 = Body1, Body1_1, Body1_2
  group core_together = Body1_3, Body1_4, Body1_5
boundaries and excitations:
  Np_1: Coil Terminal Objects=Np1_Section1 Conductor_number=1 Winding=Np Point_out_of_terminal=false
  Np_2: Coil Terminal Objects=Np2_Section1 Conductor_number=1 Winding=Np Point_out_of_terminal=false
  Np_3: Coil Terminal Objects=Np3_Section1 Conductor_number=1 Winding=Np Point_out_of_terminal=false
  Np_4: Coil Terminal Objects=Np4_Section1 Conductor_number=1 Winding=Np Point_out_of_terminal=false
  Np_5: Coil Terminal Objects=Np5_Section1 Conductor_number=1 Winding=Np Point_out_of_terminal=false
  Np_6: Coil Terminal Objects=Np6_Section1 Conductor_number=1 Winding=Np Point_out_of_terminal=false
  Np_7: Coil Terminal Objects=Np7_Section1 Conductor_number=1 Winding=Np Point_out_of_terminal=false
  Np_8: Coil Terminal Objects=Np8_Section1 Conductor_number=1 Winding=Np Point_out_of_terminal=false
  Np_9: Coil Terminal Objects=Np9_Section1 Conductor_number=1 Winding=Np Point_out_of_terminal=false
  Np_10: Coil Terminal Objects=Np10_Section1 Conductor_number=1 Winding=Np Point_out_of_terminal=false
  Np_11: Coil Terminal Objects=Np11_Section1 Conductor_number=1 Winding=Np Point_out_of_terminal=false
  Np_12: Coil Terminal Objects=Np12_Section1 Conductor_number=1 Winding=Np Point_out_of_terminal=false
  Ns_1: Coil Terminal Objects=Ns1_Section1 Conductor_number=1 Winding=Ns Point_out_of_terminal=true
  Ns_2: Coil Terminal Objects=Ns2_Section1 Conductor_number=1 Winding=Ns Point_out_of_terminal=true
  Ns_3: Coil Terminal Objects=Ns3_Section1 Conductor_number=1 Winding=Ns Point_out_of_terminal=true
  Ns_4: Coil Terminal Objects=Ns4_Section1 Conductor_number=1 Winding=Ns Point_out_of_terminal=true
  Ns_5: Coil Terminal Objects=Ns5_Section1 Conductor_number=1 Winding=Ns Point_out_of_terminal=true
  Ns_6: Coil Terminal Objects=Ns6_Section1 Conductor_number=1 Winding=Ns Point_out_of_terminal=true
  Ns_7: Coil Terminal Objects=Ns7_Section1 Conductor_number=1 Winding=Ns Point_out_of_terminal=true
  Ns_8: Coil Terminal Objects=Ns8_Section1 Conductor_number=1 Winding=Ns Point_out_of_terminal=true
  Ns_9: Coil Terminal Objects=Ns9_Section1 Conductor_number=1 Winding=Ns Point_out_of_terminal=true
  Ns_10: Coil Terminal Objects=Ns10_Section1 Conductor_number=1 Winding=Ns Point_out_of_terminal=true
  Ns_11: Coil Terminal Objects=Ns11_Section1 Conductor_number=1 Winding=Ns Point_out_of_terminal=true
  Ns_12: Coil Terminal Objects=Ns12_Section1_Separate1 Conductor_number=1 Winding=Ns Point_out_of_terminal=true
  Np: Winding Group Type=Current IsSolid=true Current=16.36A ParallelBranchesNum=1 Phase=0rad
  Ns: Winding Group Type=Current IsSolid=true Current=15.96A ParallelBranchesNum=1 Phase=0.1522rad
parameters:
  Matrix1: Matrix Np, Ns:
mesh:
  Length1: LengthBased Objects=[plate_2, Np1..Np12, Ns1..Ns12, plate_1] MaxLength=2mm
  Length2: LengthBased Objects=[Body1_1, Body1_2, Body1, Body1_3, Body1_4, Body1_5] MaxLength=5mm
  initial mesh: GlobalSurfApproximation{CurvedSurfaceApproxChoice=UseSlider SliderMeshSettings=9} GlobalCurvilinear{Apply} MeshMethod=AnsoftClassic
setups:
  Setup1: EddyCurrent MaximumPasses=20 MinimumPasses=2 MinimumConvergedPasses=1 PercentRefinement=30 PercentError=1 NonLinearResidual=0.0001 Frequency=28.5kHz LossAdaptiveCtrl=0.5

design 12turns_3D_WindingLoss_PSSP (Maxwell 3D, EddyCurrent, model units mm)
geometry:
  Region [vacuum] = region(percentage_offset=0 on all sides)
  Np1 [copper] = imported_body(C:\Users\karlr\Documents\core_assembled_flatwise_12turns.step)
  Np1_Section1 = Np1.section(plane=ZX)
  Np10 [copper] = imported_body(C:\Users\karlr\Documents\core_assembled_flatwise_12turns.step)
  Np10_Section1 = Np10.section(plane=ZX)
  Np11 [copper] = imported_body(C:\Users\karlr\Documents\core_assembled_flatwise_12turns.step)
  Np11_Section1 = Np11.section(plane=ZX)
  Np12 [copper] = imported_body(C:\Users\karlr\Documents\core_assembled_flatwise_12turns.step)
  Np12_Section1 = Np12.section(plane=ZX)
  Np2 [copper] = imported_body(C:\Users\karlr\Documents\core_assembled_flatwise_12turns.step)
  Np2_Section1 = Np2.section(plane=ZX)
  Np3 [copper] = imported_body(C:\Users\karlr\Documents\core_assembled_flatwise_12turns.step)
  Np3_Section1 = Np3.section(plane=ZX)
  Np4 [copper] = imported_body(C:\Users\karlr\Documents\core_assembled_flatwise_12turns.step)
  Np4_Section1 = Np4.section(plane=ZX)
  Np5 [copper] = imported_body(C:\Users\karlr\Documents\core_assembled_flatwise_12turns.step)
  Np5_Section1 = Np5.section(plane=ZX)
  Np6 [copper] = imported_body(C:\Users\karlr\Documents\core_assembled_flatwise_12turns.step)
  Np6_Section1 = Np6.section(plane=ZX)
  Np7 [copper] = imported_body(C:\Users\karlr\Documents\core_assembled_flatwise_12turns.step)
  Np7_Section1 = Np7.section(plane=ZX)
  Np8 [copper] = imported_body(C:\Users\karlr\Documents\core_assembled_flatwise_12turns.step)
  Np8_Section1 = Np8.section(plane=ZX)
  Np9 [copper] = imported_body(C:\Users\karlr\Documents\core_assembled_flatwise_12turns.step)
  Np9_Section1 = Np9.section(plane=ZX)
  Ns1 [copper] = imported_body(C:\Users\karlr\Documents\core_assembled_flatwise_12turns.step)
  Ns1_Section1 = Ns1.section(plane=ZX)
  Ns10 [copper] = imported_body(C:\Users\karlr\Documents\core_assembled_flatwise_12turns.step)
  Ns10_Section1 = Ns10.section(plane=ZX)
  Ns11 [copper] = imported_body(C:\Users\karlr\Documents\core_assembled_flatwise_12turns.step)
  Ns11_Section1 = Ns11.section(plane=ZX)
  Ns12 [copper] = imported_body(C:\Users\karlr\Documents\core_assembled_flatwise_12turns.step)
  Ns12_Section1 = Ns12.section(plane=ZX)
  Ns2 [copper] = imported_body(C:\Users\karlr\Documents\core_assembled_flatwise_12turns.step)
  Ns2_Section1 = Ns2.section(plane=ZX)
  Ns3 [copper] = imported_body(C:\Users\karlr\Documents\core_assembled_flatwise_12turns.step)
  Ns3_Section1 = Ns3.section(plane=ZX)
  Ns4 [copper] = imported_body(C:\Users\karlr\Documents\core_assembled_flatwise_12turns.step)
  Ns4_Section1 = Ns4.section(plane=ZX)
  Ns5 [copper] = imported_body(C:\Users\karlr\Documents\core_assembled_flatwise_12turns.step)
  Ns5_Section1 = Ns5.section(plane=ZX)
  Ns6 [copper] = imported_body(C:\Users\karlr\Documents\core_assembled_flatwise_12turns.step)
  Ns6_Section1 = Ns6.section(plane=ZX)
  Ns7 [copper] = imported_body(C:\Users\karlr\Documents\core_assembled_flatwise_12turns.step)
  Ns7_Section1 = Ns7.section(plane=ZX)
  Ns8 [copper] = imported_body(C:\Users\karlr\Documents\core_assembled_flatwise_12turns.step)
  Ns8_Section1 = Ns8.section(plane=ZX)
  Ns9 [copper] = imported_body(C:\Users\karlr\Documents\core_assembled_flatwise_12turns.step)
  Ns9_Section1 = Ns9.section(plane=ZX)
  plate_1, plate_2 [Al_N] = imported_body(C:\Users\karlr\Documents\core_assembled_flatwise_12turns.step)
  Body1 [ferrite - Copy] = imported_body(C:\Users\karlr\Documents\core_assembled_flatwise_12turns.step)
  Body1_1, Body1_2 [aluminum] = imported_body(C:\Users\karlr\Documents\core_assembled_flatwise_12turns.step)
  Body1_3 [ferrite - Copy] = imported_body(C:\Users\karlr\Documents\core_assembled_flatwise_12turns.step)
  Body1_4, Body1_5 [aluminum] = imported_body(C:\Users\karlr\Documents\core_assembled_flatwise_12turns.step)
  Np1_Section1.separate_bodies()
  Np2_Section1.separate_bodies()
  Np3_Section1.separate_bodies()
  Np4_Section1.separate_bodies()
  Np5_Section1.separate_bodies()
  Np6_Section1.separate_bodies()
  Np7_Section1.separate_bodies()
  Np8_Section1.separate_bodies()
  Np9_Section1.separate_bodies()
  Np10_Section1.separate_bodies()
  Np11_Section1.separate_bodies()
  Np12_Section1.separate_bodies()
  Ns1_Section1.separate_bodies()
  Ns2_Section1.separate_bodies()
  Ns3_Section1.separate_bodies()
  Ns4_Section1.separate_bodies()
  Ns5_Section1.separate_bodies()
  Ns6_Section1.separate_bodies()
  Ns7_Section1.separate_bodies()
  Ns8_Section1.separate_bodies()
  Ns9_Section1.separate_bodies()
  Ns10_Section1.separate_bodies()
  Ns11_Section1.separate_bodies()
  Ns12_Section1_Separate1 = Ns12_Section1.separate_bodies()
  Ns12_Section1.delete()
  group core_assembled_flatwise = Np1, Np10, Np11, Np12, Np2..Np9, Ns1, Ns10, Ns11, Ns12, Ns2..Ns9, plate_1, plate_2, Np1_Section1, Np2_Section1, Np3_Section1, Np4_Section1, Np5_Section1, Np6_Section1, Np7_Section1, Np8_Section1, Np9_Section1, Np10_Section1, Np11_Section1, Np12_Section1, Ns1_Section1, Ns2_Section1, Ns3_Section1, Ns4_Section1, Ns5_Section1, Ns6_Section1, Ns7_Section1, Ns8_Section1, Ns9_Section1, Ns10_Section1, Ns11_Section1, Ns12_Section1_Separate1
  group core_together_1 = Body1, Body1_1, Body1_2
  group core_together = Body1_3, Body1_4, Body1_5
boundaries and excitations:
  Ns_12: Coil Terminal Objects=Ns11_Section1 Conductor_number=1 Winding=Ns Point_out_of_terminal=true
  Ns_11: Coil Terminal Objects=Ns9_Section1 Conductor_number=1 Winding=Ns Point_out_of_terminal=true
  Ns_10: Coil Terminal Objects=Ns7_Section1 Conductor_number=1 Winding=Ns Point_out_of_terminal=true
  Ns_9: Coil Terminal Objects=Ns5_Section1 Conductor_number=1 Winding=Ns Point_out_of_terminal=true
  Ns_8: Coil Terminal Objects=Ns3_Section1 Conductor_number=1 Winding=Ns Point_out_of_terminal=true
  Ns_7: Coil Terminal Objects=Ns1_Section1 Conductor_number=1 Winding=Ns Point_out_of_terminal=true
  Ns_6: Coil Terminal Objects=Np12_Section1 Conductor_number=1 Winding=Ns Point_out_of_terminal=true
  Ns_5: Coil Terminal Objects=Np10_Section1 Conductor_number=1 Winding=Ns Point_out_of_terminal=true
  Ns_4: Coil Terminal Objects=Np8_Section1 Conductor_number=1 Winding=Ns Point_out_of_terminal=true
  Ns_3: Coil Terminal Objects=Np6_Section1 Conductor_number=1 Winding=Ns Point_out_of_terminal=true
  Ns_2: Coil Terminal Objects=Np4_Section1 Conductor_number=1 Winding=Ns Point_out_of_terminal=true
  Ns_1: Coil Terminal Objects=Np2_Section1 Conductor_number=1 Winding=Ns Point_out_of_terminal=true
  Np_12: Coil Terminal Objects=Np11_Section1 Conductor_number=1 Winding=Np Point_out_of_terminal=false
  Np_11: Coil Terminal Objects=Np9_Section1 Conductor_number=1 Winding=Np Point_out_of_terminal=false
  Np_10: Coil Terminal Objects=Np7_Section1 Conductor_number=1 Winding=Np Point_out_of_terminal=false
  Np_9: Coil Terminal Objects=Ns12_Section1_Separate1 Conductor_number=1 Winding=Np Point_out_of_terminal=false
  Np_8: Coil Terminal Objects=Ns10_Section1 Conductor_number=1 Winding=Np Point_out_of_terminal=false
  Np_7: Coil Terminal Objects=Ns8_Section1 Conductor_number=1 Winding=Np Point_out_of_terminal=false
  Np_6: Coil Terminal Objects=Ns6_Section1 Conductor_number=1 Winding=Np Point_out_of_terminal=false
  Np_5: Coil Terminal Objects=Np5_Section1 Conductor_number=1 Winding=Np Point_out_of_terminal=false
  Np_4: Coil Terminal Objects=Ns4_Section1 Conductor_number=1 Winding=Np Point_out_of_terminal=false
  Np_3: Coil Terminal Objects=Np3_Section1 Conductor_number=1 Winding=Np Point_out_of_terminal=false
  Np_2: Coil Terminal Objects=Ns2_Section1 Conductor_number=1 Winding=Np Point_out_of_terminal=false
  Np_1: Coil Terminal Objects=Np1_Section1 Conductor_number=1 Winding=Np Point_out_of_terminal=false
  Np: Winding Group Type=Current IsSolid=true Current=16.36A ParallelBranchesNum=1 Phase=0deg
  Ns: Winding Group Type=Current IsSolid=true Current=15.96A ParallelBranchesNum=1 Phase=0.1522rad
  eddy effects on: Np1, Np10, Np11, Np12, Np2..Np9, Ns1, Ns10, Ns11, Ns12, Ns2..Ns9, Body1_1, Body1_2, Body1_4, Body1_5
parameters:
  Matrix1: Matrix Np, Ns:
mesh:
  Length1: LengthBased Objects=[plate_2, Np1..Np12, Ns1..Ns12, plate_1] MaxLength=2mm
  Length2: LengthBased Objects=[Body1_1, Body1_2, Body1, Body1_3, Body1_4, Body1_5] MaxLength=5mm
  initial mesh: GlobalSurfApproximation{CurvedSurfaceApproxChoice=UseSlider SliderMeshSettings=9} GlobalCurvilinear{Apply} MeshMethod=AnsoftClassic
setups:
  Setup1: EddyCurrent MaximumPasses=20 MinimumPasses=2 MinimumConvergedPasses=1 PercentRefinement=30 PercentError=1 NonLinearResidual=0.0001 Frequency=28.5kHz LossAdaptiveCtrl=0.5

design 12turns_3D_WindingLoss_NoInterleaving (Maxwell 3D, EddyCurrent, model units mm)
geometry:
  Region [vacuum] = region(percentage_offset=0 on all sides)
  Np1 [copper] = imported_body(C:\Users\karlr\Documents\core_assembled_flatwise_12turns.step)
  Np1_Section1 [copper] = Np1.section(plane=ZX)
  Np10 [copper] = imported_body(C:\Users\karlr\Documents\core_assembled_flatwise_12turns.step)
  Np10_Section1 [copper] = Np10.section(plane=ZX)
  Np11 [copper] = imported_body(C:\Users\karlr\Documents\core_assembled_flatwise_12turns.step)
  Np11_Section1 [copper] = Np11.section(plane=ZX)
  Np12 [copper] = imported_body(C:\Users\karlr\Documents\core_assembled_flatwise_12turns.step)
  Np12_Section1 [copper] = Np12.section(plane=ZX)
  Np2 [copper] = imported_body(C:\Users\karlr\Documents\core_assembled_flatwise_12turns.step)
  Np2_Section1 [copper] = Np2.section(plane=ZX)
  Np3 [copper] = imported_body(C:\Users\karlr\Documents\core_assembled_flatwise_12turns.step)
  Np3_Section1 [copper] = Np3.section(plane=ZX)
  Np4 [copper] = imported_body(C:\Users\karlr\Documents\core_assembled_flatwise_12turns.step)
  Np4_Section1 [copper] = Np4.section(plane=ZX)
  Np5 [copper] = imported_body(C:\Users\karlr\Documents\core_assembled_flatwise_12turns.step)
  Np5_Section1 [copper] = Np5.section(plane=ZX)
  Np6 [copper] = imported_body(C:\Users\karlr\Documents\core_assembled_flatwise_12turns.step)
  Np6_Section1 [copper] = Np6.section(plane=ZX)
  Np7 [copper] = imported_body(C:\Users\karlr\Documents\core_assembled_flatwise_12turns.step)
  Np7_Section1 [copper] = Np7.section(plane=ZX)
  Np8 [copper] = imported_body(C:\Users\karlr\Documents\core_assembled_flatwise_12turns.step)
  Np8_Section1 [copper] = Np8.section(plane=ZX)
  Np9 [copper] = imported_body(C:\Users\karlr\Documents\core_assembled_flatwise_12turns.step)
  Np9_Section1 [copper] = Np9.section(plane=ZX)
  Ns1 [copper] = imported_body(C:\Users\karlr\Documents\core_assembled_flatwise_12turns.step)
  Ns1_Section1 [copper] = Ns1.section(plane=ZX)
  Ns10 [copper] = imported_body(C:\Users\karlr\Documents\core_assembled_flatwise_12turns.step)
  Ns10_Section1 [copper] = Ns10.section(plane=ZX)
  Ns11 [copper] = imported_body(C:\Users\karlr\Documents\core_assembled_flatwise_12turns.step)
  Ns11_Section1 [copper] = Ns11.section(plane=ZX)
  Ns12 [copper] = imported_body(C:\Users\karlr\Documents\core_assembled_flatwise_12turns.step)
  Ns12_Section1 = Ns12.section(plane=ZX)
  Ns2 [copper] = imported_body(C:\Users\karlr\Documents\core_assembled_flatwise_12turns.step)
  Ns2_Section1 [copper] = Ns2.section(plane=ZX)
  Ns3 [copper] = imported_body(C:\Users\karlr\Documents\core_assembled_flatwise_12turns.step)
  Ns3_Section1 [copper] = Ns3.section(plane=ZX)
  Ns4 [copper] = imported_body(C:\Users\karlr\Documents\core_assembled_flatwise_12turns.step)
  Ns4_Section1 [copper] = Ns4.section(plane=ZX)
  Ns5 [copper] = imported_body(C:\Users\karlr\Documents\core_assembled_flatwise_12turns.step)
  Ns5_Section1 [copper] = Ns5.section(plane=ZX)
  Ns6 [copper] = imported_body(C:\Users\karlr\Documents\core_assembled_flatwise_12turns.step)
  Ns6_Section1 [copper] = Ns6.section(plane=ZX)
  Ns7 [copper] = imported_body(C:\Users\karlr\Documents\core_assembled_flatwise_12turns.step)
  Ns7_Section1 [copper] = Ns7.section(plane=ZX)
  Ns8 [copper] = imported_body(C:\Users\karlr\Documents\core_assembled_flatwise_12turns.step)
  Ns8_Section1 [copper] = Ns8.section(plane=ZX)
  Ns9 [copper] = imported_body(C:\Users\karlr\Documents\core_assembled_flatwise_12turns.step)
  Ns9_Section1 [copper] = Ns9.section(plane=ZX)
  plate_1, plate_2 [Al_N] = imported_body(C:\Users\karlr\Documents\core_assembled_flatwise_12turns.step)
  Body1 [ferrite - Copy] = imported_body(C:\Users\karlr\Documents\core_assembled_flatwise_12turns.step)
  Body1_1, Body1_2 [aluminum] = imported_body(C:\Users\karlr\Documents\core_assembled_flatwise_12turns.step)
  Body1_3 [ferrite - Copy] = imported_body(C:\Users\karlr\Documents\core_assembled_flatwise_12turns.step)
  Body1_4, Body1_5 [aluminum] = imported_body(C:\Users\karlr\Documents\core_assembled_flatwise_12turns.step)
  Np1_Section1.separate_bodies()
  Np2_Section1.separate_bodies()
  Np3_Section1.separate_bodies()
  Np4_Section1.separate_bodies()
  Np5_Section1.separate_bodies()
  Np6_Section1.separate_bodies()
  Np7_Section1.separate_bodies()
  Np8_Section1.separate_bodies()
  Np9_Section1.separate_bodies()
  Np10_Section1.separate_bodies()
  Np11_Section1.separate_bodies()
  Np12_Section1.separate_bodies()
  Ns1_Section1.separate_bodies()
  Ns2_Section1.separate_bodies()
  Ns3_Section1.separate_bodies()
  Ns4_Section1.separate_bodies()
  Ns5_Section1.separate_bodies()
  Ns6_Section1.separate_bodies()
  Ns7_Section1.separate_bodies()
  Ns8_Section1.separate_bodies()
  Ns9_Section1.separate_bodies()
  Ns10_Section1.separate_bodies()
  Ns11_Section1.separate_bodies()
  Ns12_Section1_Separate1 [copper] = Ns12_Section1.separate_bodies()
  Ns12_Section1.delete()
  group core_assembled_flatwise = Np1, Np10, Np11, Np12, Np2..Np9, Ns1, Ns10, Ns11, Ns12, Ns2..Ns9, plate_1, plate_2, Np1_Section1, Np2_Section1, Np3_Section1, Np4_Section1, Np5_Section1, Np6_Section1, Np7_Section1, Np8_Section1, Np9_Section1, Np10_Section1, Np11_Section1, Np12_Section1, Ns1_Section1, Ns2_Section1, Ns3_Section1, Ns4_Section1, Ns5_Section1, Ns6_Section1, Ns7_Section1, Ns8_Section1, Ns9_Section1, Ns10_Section1, Ns11_Section1, Ns12_Section1_Separate1
  group core_together_1 = Body1, Body1_1, Body1_2
  group core_together = Body1_3, Body1_4, Body1_5
boundaries and excitations:
  Np_1: Coil Terminal Objects=Np1_Section1 Conductor_number=1 Winding=Np Point_out_of_terminal=false
  Np_2: Coil Terminal Objects=Np2_Section1 Conductor_number=1 Winding=Np Point_out_of_terminal=false
  Np_3: Coil Terminal Objects=Np3_Section1 Conductor_number=1 Winding=Np Point_out_of_terminal=false
  Np_4: Coil Terminal Objects=Np4_Section1 Conductor_number=1 Winding=Np Point_out_of_terminal=false
  Np_5: Coil Terminal Objects=Np5_Section1 Conductor_number=1 Winding=Np Point_out_of_terminal=false
  Np_6: Coil Terminal Objects=Np6_Section1 Conductor_number=1 Winding=Np Point_out_of_terminal=false
  Np_7: Coil Terminal Objects=Ns1_Section1 Conductor_number=1 Winding=Np Point_out_of_terminal=false
  Np_8: Coil Terminal Objects=Ns2_Section1 Conductor_number=1 Winding=Np Point_out_of_terminal=false
  Np_9: Coil Terminal Objects=Ns3_Section1 Conductor_number=1 Winding=Np Point_out_of_terminal=false
  Np_10: Coil Terminal Objects=Ns4_Section1 Conductor_number=1 Winding=Np Point_out_of_terminal=false
  Np_11: Coil Terminal Objects=Ns5_Section1 Conductor_number=1 Winding=Np Point_out_of_terminal=false
  Np_12: Coil Terminal Objects=Ns6_Section1 Conductor_number=1 Winding=Np Point_out_of_terminal=false
  Ns_1: Coil Terminal Objects=Ns12_Section1_Separate1 Conductor_number=1 Winding=Ns Point_out_of_terminal=true
  Ns_2: Coil Terminal Objects=Np7_Section1 Conductor_number=1 Winding=Ns Point_out_of_terminal=true
  Ns_3: Coil Terminal Objects=Np8_Section1 Conductor_number=1 Winding=Ns Point_out_of_terminal=true
  Ns_4: Coil Terminal Objects=Np9_Section1 Conductor_number=1 Winding=Ns Point_out_of_terminal=true
  Ns_5: Coil Terminal Objects=Np10_Section1 Conductor_number=1 Winding=Ns Point_out_of_terminal=true
  Ns_6: Coil Terminal Objects=Np11_Section1 Conductor_number=1 Winding=Ns Point_out_of_terminal=true
  Ns_7: Coil Terminal Objects=Np12_Section1 Conductor_number=1 Winding=Ns Point_out_of_terminal=true
  Ns_8: Coil Terminal Objects=Ns7_Section1 Conductor_number=1 Winding=Ns Point_out_of_terminal=true
  Ns_9: Coil Terminal Objects=Ns8_Section1 Conductor_number=1 Winding=Ns Point_out_of_terminal=true
  Ns_10: Coil Terminal Objects=Ns9_Section1 Conductor_number=1 Winding=Ns Point_out_of_terminal=true
  Ns_11: Coil Terminal Objects=Ns10_Section1 Conductor_number=1 Winding=Ns Point_out_of_terminal=true
  Ns_12: Coil Terminal Objects=Ns11_Section1 Conductor_number=1 Winding=Ns Point_out_of_terminal=true
  Np: Winding Group Type=Current IsSolid=true Current=16.36A ParallelBranchesNum=1 Phase=0rad
  Ns: Winding Group Type=Current IsSolid=true Current=15.96A ParallelBranchesNum=1 Phase=0.1522rad
parameters:
  Matrix1: Matrix Np, Ns:
mesh:
  Length1: LengthBased Objects=[plate_2, Np1..Np12, Ns1..Ns12, plate_1] MaxLength=2mm
  Length2: LengthBased Objects=[Body1_1, Body1_2, Body1, Body1_3, Body1_4, Body1_5] MaxLength=5mm
  initial mesh: GlobalSurfApproximation{CurvedSurfaceApproxChoice=UseSlider SliderMeshSettings=9} GlobalCurvilinear{Apply} MeshMethod=AnsoftClassic
setups:
  Setup1: EddyCurrent MaximumPasses=20 MinimumPasses=2 MinimumConvergedPasses=1 PercentRefinement=30 PercentError=1 NonLinearResidual=0.0001 Frequency=28.5kHz LossAdaptiveCtrl=0.5

design 12turns_3D_CoreLoss_FullInterleaved_tempdependent (Maxwell 3D, EddyCurrent, model units mm)
geometry:
  Np1, Np10, Np11, Np12, Np2..Np9, Ns1, Ns10, Ns11, Ns12, Ns2..Ns9 [copper - tempDependent] = imported_body(C:\Users\karlr\Documents\core_assembled_flatwise_12turns.step)
  plate_1, plate_2 [Al_N] = imported_body(C:\Users\karlr\Documents\core_assembled_flatwise_12turns.step)
  Body1 [ferrite_tempdependent] = imported_body(C:\Users\karlr\Documents\core_assembled_flatwise_12turns.step)
  Body1_1, Body1_2 [aluminum] = imported_body(C:\Users\karlr\Documents\core_assembled_flatwise_12turns.step)
  Body1_3 [ferrite_tempdependent] = imported_body(C:\Users\karlr\Documents\core_assembled_flatwise_12turns.step)
  Body1_4, Body1_5 [aluminum] = imported_body(C:\Users\karlr\Documents\core_assembled_flatwise_12turns.step)
  Np1_Section1 [copper] = Np1.section(plane=ZX)
  Np2_Section1 [copper] = Np2.section(plane=ZX)
  Np3_Section1 [copper] = Np3.section(plane=ZX)
  Np4_Section1 [copper] = Np4.section(plane=ZX)
  Np5_Section1 [copper] = Np5.section(plane=ZX)
  Np6_Section1 [copper] = Np6.section(plane=ZX)
  Np7_Section1 [copper] = Np7.section(plane=ZX)
  Np8_Section1 [copper] = Np8.section(plane=ZX)
  Np9_Section1 [copper] = Np9.section(plane=ZX)
  Np10_Section1 [copper] = Np10.section(plane=ZX)
  Np11_Section1 [copper] = Np11.section(plane=ZX)
  Np12_Section1 [copper] = Np12.section(plane=ZX)
  Ns1_Section1 [copper] = Ns1.section(plane=ZX)
  Ns2_Section1 [copper] = Ns2.section(plane=ZX)
  Ns3_Section1 [copper] = Ns3.section(plane=ZX)
  Ns4_Section1 [copper] = Ns4.section(plane=ZX)
  Ns5_Section1 [copper] = Ns5.section(plane=ZX)
  Ns6_Section1 [copper] = Ns6.section(plane=ZX)
  Ns7_Section1 [copper] = Ns7.section(plane=ZX)
  Ns8_Section1 [copper] = Ns8.section(plane=ZX)
  Ns9_Section1 [copper] = Ns9.section(plane=ZX)
  Ns10_Section1 [copper] = Ns10.section(plane=ZX)
  Ns11_Section1 [copper] = Ns11.section(plane=ZX)
  Ns12_Section1 = Ns12.section(plane=ZX)
  Np1_Section1.separate_bodies()
  Np2_Section1.separate_bodies()
  Np3_Section1.separate_bodies()
  Np4_Section1.separate_bodies()
  Np5_Section1.separate_bodies()
  Np6_Section1.separate_bodies()
  Np7_Section1.separate_bodies()
  Np8_Section1.separate_bodies()
  Np9_Section1.separate_bodies()
  Np10_Section1.separate_bodies()
  Np11_Section1.separate_bodies()
  Np12_Section1.separate_bodies()
  Ns1_Section1.separate_bodies()
  Ns2_Section1.separate_bodies()
  Ns3_Section1.separate_bodies()
  Ns4_Section1.separate_bodies()
  Ns5_Section1.separate_bodies()
  Ns6_Section1.separate_bodies()
  Ns7_Section1.separate_bodies()
  Ns8_Section1.separate_bodies()
  Ns9_Section1.separate_bodies()
  Ns10_Section1.separate_bodies()
  Ns11_Section1.separate_bodies()
  Ns12_Section1_Separate1 [copper] = Ns12_Section1.separate_bodies()
  Ns12_Section1.delete()
  Region [vacuum] = region(percentage_offset=0 on all sides)
  Rectangle1 [non-model] = rectangle(corner=(45.8mm, 22.75mm, 0mm), z_size=20mm, x_size=-45.8mm)
  group core_assembled_flatwise = Np1, Np10, Np11, Np12, Np2..Np9, Ns1, Ns10, Ns11, Ns12, Ns2..Ns9, plate_1, plate_2, Np1_Section1, Np2_Section1, Np3_Section1, Np4_Section1, Np5_Section1, Np6_Section1, Np7_Section1, Np8_Section1, Np9_Section1, Np10_Section1, Np11_Section1, Np12_Section1, Ns1_Section1, Ns2_Section1, Ns3_Section1, Ns4_Section1, Ns5_Section1, Ns6_Section1, Ns7_Section1, Ns8_Section1, Ns9_Section1, Ns10_Section1, Ns11_Section1, Ns12_Section1_Separate1
  group core_together_1 = Body1, Body1_1, Body1_2
  group core_together = Body1_3, Body1_4, Body1_5
boundaries and excitations:
  Np_1: Coil Terminal Objects=Np1_Section1 Conductor_number=1 Winding=Primary Point_out_of_terminal=false
  Np_2: Coil Terminal Objects=Np2_Section1 Conductor_number=1 Winding=Primary Point_out_of_terminal=false
  Np_3: Coil Terminal Objects=Np3_Section1 Conductor_number=1 Winding=Primary Point_out_of_terminal=false
  Np_4: Coil Terminal Objects=Np4_Section1 Conductor_number=1 Winding=Primary Point_out_of_terminal=false
  Np_5: Coil Terminal Objects=Np5_Section1 Conductor_number=1 Winding=Primary Point_out_of_terminal=false
  Np_6: Coil Terminal Objects=Np6_Section1 Conductor_number=1 Winding=Primary Point_out_of_terminal=false
  Np_7: Coil Terminal Objects=Np7_Section1 Conductor_number=1 Winding=Primary Point_out_of_terminal=false
  Np_8: Coil Terminal Objects=Np8_Section1 Conductor_number=1 Winding=Primary Point_out_of_terminal=false
  Np_9: Coil Terminal Objects=Np9_Section1 Conductor_number=1 Winding=Primary Point_out_of_terminal=false
  Np_10: Coil Terminal Objects=Np10_Section1 Conductor_number=1 Winding=Primary Point_out_of_terminal=false
  Np_11: Coil Terminal Objects=Np11_Section1 Conductor_number=1 Winding=Primary Point_out_of_terminal=false
  Np_12: Coil Terminal Objects=Np12_Section1 Conductor_number=1 Winding=Primary Point_out_of_terminal=false
  Ns_1: Coil Terminal Objects=Ns1_Section1 Conductor_number=1 Winding=Winding1 Point_out_of_terminal=true
  Ns_2: Coil Terminal Objects=Ns2_Section1 Conductor_number=1 Winding=Winding1 Point_out_of_terminal=true
  Ns_3: Coil Terminal Objects=Ns3_Section1 Conductor_number=1 Winding=Winding1 Point_out_of_terminal=true
  Ns_4: Coil Terminal Objects=Ns4_Section1 Conductor_number=1 Winding=Winding1 Point_out_of_terminal=true
  Ns_5: Coil Terminal Objects=Ns5_Section1 Conductor_number=1 Winding=Winding1 Point_out_of_terminal=true
  Ns_6: Coil Terminal Objects=Ns6_Section1 Conductor_number=1 Winding=Winding1 Point_out_of_terminal=true
  Ns_7: Coil Terminal Objects=Ns7_Section1 Conductor_number=1 Winding=Winding1 Point_out_of_terminal=true
  Ns_8: Coil Terminal Objects=Ns8_Section1 Conductor_number=1 Winding=Winding1 Point_out_of_terminal=true
  Ns_9: Coil Terminal Objects=Ns9_Section1 Conductor_number=1 Winding=Winding1 Point_out_of_terminal=true
  Ns_10: Coil Terminal Objects=Ns10_Section1 Conductor_number=1 Winding=Winding1 Point_out_of_terminal=true
  Ns_11: Coil Terminal Objects=Ns11_Section1 Conductor_number=1 Winding=Winding1 Point_out_of_terminal=true
  Ns_12: Coil Terminal Objects=Ns12_Section1_Separate1 Conductor_number=1 Winding=Winding1 Point_out_of_terminal=true
  Primary: Winding Group Type=Voltage IsSolid=true Current=0A Resistance=0ohm Inductance=0nH Voltage=141V ParallelBranchesNum=1 Phase=0rad
  Winding1: Winding Group Type=Current IsSolid=true Current=0mA ParallelBranchesNum=1 Phase=0deg
  eddy effects on: Np1, Np10, Np11, Np12, Np2..Np9, Ns1, Ns10, Ns11, Ns12, Ns2..Ns9, Body1_1, Body1_2, Body1_4, Body1_5
  core loss on: Body1, Body1_3
parameters:
  Matrix1: Matrix Primary, Winding1:
mesh:
  Length1: LengthBased Objects=[plate_1, plate_2, Np1..Np12, Ns1..Ns12] MaxLength=2mm
  Length2: LengthBased Objects=[Body1, Body1_1..Body1_5] MaxLength=5mm
  initial mesh: GlobalSurfApproximation{CurvedSurfaceApproxChoice=UseSlider SliderMeshSettings=9} GlobalCurvilinear{Apply} MeshMethod=AnsoftClassic
temperatures:
  Np1, Np10, Np11, Np12, Np2..Np9, Ns1, Ns10, Ns11, Ns12, Ns2..Ns9, plate_1, plate_2, Body1, Body1_1..Body1_5, Np1_Section1, Np2_Section1, Np3_Section1, Np4_Section1, Np5_Section1, Np6_Section1, Np7_Section1, Np8_Section1, Np9_Section1, Np10_Section1, Np11_Section1, Np12_Section1, Ns1_Section1, Ns2_Section1, Ns3_Section1, Ns4_Section1, Ns5_Section1, Ns6_Section1, Ns7_Section1, Ns8_Section1, Ns9_Section1, Ns10_Section1, Ns11_Section1, Ns12_Section1_Separate1, Region: 22cel
setups:
  Setup1: EddyCurrent MaximumPasses=20 MinimumPasses=2 MinimumConvergedPasses=1 PercentRefinement=30 PercentError=1 NonLinearResidual=0.0001 Frequency=28.5kHz LossAdaptiveCtrl=0.5
field plots:
  Mesh1: MeshPlots in Body1_3, Body1 on Setup1 : LastAdaptive at Freq=28.5kHz Phase=0deg
  Mag_B1: B over Body1_3.face(at (22.9, 45.5, 15.325), at (0, 22.75, 15.325), at (22.9, 22.75, 20.35), at (45.8, 22.75, 15.325), at (22.9, 0, 15.325)) Body1.face(at (22.9, 45.5, 5.025), at (0, 22.75, 5.025), at (45.8, 22.75, 5.025), at (22.9, 22.75, 0), at (22.9, 0, 5.025)) on Setup1 : LastAdaptive at Freq=28.5kHz Phase=45deg

design 12turns_3D_WindingLoss_FullInterleaved_tempdependent (Maxwell 3D, EddyCurrent, model units mm)
geometry:
  Np1, Np10, Np11, Np12, Np2..Np9, Ns1, Ns10, Ns11, Ns12, Ns2..Ns9 [copper] = imported_body(C:\Users\karlr\Documents\core_assembled_flatwise_12turns.step)
  plate_1, plate_2 [Al_N] = imported_body(C:\Users\karlr\Documents\core_assembled_flatwise_12turns.step)
  Body1 [ferrite - Copy] = imported_body(C:\Users\karlr\Documents\core_assembled_flatwise_12turns.step)
  Body1_1, Body1_2 [aluminum] = imported_body(C:\Users\karlr\Documents\core_assembled_flatwise_12turns.step)
  Body1_3 [ferrite - Copy] = imported_body(C:\Users\karlr\Documents\core_assembled_flatwise_12turns.step)
  Body1_4, Body1_5 [aluminum] = imported_body(C:\Users\karlr\Documents\core_assembled_flatwise_12turns.step)
  Np1_Section1 [copper] = Np1.section(plane=ZX)
  Np2_Section1 [copper] = Np2.section(plane=ZX)
  Np3_Section1 [copper] = Np3.section(plane=ZX)
  Np4_Section1 [copper] = Np4.section(plane=ZX)
  Np5_Section1 [copper] = Np5.section(plane=ZX)
  Np6_Section1 [copper] = Np6.section(plane=ZX)
  Np7_Section1 [copper] = Np7.section(plane=ZX)
  Np8_Section1 [copper] = Np8.section(plane=ZX)
  Np9_Section1 [copper] = Np9.section(plane=ZX)
  Np10_Section1 [copper] = Np10.section(plane=ZX)
  Np11_Section1 [copper] = Np11.section(plane=ZX)
  Np12_Section1 [copper] = Np12.section(plane=ZX)
  Ns1_Section1 [copper] = Ns1.section(plane=ZX)
  Ns2_Section1 [copper] = Ns2.section(plane=ZX)
  Ns3_Section1 [copper] = Ns3.section(plane=ZX)
  Ns4_Section1 [copper] = Ns4.section(plane=ZX)
  Ns5_Section1 [copper] = Ns5.section(plane=ZX)
  Ns6_Section1 [copper] = Ns6.section(plane=ZX)
  Ns7_Section1 [copper] = Ns7.section(plane=ZX)
  Ns8_Section1 [copper] = Ns8.section(plane=ZX)
  Ns9_Section1 [copper] = Ns9.section(plane=ZX)
  Ns10_Section1 [copper] = Ns10.section(plane=ZX)
  Ns11_Section1 [copper] = Ns11.section(plane=ZX)
  Ns12_Section1 = Ns12.section(plane=ZX)
  Np1_Section1.separate_bodies()
  Np2_Section1.separate_bodies()
  Np3_Section1.separate_bodies()
  Np4_Section1.separate_bodies()
  Np5_Section1.separate_bodies()
  Np6_Section1.separate_bodies()
  Np7_Section1.separate_bodies()
  Np8_Section1.separate_bodies()
  Np9_Section1.separate_bodies()
  Np10_Section1.separate_bodies()
  Np11_Section1.separate_bodies()
  Np12_Section1.separate_bodies()
  Ns1_Section1.separate_bodies()
  Ns2_Section1.separate_bodies()
  Ns3_Section1.separate_bodies()
  Ns4_Section1.separate_bodies()
  Ns5_Section1.separate_bodies()
  Ns6_Section1.separate_bodies()
  Ns7_Section1.separate_bodies()
  Ns8_Section1.separate_bodies()
  Ns9_Section1.separate_bodies()
  Ns10_Section1.separate_bodies()
  Ns11_Section1.separate_bodies()
  Ns12_Section1_Separate1 [copper] = Ns12_Section1.separate_bodies()
  Ns12_Section1.delete()
  Region [vacuum] = region(percentage_offset=0 on all sides)
  Rectangle1 [non-model] = rectangle(corner=(45.8mm, 22.75mm, 0mm), z_size=20mm, x_size=-45.8mm)
  group core_assembled_flatwise = Np1, Np10, Np11, Np12, Np2..Np9, Ns1, Ns10, Ns11, Ns12, Ns2..Ns9, plate_1, plate_2, Np1_Section1, Np2_Section1, Np3_Section1, Np4_Section1, Np5_Section1, Np6_Section1, Np7_Section1, Np8_Section1, Np9_Section1, Np10_Section1, Np11_Section1, Np12_Section1, Ns1_Section1, Ns2_Section1, Ns3_Section1, Ns4_Section1, Ns5_Section1, Ns6_Section1, Ns7_Section1, Ns8_Section1, Ns9_Section1, Ns10_Section1, Ns11_Section1, Ns12_Section1_Separate1
  group core_together_1 = Body1, Body1_1, Body1_2
  group core_together = Body1_3, Body1_4, Body1_5
boundaries and excitations:
  Np_1: Coil Terminal Objects=Np1_Section1 Conductor_number=1 Winding=Primary Point_out_of_terminal=false
  Np_2: Coil Terminal Objects=Np2_Section1 Conductor_number=1 Winding=Primary Point_out_of_terminal=false
  Np_3: Coil Terminal Objects=Np3_Section1 Conductor_number=1 Winding=Primary Point_out_of_terminal=false
  Np_4: Coil Terminal Objects=Np4_Section1 Conductor_number=1 Winding=Primary Point_out_of_terminal=false
  Np_5: Coil Terminal Objects=Np5_Section1 Conductor_number=1 Winding=Primary Point_out_of_terminal=false
  Np_6: Coil Terminal Objects=Np6_Section1 Conductor_number=1 Winding=Primary Point_out_of_terminal=false
  Np_7: Coil Terminal Objects=Np7_Section1 Conductor_number=1 Winding=Primary Point_out_of_terminal=false
  Np_8: Coil Terminal Objects=Np8_Section1 Conductor_number=1 Winding=Primary Point_out_of_terminal=false
  Np_9: Coil Terminal Objects=Np9_Section1 Conductor_number=1 Winding=Primary Point_out_of_terminal=false
  Np_10: Coil Terminal Objects=Np10_Section1 Conductor_number=1 Winding=Primary Point_out_of_terminal=false
  Np_11: Coil Terminal Objects=Np11_Section1 Conductor_number=1 Winding=Primary Point_out_of_terminal=false
  Np_12: Coil Terminal Objects=Np12_Section1 Conductor_number=1 Winding=Primary Point_out_of_terminal=false
  Ns_1: Coil Terminal Objects=Ns1_Section1 Conductor_number=1 Winding=Secondary Point_out_of_terminal=true
  Ns_2: Coil Terminal Objects=Ns2_Section1 Conductor_number=1 Winding=Secondary Point_out_of_terminal=true
  Ns_3: Coil Terminal Objects=Ns3_Section1 Conductor_number=1 Winding=Secondary Point_out_of_terminal=true
  Ns_4: Coil Terminal Objects=Ns4_Section1 Conductor_number=1 Winding=Secondary Point_out_of_terminal=true
  Ns_5: Coil Terminal Objects=Ns5_Section1 Conductor_number=1 Winding=Secondary Point_out_of_terminal=true
  Ns_6: Coil Terminal Objects=Ns6_Section1 Conductor_number=1 Winding=Secondary Point_out_of_terminal=true
  Ns_7: Coil Terminal Objects=Ns7_Section1 Conductor_number=1 Winding=Secondary Point_out_of_terminal=true
  Ns_8: Coil Terminal Objects=Ns8_Section1 Conductor_number=1 Winding=Secondary Point_out_of_terminal=true
  Ns_9: Coil Terminal Objects=Ns9_Section1 Conductor_number=1 Winding=Secondary Point_out_of_terminal=true
  Ns_10: Coil Terminal Objects=Ns10_Section1 Conductor_number=1 Winding=Secondary Point_out_of_terminal=true
  Ns_11: Coil Terminal Objects=Ns11_Section1 Conductor_number=1 Winding=Secondary Point_out_of_terminal=true
  Ns_12: Coil Terminal Objects=Ns12_Section1_Separate1 Conductor_number=1 Winding=Secondary Point_out_of_terminal=true
  Primary: Winding Group Type=Current IsSolid=true Current=16.36A ParallelBranchesNum=1 Phase=0rad
  Secondary: Winding Group Type=Current IsSolid=true Current=15.96A ParallelBranchesNum=1 Phase=0.1522rad
  eddy effects on: Np1, Np10, Np11, Np12, Np2..Np9, Ns1, Ns10, Ns11, Ns12, Ns2..Ns9, Body1_1, Body1_2, Body1_4, Body1_5
parameters:
  Matrix1: Matrix Primary, Secondary:
mesh:
  Length1: LengthBased Objects=[plate_1, plate_2, Np1..Np12, Ns1..Ns12] MaxLength=2mm
  Length2: LengthBased Objects=[Body1, Body1_1..Body1_5] MaxLength=5mm
  initial mesh: GlobalSurfApproximation{CurvedSurfaceApproxChoice=UseSlider SliderMeshSettings=9} GlobalCurvilinear{Apply} MeshMethod=AnsoftClassic
temperatures:
  Np1, Np10, Np11, Np12, Np2..Np9, Ns1, Ns10, Ns11, Ns12, Ns2..Ns9, plate_1, plate_2, Body1, Body1_1..Body1_5, Np1_Section1, Np2_Section1, Np3_Section1, Np4_Section1, Np5_Section1, Np6_Section1, Np7_Section1, Np8_Section1, Np9_Section1, Np10_Section1, Np11_Section1, Np12_Section1, Ns1_Section1, Ns2_Section1, Ns3_Section1, Ns4_Section1, Ns5_Section1, Ns6_Section1, Ns7_Section1, Ns8_Section1, Ns9_Section1, Ns10_Section1, Ns11_Section1, Ns12_Section1_Separate1, Region: 22cel
setups:
  Setup1: EddyCurrent MaximumPasses=20 MinimumPasses=2 MinimumConvergedPasses=1 PercentRefinement=30 PercentError=1 NonLinearResidual=0.0001 Frequency=28.5kHz LossAdaptiveCtrl=0.5
field plots:
  Mesh1: MeshPlots in Body1_3, Body1 on Setup1 : LastAdaptive at Freq=28.5kHz Phase=0deg
  Mag_B1: B over Body1_3.face(at (22.9, 45.5, 15.325), at (0, 22.75, 15.325), at (22.9, 22.75, 20.35), at (45.8, 22.75, 15.325), at (22.9, 0, 15.325)) Body1.face(at (22.9, 45.5, 5.025), at (0, 22.75, 5.025), at (45.8, 22.75, 5.025), at (22.9, 22.75, 0), at (22.9, 0, 5.025)) on Setup1 : LastAdaptive at Freq=28.5kHz Phase=45deg

design 12turns_3D_Thermal_FullInterleaved_Edgewise (Maxwell 3D, EddyCurrent, model units mm)
geometry:
  Np1, Np10, Np11, Np12, Np2..Np9, Ns1, Ns10, Ns11, Ns12, Ns2..Ns9 [copper] = imported_body(C:\Users\karlr\Documents\core_assembled_edgewise v3again.step)
  plate1, plate2 [Al_N] = imported_body(C:\Users\karlr\Documents\core_assembled_edgewise v3again.step)
  Body1 [ferrite - Copy] = imported_body(C:\Users\karlr\Documents\core_assembled_edgewise v3again.step)
  Body1_1, Body1_2 [aluminum] = imported_body(C:\Users\karlr\Documents\core_assembled_edgewise v3again.step)
  Body1_3 [ferrite - Copy] = imported_body(C:\Users\karlr\Documents\core_assembled_edgewise v3again.step)
  Body1_4, Body1_5 [aluminum] = imported_body(C:\Users\karlr\Documents\core_assembled_edgewise v3again.step)
  Np1_Section1 [copper] = Np1.section(plane=ZX)
  Np2_Section1 [copper] = Np2.section(plane=ZX)
  Np3_Section1 [copper] = Np3.section(plane=ZX)
  Np4_Section1 [copper] = Np4.section(plane=ZX)
  Np5_Section1 [copper] = Np5.section(plane=ZX)
  Np6_Section1 [copper] = Np6.section(plane=ZX)
  Np7_Section1 [copper] = Np7.section(plane=ZX)
  Np8_Section1 [copper] = Np8.section(plane=ZX)
  Np9_Section1 [copper] = Np9.section(plane=ZX)
  Np10_Section1 [copper] = Np10.section(plane=ZX)
  Np11_Section1 [copper] = Np11.section(plane=ZX)
  Np12_Section1 [copper] = Np12.section(plane=ZX)
  Ns1_Section1 [copper] = Ns1.section(plane=ZX)
  Ns2_Section1 [copper] = Ns2.section(plane=ZX)
  Ns3_Section1 [copper] = Ns3.section(plane=ZX)
  Ns4_Section1 [copper] = Ns4.section(plane=ZX)
  Ns5_Section1 [copper] = Ns5.section(plane=ZX)
  Ns6_Section1 [copper] = Ns6.section(plane=ZX)
  Ns7_Section1 [copper] = Ns7.section(plane=ZX)
  Ns8_Section1 [copper] = Ns8.section(plane=ZX)
  Ns9_Section1 [copper] = Ns9.section(plane=ZX)
  Ns10_Section1 [copper] = Ns10.section(plane=ZX)
  Ns11_Section1 [copper] = Ns11.section(plane=ZX)
  Ns12_Section1 [copper] = Ns12.section(plane=ZX)
  Np1_Section1.separate_bodies()
  Np2_Section1.separate_bodies()
  Np3_Section1.separate_bodies()
  Np4_Section1.separate_bodies()
  Np5_Section1.separate_bodies()
  Np6_Section1.separate_bodies()
  Np7_Section1.separate_bodies()
  Np8_Section1.separate_bodies()
  Np9_Section1.separate_bodies()
  Np10_Section1.separate_bodies()
  Np11_Section1.separate_bodies()
  Np12_Section1.separate_bodies()
  Ns1_Section1.separate_bodies()
  Ns2_Section1.separate_bodies()
  Ns3_Section1.separate_bodies()
  Ns4_Section1.separate_bodies()
  Ns5_Section1.separate_bodies()
  Ns6_Section1.separate_bodies()
  Ns7_Section1.separate_bodies()
  Ns8_Section1.separate_bodies()
  Ns9_Section1.separate_bodies()
  Ns10_Section1.separate_bodies()
  Ns11_Section1.separate_bodies()
  Ns12_Section1.separate_bodies()
  Region [vacuum] = region(percentage_offset=0 on all sides)
  group core_assembled_edgewise = Np1, Np10, Np11, Np12, Np2..Np9, Ns1, Ns10, Ns11, Ns12, Ns2..Ns9, plate1, plate2, Np1_Section1, Np2_Section1, Np3_Section1, Np4_Section1, Np5_Section1, Np6_Section1, Np7_Section1, Np8_Section1, Np9_Section1, Np10_Section1, Np11_Section1, Np12_Section1, Ns1_Section1, Ns2_Section1, Ns3_Section1, Ns4_Section1, Ns5_Section1, Ns6_Section1, Ns7_Section1, Ns8_Section1, Ns9_Section1, Ns10_Section1, Ns11_Section1, Ns12_Section1
  group core_together_1 = Body1, Body1_1, Body1_2
  group core_together = Body1_3, Body1_4, Body1_5
boundaries and excitations:
  CoilTerminal_1: Coil Terminal Objects=Np1_Section1 Conductor_number=1 Winding=Pri Point_out_of_terminal=false
  CoilTerminal_2: Coil Terminal Objects=Np2_Section1 Conductor_number=1 Winding=Pri Point_out_of_terminal=false
  CoilTerminal_3: Coil Terminal Objects=Np3_Section1 Conductor_number=1 Winding=Pri Point_out_of_terminal=false
  CoilTerminal_4: Coil Terminal Objects=Np4_Section1 Conductor_number=1 Winding=Pri Point_out_of_terminal=false
  CoilTerminal_5: Coil Terminal Objects=Np5_Section1 Conductor_number=1 Winding=Pri Point_out_of_terminal=false
  CoilTerminal_6: Coil Terminal Objects=Np6_Section1 Conductor_number=1 Winding=Pri Point_out_of_terminal=false
  CoilTerminal_7: Coil Terminal Objects=Np7_Section1 Conductor_number=1 Winding=Pri Point_out_of_terminal=false
  CoilTerminal_8: Coil Terminal Objects=Np8_Section1 Conductor_number=1 Winding=Pri Point_out_of_terminal=false
  CoilTerminal_9: Coil Terminal Objects=Np9_Section1 Conductor_number=1 Winding=Pri Point_out_of_terminal=false
  CoilTerminal_10: Coil Terminal Objects=Np10_Section1 Conductor_number=1 Winding=Pri Point_out_of_terminal=false
  CoilTerminal_11: Coil Terminal Objects=Np11_Section1 Conductor_number=1 Winding=Pri Point_out_of_terminal=false
  CoilTerminal_12: Coil Terminal Objects=Np12_Section1 Conductor_number=1 Winding=Pri Point_out_of_terminal=false
  CoilTerminal_13: Coil Terminal Objects=Ns1_Section1 Conductor_number=1 Winding=Sec Point_out_of_terminal=true
  CoilTerminal_14: Coil Terminal Objects=Ns2_Section1 Conductor_number=1 Winding=Sec Point_out_of_terminal=true
  CoilTerminal_15: Coil Terminal Objects=Ns3_Section1 Conductor_number=1 Winding=Sec Point_out_of_terminal=true
  CoilTerminal_16: Coil Terminal Objects=Ns4_Section1 Conductor_number=1 Winding=Sec Point_out_of_terminal=true
  CoilTerminal_17: Coil Terminal Objects=Ns5_Section1 Conductor_number=1 Winding=Sec Point_out_of_terminal=true
  CoilTerminal_18: Coil Terminal Objects=Ns6_Section1 Conductor_number=1 Winding=Sec Point_out_of_terminal=true
  CoilTerminal_19: Coil Terminal Objects=Ns7_Section1 Conductor_number=1 Winding=Sec Point_out_of_terminal=true
  CoilTerminal_20: Coil Terminal Objects=Ns8_Section1 Conductor_number=1 Winding=Sec Point_out_of_terminal=true
  CoilTerminal_21: Coil Terminal Objects=Ns9_Section1 Conductor_number=1 Winding=Sec Point_out_of_terminal=true
  CoilTerminal_22: Coil Terminal Objects=Ns10_Section1 Conductor_number=1 Winding=Sec Point_out_of_terminal=true
  CoilTerminal_23: Coil Terminal Objects=Ns11_Section1 Conductor_number=1 Winding=Sec Point_out_of_terminal=true
  CoilTerminal_24: Coil Terminal Objects=Ns12_Section1 Conductor_number=1 Winding=Sec Point_out_of_terminal=true
  Pri: Winding Group Type=Voltage IsSolid=true Current=0mA Resistance=0ohm Inductance=0nH Voltage=141V ParallelBranchesNum=1 Phase=0deg
  Sec: Winding Group Type=Current IsSolid=true Current=0mA ParallelBranchesNum=1 Phase=0deg
  eddy effects on: Np1, Np10, Np11, Np12, Np2..Np9, Ns1, Ns10, Ns11, Ns12, Ns2..Ns9, Body1_1, Body1_2, Body1_4, Body1_5
  core loss on: Body1, Body1_3
parameters:
  Matrix1: Matrix Pri, Sec:
mesh:
  Length1: LengthBased Objects=[plate1, plate2, Np1..Np12, Ns1..Ns12] MaxLength=2mm
  Length2: LengthBased Objects=[Body1_4, Body1_5, Body1_3, Body1_1, Body1_2, Body1] MaxLength=5mm
  initial mesh: GlobalSurfApproximation{CurvedSurfaceApproxChoice=UseSlider SliderMeshSettings=9} GlobalCurvilinear{Apply} MeshMethod=AnsoftClassic
setups:
  Setup1: EddyCurrent MaximumPasses=20 MinimumPasses=2 MinimumConvergedPasses=1 PercentRefinement=30 PercentError=1 NonLinearResidual=0.0001 Frequency=28.5kHz LossAdaptiveCtrl=0.5

design 12turns_3D_Thermal_FullInterleaved_Edgewise_winding (Maxwell 3D, EddyCurrent, model units mm)
geometry:
  Np1, Np10, Np11, Np12, Np2..Np9, Ns1, Ns10, Ns11, Ns12, Ns2..Ns9 [copper] = imported_body(C:\Users\karlr\Documents\core_assembled_edgewise v3again.step)
  plate1, plate2 [Al_N] = imported_body(C:\Users\karlr\Documents\core_assembled_edgewise v3again.step)
  Body1 [ferrite - Copy] = imported_body(C:\Users\karlr\Documents\core_assembled_edgewise v3again.step)
  Body1_1, Body1_2 [aluminum] = imported_body(C:\Users\karlr\Documents\core_assembled_edgewise v3again.step)
  Body1_3 [ferrite - Copy] = imported_body(C:\Users\karlr\Documents\core_assembled_edgewise v3again.step)
  Body1_4, Body1_5 [aluminum] = imported_body(C:\Users\karlr\Documents\core_assembled_edgewise v3again.step)
  Np1_Section1 [copper] = Np1.section(plane=ZX)
  Np2_Section1 [copper] = Np2.section(plane=ZX)
  Np3_Section1 [copper] = Np3.section(plane=ZX)
  Np4_Section1 [copper] = Np4.section(plane=ZX)
  Np5_Section1 [copper] = Np5.section(plane=ZX)
  Np6_Section1 [copper] = Np6.section(plane=ZX)
  Np7_Section1 [copper] = Np7.section(plane=ZX)
  Np8_Section1 [copper] = Np8.section(plane=ZX)
  Np9_Section1 [copper] = Np9.section(plane=ZX)
  Np10_Section1 [copper] = Np10.section(plane=ZX)
  Np11_Section1 [copper] = Np11.section(plane=ZX)
  Np12_Section1 [copper] = Np12.section(plane=ZX)
  Ns1_Section1 [copper] = Ns1.section(plane=ZX)
  Ns2_Section1 [copper] = Ns2.section(plane=ZX)
  Ns3_Section1 [copper] = Ns3.section(plane=ZX)
  Ns4_Section1 [copper] = Ns4.section(plane=ZX)
  Ns5_Section1 [copper] = Ns5.section(plane=ZX)
  Ns6_Section1 [copper] = Ns6.section(plane=ZX)
  Ns7_Section1 [copper] = Ns7.section(plane=ZX)
  Ns8_Section1 [copper] = Ns8.section(plane=ZX)
  Ns9_Section1 [copper] = Ns9.section(plane=ZX)
  Ns10_Section1 [copper] = Ns10.section(plane=ZX)
  Ns11_Section1 [copper] = Ns11.section(plane=ZX)
  Ns12_Section1 [copper] = Ns12.section(plane=ZX)
  Np1_Section1.separate_bodies()
  Np2_Section1.separate_bodies()
  Np3_Section1.separate_bodies()
  Np4_Section1.separate_bodies()
  Np5_Section1.separate_bodies()
  Np6_Section1.separate_bodies()
  Np7_Section1.separate_bodies()
  Np8_Section1.separate_bodies()
  Np9_Section1.separate_bodies()
  Np10_Section1.separate_bodies()
  Np11_Section1.separate_bodies()
  Np12_Section1.separate_bodies()
  Ns1_Section1.separate_bodies()
  Ns2_Section1.separate_bodies()
  Ns3_Section1.separate_bodies()
  Ns4_Section1.separate_bodies()
  Ns5_Section1.separate_bodies()
  Ns6_Section1.separate_bodies()
  Ns7_Section1.separate_bodies()
  Ns8_Section1.separate_bodies()
  Ns9_Section1.separate_bodies()
  Ns10_Section1.separate_bodies()
  Ns11_Section1.separate_bodies()
  Ns12_Section1.separate_bodies()
  Region [vacuum] = region(percentage_offset=0 on all sides)
  group core_assembled_edgewise = Np1, Np10, Np11, Np12, Np2..Np9, Ns1, Ns10, Ns11, Ns12, Ns2..Ns9, plate1, plate2, Np1_Section1, Np2_Section1, Np3_Section1, Np4_Section1, Np5_Section1, Np6_Section1, Np7_Section1, Np8_Section1, Np9_Section1, Np10_Section1, Np11_Section1, Np12_Section1, Ns1_Section1, Ns2_Section1, Ns3_Section1, Ns4_Section1, Ns5_Section1, Ns6_Section1, Ns7_Section1, Ns8_Section1, Ns9_Section1, Ns10_Section1, Ns11_Section1, Ns12_Section1
  group core_together_1 = Body1, Body1_1, Body1_2
  group core_together = Body1_3, Body1_4, Body1_5
boundaries and excitations:
  CoilTerminal_1: Coil Terminal Objects=Np1_Section1 Conductor_number=1 Winding=Pri Point_out_of_terminal=false
  CoilTerminal_2: Coil Terminal Objects=Np2_Section1 Conductor_number=1 Winding=Pri Point_out_of_terminal=false
  CoilTerminal_3: Coil Terminal Objects=Np3_Section1 Conductor_number=1 Winding=Pri Point_out_of_terminal=false
  CoilTerminal_4: Coil Terminal Objects=Np4_Section1 Conductor_number=1 Winding=Pri Point_out_of_terminal=false
  CoilTerminal_5: Coil Terminal Objects=Np5_Section1 Conductor_number=1 Winding=Pri Point_out_of_terminal=false
  CoilTerminal_6: Coil Terminal Objects=Np6_Section1 Conductor_number=1 Winding=Pri Point_out_of_terminal=false
  CoilTerminal_7: Coil Terminal Objects=Np7_Section1 Conductor_number=1 Winding=Pri Point_out_of_terminal=false
  CoilTerminal_8: Coil Terminal Objects=Np8_Section1 Conductor_number=1 Winding=Pri Point_out_of_terminal=false
  CoilTerminal_9: Coil Terminal Objects=Np9_Section1 Conductor_number=1 Winding=Pri Point_out_of_terminal=false
  CoilTerminal_10: Coil Terminal Objects=Np10_Section1 Conductor_number=1 Winding=Pri Point_out_of_terminal=false
  CoilTerminal_11: Coil Terminal Objects=Np11_Section1 Conductor_number=1 Winding=Pri Point_out_of_terminal=false
  CoilTerminal_12: Coil Terminal Objects=Np12_Section1 Conductor_number=1 Winding=Pri Point_out_of_terminal=false
  CoilTerminal_13: Coil Terminal Objects=Ns1_Section1 Conductor_number=1 Winding=Sec Point_out_of_terminal=true
  CoilTerminal_14: Coil Terminal Objects=Ns2_Section1 Conductor_number=1 Winding=Sec Point_out_of_terminal=true
  CoilTerminal_15: Coil Terminal Objects=Ns3_Section1 Conductor_number=1 Winding=Sec Point_out_of_terminal=true
  CoilTerminal_16: Coil Terminal Objects=Ns4_Section1 Conductor_number=1 Winding=Sec Point_out_of_terminal=true
  CoilTerminal_17: Coil Terminal Objects=Ns5_Section1 Conductor_number=1 Winding=Sec Point_out_of_terminal=true
  CoilTerminal_18: Coil Terminal Objects=Ns6_Section1 Conductor_number=1 Winding=Sec Point_out_of_terminal=true
  CoilTerminal_19: Coil Terminal Objects=Ns7_Section1 Conductor_number=1 Winding=Sec Point_out_of_terminal=true
  CoilTerminal_20: Coil Terminal Objects=Ns8_Section1 Conductor_number=1 Winding=Sec Point_out_of_terminal=true
  CoilTerminal_21: Coil Terminal Objects=Ns9_Section1 Conductor_number=1 Winding=Sec Point_out_of_terminal=true
  CoilTerminal_22: Coil Terminal Objects=Ns10_Section1 Conductor_number=1 Winding=Sec Point_out_of_terminal=true
  CoilTerminal_23: Coil Terminal Objects=Ns11_Section1 Conductor_number=1 Winding=Sec Point_out_of_terminal=true
  CoilTerminal_24: Coil Terminal Objects=Ns12_Section1 Conductor_number=1 Winding=Sec Point_out_of_terminal=true
  Pri: Winding Group Type=Current IsSolid=true Current=16.36A ParallelBranchesNum=1 Phase=0deg
  Sec: Winding Group Type=Current IsSolid=true Current=15.96A ParallelBranchesNum=1 Phase=0.1522rad
  eddy effects on: Np1, Np10, Np11, Np12, Np2..Np9, Ns1, Ns10, Ns11, Ns12, Ns2..Ns9, Body1_1, Body1_2, Body1_4, Body1_5
parameters:
  Matrix1: Matrix Pri, Sec:
mesh:
  Length1: LengthBased Objects=[plate1, plate2, Np1..Np12, Ns1..Ns12] MaxLength=2mm
  Length2: LengthBased Objects=[Body1_4, Body1_5, Body1_3, Body1_1, Body1_2, Body1] MaxLength=5mm
  initial mesh: GlobalSurfApproximation{CurvedSurfaceApproxChoice=UseSlider SliderMeshSettings=9} GlobalCurvilinear{Apply} MeshMethod=AnsoftClassic
setups:
  Setup1: EddyCurrent MaximumPasses=20 MinimumPasses=2 MinimumConvergedPasses=1 PercentRefinement=30 PercentError=1 NonLinearResidual=0.0001 Frequency=28.5kHz LossAdaptiveCtrl=0.5

design 12turns_3D_CoreLoss_FullInterleaved_FLATWISE_TIMSIDE (Maxwell 3D, EddyCurrent, model units mm)
geometry:
  Region [vacuum] = region(percentage_offset=0 on all sides)
  Np1, Np10, Np11, Np12, Np2..Np9, Ns1, Ns10, Ns11, Ns12, Ns2..Ns9 [copper] = imported_body(C:\Users\karlr\Documents\core_flatwise_TIMSIDE.step)
  SIDE1, SIDE1_1 [Al_N] = imported_body(C:\Users\karlr\Documents\core_flatwise_TIMSIDE.step)
  SIDE1_2 = imported_body(C:\Users\karlr\Documents\core_flatwise_TIMSIDE.step)
  SIDE1_3 [Al_N] = imported_body(C:\Users\karlr\Documents\core_flatwise_TIMSIDE.step)
  SIDE1_4, SIDE1_5 = imported_body(C:\Users\karlr\Documents\core_flatwise_TIMSIDE.step)
  Body1 [ferrite - Copy] = imported_body(C:\Users\karlr\Documents\core_flatwise_TIMSIDE.step)
  Body1_1, Body1_2 [aluminum] = imported_body(C:\Users\karlr\Documents\core_flatwise_TIMSIDE.step)
  Body1_3 [ferrite - Copy] = imported_body(C:\Users\karlr\Documents\core_flatwise_TIMSIDE.step)
  Body1_4, Body1_5 [aluminum] = imported_body(C:\Users\karlr\Documents\core_flatwise_TIMSIDE.step)
  SIDE1_3.unite(SIDE1_4, SIDE1_5, SIDE1_2)
  Np1_Section1 [copper] = Np1.section(plane=ZX)
  Np2_Section1 [copper] = Np2.section(plane=ZX)
  Np3_Section1 [copper] = Np3.section(plane=ZX)
  Np4_Section1 [copper] = Np4.section(plane=ZX)
  Np5_Section1 [copper] = Np5.section(plane=ZX)
  Np6_Section1 [copper] = Np6.section(plane=ZX)
  Np7_Section1 [copper] = Np7.section(plane=ZX)
  Np8_Section1 [copper] = Np8.section(plane=ZX)
  Np9_Section1 [copper] = Np9.section(plane=ZX)
  Np10_Section1 [copper] = Np10.section(plane=ZX)
  Np11_Section1 [copper] = Np11.section(plane=ZX)
  Np12_Section1 [copper] = Np12.section(plane=ZX)
  Ns1_Section1 [copper] = Ns1.section(plane=ZX)
  Ns2_Section1 [copper] = Ns2.section(plane=ZX)
  Ns3_Section1 [copper] = Ns3.section(plane=ZX)
  Ns4_Section1 [copper] = Ns4.section(plane=ZX)
  Ns5_Section1 [copper] = Ns5.section(plane=ZX)
  Ns6_Section1 [copper] = Ns6.section(plane=ZX)
  Ns7_Section1 [copper] = Ns7.section(plane=ZX)
  Ns8_Section1 [copper] = Ns8.section(plane=ZX)
  Ns9_Section1 [copper] = Ns9.section(plane=ZX)
  Ns10_Section1 [copper] = Ns10.section(plane=ZX)
  Ns11_Section1 [copper] = Ns11.section(plane=ZX)
  Ns12_Section1 = Ns12.section(plane=ZX)
  Np1_Section1.separate_bodies()
  Np2_Section1.separate_bodies()
  Np3_Section1.separate_bodies()
  Np4_Section1.separate_bodies()
  Np5_Section1.separate_bodies()
  Np6_Section1.separate_bodies()
  Np7_Section1.separate_bodies()
  Np8_Section1.separate_bodies()
  Np9_Section1.separate_bodies()
  Np10_Section1.separate_bodies()
  Np11_Section1.separate_bodies()
  Np12_Section1.separate_bodies()
  Ns1_Section1.separate_bodies()
  Ns2_Section1.separate_bodies()
  Ns3_Section1.separate_bodies()
  Ns4_Section1.separate_bodies()
  Ns5_Section1.separate_bodies()
  Ns6_Section1.separate_bodies()
  Ns7_Section1.separate_bodies()
  Ns8_Section1.separate_bodies()
  Ns9_Section1.separate_bodies()
  Ns10_Section1.separate_bodies()
  Ns11_Section1.separate_bodies()
  Ns12_Section1_Separate1 [copper] = Ns12_Section1.separate_bodies()
  Ns12_Section1.delete()
  group core_assembled_flatwise = Np1, Np10, Np11, Np12, Np2..Np9, Ns1, Ns10, Ns11, Ns12, Ns2..Ns9, SIDE1, SIDE1_1, SIDE1_3, Np1_Section1, Np2_Section1, Np3_Section1, Np4_Section1, Np5_Section1, Np6_Section1, Np7_Section1, Np8_Section1, Np9_Section1, Np10_Section1, Np11_Section1, Np12_Section1, Ns1_Section1, Ns2_Section1, Ns3_Section1, Ns4_Section1, Ns5_Section1, Ns6_Section1, Ns7_Section1, Ns8_Section1, Ns9_Section1, Ns10_Section1, Ns11_Section1, Ns12_Section1_Separate1
  group core_together_1 = Body1, Body1_1, Body1_2
  group core_together = Body1_3, Body1_4, Body1_5
boundaries and excitations:
  Np_1: Coil Terminal Objects=Np1_Section1 Conductor_number=1 Winding=Np Point_out_of_terminal=false
  Np_2: Coil Terminal Objects=Np2_Section1 Conductor_number=1 Winding=Np Point_out_of_terminal=false
  Np_3: Coil Terminal Objects=Np3_Section1 Conductor_number=1 Winding=Np Point_out_of_terminal=false
  Np_4: Coil Terminal Objects=Np4_Section1 Conductor_number=1 Winding=Np Point_out_of_terminal=false
  Np_5: Coil Terminal Objects=Np5_Section1 Conductor_number=1 Winding=Np Point_out_of_terminal=false
  Np_6: Coil Terminal Objects=Np6_Section1 Conductor_number=1 Winding=Np Point_out_of_terminal=false
  Np_7: Coil Terminal Objects=Np7_Section1 Conductor_number=1 Winding=Np Point_out_of_terminal=false
  Np_8: Coil Terminal Objects=Np8_Section1 Conductor_number=1 Winding=Np Point_out_of_terminal=false
  Np_9: Coil Terminal Objects=Np9_Section1 Conductor_number=1 Winding=Np Point_out_of_terminal=false
  Np_10: Coil Terminal Objects=Np10_Section1 Conductor_number=1 Winding=Np Point_out_of_terminal=false
  Np_11: Coil Terminal Objects=Np11_Section1 Conductor_number=1 Winding=Np Point_out_of_terminal=false
  Np_12: Coil Terminal Objects=Np12_Section1 Conductor_number=1 Winding=Np Point_out_of_terminal=false
  Nd_1: Coil Terminal Objects=Ns1_Section1 Conductor_number=1 Winding=Ns Point_out_of_terminal=true
  Nd_2: Coil Terminal Objects=Ns2_Section1 Conductor_number=1 Winding=Ns Point_out_of_terminal=true
  Nd_3: Coil Terminal Objects=Ns3_Section1 Conductor_number=1 Winding=Ns Point_out_of_terminal=true
  Nd_4: Coil Terminal Objects=Ns4_Section1 Conductor_number=1 Winding=Ns Point_out_of_terminal=true
  Nd_5: Coil Terminal Objects=Ns5_Section1 Conductor_number=1 Winding=Ns Point_out_of_terminal=true
  Nd_6: Coil Terminal Objects=Ns6_Section1 Conductor_number=1 Winding=Ns Point_out_of_terminal=true
  Nd_7: Coil Terminal Objects=Ns7_Section1 Conductor_number=1 Winding=Ns Point_out_of_terminal=true
  Nd_8: Coil Terminal Objects=Ns8_Section1 Conductor_number=1 Winding=Ns Point_out_of_terminal=true
  Nd_9: Coil Terminal Objects=Ns9_Section1 Conductor_number=1 Winding=Ns Point_out_of_terminal=true
  Nd_10: Coil Terminal Objects=Ns10_Section1 Conductor_number=1 Winding=Ns Point_out_of_terminal=true
  Nd_11: Coil Terminal Objects=Ns11_Section1 Conductor_number=1 Winding=Ns Point_out_of_terminal=true
  Nd_12: Coil Terminal Objects=Ns12_Section1_Separate1 Conductor_number=1 Winding=Ns Point_out_of_terminal=true
  Np: Winding Group Type=Voltage IsSolid=true Current=0A Resistance=0ohm Inductance=0nH Voltage=141V ParallelBranchesNum=1 Phase=0rad
  Ns: Winding Group Type=Current IsSolid=true Current=0mA ParallelBranchesNum=1 Phase=0deg
  eddy effects on: Np1, Np10, Np11, Np12, Np2..Np9, Ns1, Ns10, Ns11, Ns12, Ns2..Ns9, Body1_1, Body1_2, Body1_4, Body1_5
  core loss on: Body1, Body1_3
parameters:
  Matrix1: Matrix Np, Ns:
mesh:
  Length1: LengthBased Objects=[SIDE1, SIDE1_1, SIDE1_3, Np1..Np12, Ns1..Ns12] MaxLength=2mm
  Length2: LengthBased Objects=[Body1_1, Body1_2, Body1, Body1_3, Body1_4, Body1_5] MaxLength=5mm
  initial mesh: GlobalSurfApproximation{CurvedSurfaceApproxChoice=UseSlider SliderMeshSettings=9} GlobalCurvilinear{Apply} MeshMethod=AnsoftClassic
setups:
  Setup1: EddyCurrent MaximumPasses=20 MinimumPasses=2 MinimumConvergedPasses=1 PercentRefinement=30 PercentError=1 NonLinearResidual=0.0001 Frequency=28.5kHz LossAdaptiveCtrl=0.5

design 12turns_3D_WindingLoss_FullInterleaved_Flatwise_TIMSIDE (Maxwell 3D, EddyCurrent, model units mm)
geometry:
  Region [vacuum] = region(percentage_offset=0 on all sides)
  Np1 [copper] = imported_body(C:\Users\karlr\Documents\core_flatwise_TIMSIDE.step)
  Np1_Section1 [copper] = Np1.section(plane=ZX)
  Np10 [copper] = imported_body(C:\Users\karlr\Documents\core_flatwise_TIMSIDE.step)
  Np10_Section1 [copper] = Np10.section(plane=ZX)
  Np11 [copper] = imported_body(C:\Users\karlr\Documents\core_flatwise_TIMSIDE.step)
  Np11_Section1 [copper] = Np11.section(plane=ZX)
  Np12 [copper] = imported_body(C:\Users\karlr\Documents\core_flatwise_TIMSIDE.step)
  Np12_Section1 [copper] = Np12.section(plane=ZX)
  Np2 [copper] = imported_body(C:\Users\karlr\Documents\core_flatwise_TIMSIDE.step)
  Np2_Section1 [copper] = Np2.section(plane=ZX)
  Np3 [copper] = imported_body(C:\Users\karlr\Documents\core_flatwise_TIMSIDE.step)
  Np3_Section1 [copper] = Np3.section(plane=ZX)
  Np4 [copper] = imported_body(C:\Users\karlr\Documents\core_flatwise_TIMSIDE.step)
  Np4_Section1 [copper] = Np4.section(plane=ZX)
  Np5 [copper] = imported_body(C:\Users\karlr\Documents\core_flatwise_TIMSIDE.step)
  Np5_Section1 [copper] = Np5.section(plane=ZX)
  Np6 [copper] = imported_body(C:\Users\karlr\Documents\core_flatwise_TIMSIDE.step)
  Np6_Section1 [copper] = Np6.section(plane=ZX)
  Np7 [copper] = imported_body(C:\Users\karlr\Documents\core_flatwise_TIMSIDE.step)
  Np7_Section1 [copper] = Np7.section(plane=ZX)
  Np8 [copper] = imported_body(C:\Users\karlr\Documents\core_flatwise_TIMSIDE.step)
  Np8_Section1 [copper] = Np8.section(plane=ZX)
  Np9 [copper] = imported_body(C:\Users\karlr\Documents\core_flatwise_TIMSIDE.step)
  Np9_Section1 [copper] = Np9.section(plane=ZX)
  Ns1 [copper] = imported_body(C:\Users\karlr\Documents\core_flatwise_TIMSIDE.step)
  Ns1_Section1 [copper] = Ns1.section(plane=ZX)
  Ns10 [copper] = imported_body(C:\Users\karlr\Documents\core_flatwise_TIMSIDE.step)
  Ns10_Section1 [copper] = Ns10.section(plane=ZX)
  Ns11 [copper] = imported_body(C:\Users\karlr\Documents\core_flatwise_TIMSIDE.step)
  Ns11_Section1 [copper] = Ns11.section(plane=ZX)
  Ns12 [copper] = imported_body(C:\Users\karlr\Documents\core_flatwise_TIMSIDE.step)
  Ns12_Section1 = Ns12.section(plane=ZX)
  Ns2 [copper] = imported_body(C:\Users\karlr\Documents\core_flatwise_TIMSIDE.step)
  Ns2_Section1 [copper] = Ns2.section(plane=ZX)
  Ns3 [copper] = imported_body(C:\Users\karlr\Documents\core_flatwise_TIMSIDE.step)
  Ns3_Section1 [copper] = Ns3.section(plane=ZX)
  Ns4 [copper] = imported_body(C:\Users\karlr\Documents\core_flatwise_TIMSIDE.step)
  Ns4_Section1 [copper] = Ns4.section(plane=ZX)
  Ns5 [copper] = imported_body(C:\Users\karlr\Documents\core_flatwise_TIMSIDE.step)
  Ns5_Section1 [copper] = Ns5.section(plane=ZX)
  Ns6 [copper] = imported_body(C:\Users\karlr\Documents\core_flatwise_TIMSIDE.step)
  Ns6_Section1 [copper] = Ns6.section(plane=ZX)
  Ns7 [copper] = imported_body(C:\Users\karlr\Documents\core_flatwise_TIMSIDE.step)
  Ns7_Section1 [copper] = Ns7.section(plane=ZX)
  Ns8 [copper] = imported_body(C:\Users\karlr\Documents\core_flatwise_TIMSIDE.step)
  Ns8_Section1 [copper] = Ns8.section(plane=ZX)
  Ns9 [copper] = imported_body(C:\Users\karlr\Documents\core_flatwise_TIMSIDE.step)
  Ns9_Section1 [copper] = Ns9.section(plane=ZX)
  SIDE1, SIDE1_1, SIDE1_3 [Al_N] = imported_body(C:\Users\karlr\Documents\core_flatwise_TIMSIDE.step)
  SIDE1_4, SIDE1_5, SIDE1_2 = imported_body(C:\Users\karlr\Documents\core_flatwise_TIMSIDE.step)
  SIDE1_3.unite(SIDE1_4, SIDE1_5, SIDE1_2)
  Body1 [ferrite - Copy] = imported_body(C:\Users\karlr\Documents\core_flatwise_TIMSIDE.step)
  Body1_1, Body1_2 [aluminum] = imported_body(C:\Users\karlr\Documents\core_flatwise_TIMSIDE.step)
  Body1_3 [ferrite - Copy] = imported_body(C:\Users\karlr\Documents\core_flatwise_TIMSIDE.step)
  Body1_4, Body1_5 [aluminum] = imported_body(C:\Users\karlr\Documents\core_flatwise_TIMSIDE.step)
  Np1_Section1.separate_bodies()
  Np2_Section1.separate_bodies()
  Np3_Section1.separate_bodies()
  Np4_Section1.separate_bodies()
  Np5_Section1.separate_bodies()
  Np6_Section1.separate_bodies()
  Np7_Section1.separate_bodies()
  Np8_Section1.separate_bodies()
  Np9_Section1.separate_bodies()
  Np10_Section1.separate_bodies()
  Np11_Section1.separate_bodies()
  Np12_Section1.separate_bodies()
  Ns1_Section1.separate_bodies()
  Ns2_Section1.separate_bodies()
  Ns3_Section1.separate_bodies()
  Ns4_Section1.separate_bodies()
  Ns5_Section1.separate_bodies()
  Ns6_Section1.separate_bodies()
  Ns7_Section1.separate_bodies()
  Ns8_Section1.separate_bodies()
  Ns9_Section1.separate_bodies()
  Ns10_Section1.separate_bodies()
  Ns11_Section1.separate_bodies()
  Ns12_Section1_Separate1 [copper] = Ns12_Section1.separate_bodies()
  Ns12_Section1.delete()
  group core_assembled_flatwise = Np1, Np10, Np11, Np12, Np2..Np9, Ns1, Ns10, Ns11, Ns12, Ns2..Ns9, SIDE1, SIDE1_1, SIDE1_3, Np1_Section1, Np2_Section1, Np3_Section1, Np4_Section1, Np5_Section1, Np6_Section1, Np7_Section1, Np8_Section1, Np9_Section1, Np10_Section1, Np11_Section1, Np12_Section1, Ns1_Section1, Ns2_Section1, Ns3_Section1, Ns4_Section1, Ns5_Section1, Ns6_Section1, Ns7_Section1, Ns8_Section1, Ns9_Section1, Ns10_Section1, Ns11_Section1, Ns12_Section1_Separate1
  group core_together_1 = Body1, Body1_1, Body1_2
  group core_together = Body1_3, Body1_4, Body1_5
boundaries and excitations:
  Np_1: Coil Terminal Objects=Np1_Section1 Conductor_number=1 Winding=Np Point_out_of_terminal=false
  Np_2: Coil Terminal Objects=Np2_Section1 Conductor_number=1 Winding=Np Point_out_of_terminal=false
  Np_3: Coil Terminal Objects=Np3_Section1 Conductor_number=1 Winding=Np Point_out_of_terminal=false
  Np_4: Coil Terminal Objects=Np4_Section1 Conductor_number=1 Winding=Np Point_out_of_terminal=false
  Np_5: Coil Terminal Objects=Np5_Section1 Conductor_number=1 Winding=Np Point_out_of_terminal=false
  Np_6: Coil Terminal Objects=Np6_Section1 Conductor_number=1 Winding=Np Point_out_of_terminal=false
  Np_7: Coil Terminal Objects=Np7_Section1 Conductor_number=1 Winding=Np Point_out_of_terminal=false
  Np_8: Coil Terminal Objects=Np8_Section1 Conductor_number=1 Winding=Np Point_out_of_terminal=false
  Np_9: Coil Terminal Objects=Np9_Section1 Conductor_number=1 Winding=Np Point_out_of_terminal=false
  Np_10: Coil Terminal Objects=Np10_Section1 Conductor_number=1 Winding=Np Point_out_of_terminal=false
  Np_11: Coil Terminal Objects=Np11_Section1 Conductor_number=1 Winding=Np Point_out_of_terminal=false
  Np_12: Coil Terminal Objects=Np12_Section1 Conductor_number=1 Winding=Np Point_out_of_terminal=false
  Nd_1: Coil Terminal Objects=Ns1_Section1 Conductor_number=1 Winding=Ns Point_out_of_terminal=true
  Nd_2: Coil Terminal Objects=Ns2_Section1 Conductor_number=1 Winding=Ns Point_out_of_terminal=true
  Nd_3: Coil Terminal Objects=Ns3_Section1 Conductor_number=1 Winding=Ns Point_out_of_terminal=true
  Nd_4: Coil Terminal Objects=Ns4_Section1 Conductor_number=1 Winding=Ns Point_out_of_terminal=true
  Nd_5: Coil Terminal Objects=Ns5_Section1 Conductor_number=1 Winding=Ns Point_out_of_terminal=true
  Nd_6: Coil Terminal Objects=Ns6_Section1 Conductor_number=1 Winding=Ns Point_out_of_terminal=true
  Nd_7: Coil Terminal Objects=Ns7_Section1 Conductor_number=1 Winding=Ns Point_out_of_terminal=true
  Nd_8: Coil Terminal Objects=Ns8_Section1 Conductor_number=1 Winding=Ns Point_out_of_terminal=true
  Nd_9: Coil Terminal Objects=Ns9_Section1 Conductor_number=1 Winding=Ns Point_out_of_terminal=true
  Nd_10: Coil Terminal Objects=Ns10_Section1 Conductor_number=1 Winding=Ns Point_out_of_terminal=true
  Nd_11: Coil Terminal Objects=Ns11_Section1 Conductor_number=1 Winding=Ns Point_out_of_terminal=true
  Nd_12: Coil Terminal Objects=Ns12_Section1_Separate1 Conductor_number=1 Winding=Ns Point_out_of_terminal=true
  Np: Winding Group Type=Current IsSolid=true Current=16.36A ParallelBranchesNum=1 Phase=0rad
  Ns: Winding Group Type=Current IsSolid=true Current=15.96A ParallelBranchesNum=1 Phase=0.1522rad
  eddy effects on: Np1, Np10, Np11, Np12, Np2..Np9, Ns1, Ns10, Ns11, Ns12, Ns2..Ns9, Body1_1, Body1_2, Body1_4, Body1_5
parameters:
  Matrix1: Matrix Np, Ns:
mesh:
  Length1: LengthBased Objects=[SIDE1, SIDE1_1, SIDE1_3, Np1..Np12, Ns1..Ns12] MaxLength=2mm
  Length2: LengthBased Objects=[Body1_1, Body1_2, Body1, Body1_3, Body1_4, Body1_5] MaxLength=5mm
  initial mesh: GlobalSurfApproximation{CurvedSurfaceApproxChoice=UseSlider SliderMeshSettings=9} GlobalCurvilinear{Apply} MeshMethod=AnsoftClassic
setups:
  Setup1: EddyCurrent MaximumPasses=20 MinimumPasses=2 MinimumConvergedPasses=1 PercentRefinement=30 PercentError=1 NonLinearResidual=0.0001 Frequency=28.5kHz LossAdaptiveCtrl=0.5

design 12turns_3D_Thermal_FullInterleaved_Edgewise_TIM_CoreLoss (Maxwell 3D, EddyCurrent, model units mm)
geometry:
  Np1, Np10, Np11, Np12, Np2..Np9, Ns1, Ns10, Ns11, Ns12, Ns2..Ns9 [copper] = imported_body(C:\Users\karlr\Documents\core_edgewise_TIMSIDE.step)
  SIDE1, SIDE1_1, SIDE1_2 [Al_N] = imported_body(C:\Users\karlr\Documents\core_edgewise_TIMSIDE.step)
  SIDE1_3, SIDE1_4, SIDE1_5 = imported_body(C:\Users\karlr\Documents\core_edgewise_TIMSIDE.step)
  Body1 [ferrite - Copy] = imported_body(C:\Users\karlr\Documents\core_edgewise_TIMSIDE.step)
  Body1_1, Body1_2 [aluminum] = imported_body(C:\Users\karlr\Documents\core_edgewise_TIMSIDE.step)
  Body1_3 [ferrite - Copy] = imported_body(C:\Users\karlr\Documents\core_edgewise_TIMSIDE.step)
  Body1_4, Body1_5 [aluminum] = imported_body(C:\Users\karlr\Documents\core_edgewise_TIMSIDE.step)
  Region [vacuum] = region(percentage_offset=0 on all sides)
  SIDE1_2.unite(SIDE1_3, SIDE1_4, SIDE1_5)
  Np1_Section1 [copper] = Np1.section(plane=ZX)
  Np2_Section1 [copper] = Np2.section(plane=ZX)
  Np3_Section1 [copper] = Np3.section(plane=ZX)
  Np4_Section1 [copper] = Np4.section(plane=ZX)
  Np5_Section1 [copper] = Np5.section(plane=ZX)
  Np6_Section1 [copper] = Np6.section(plane=ZX)
  Np7_Section1 [copper] = Np7.section(plane=ZX)
  Np8_Section1 [copper] = Np8.section(plane=ZX)
  Np9_Section1 [copper] = Np9.section(plane=ZX)
  Np10_Section1 [copper] = Np10.section(plane=ZX)
  Np11_Section1 [copper] = Np11.section(plane=ZX)
  Np12_Section1 [copper] = Np12.section(plane=ZX)
  Ns1_Section1 [copper] = Ns1.section(plane=ZX)
  Ns2_Section1 [copper] = Ns2.section(plane=ZX)
  Ns3_Section1 [copper] = Ns3.section(plane=ZX)
  Ns4_Section1 [copper] = Ns4.section(plane=ZX)
  Ns5_Section1 [copper] = Ns5.section(plane=ZX)
  Ns6_Section1 [copper] = Ns6.section(plane=ZX)
  Ns7_Section1 [copper] = Ns7.section(plane=ZX)
  Ns8_Section1 [copper] = Ns8.section(plane=ZX)
  Ns9_Section1 [copper] = Ns9.section(plane=ZX)
  Ns10_Section1 [copper] = Ns10.section(plane=ZX)
  Ns11_Section1 [copper] = Ns11.section(plane=ZX)
  Ns12_Section1 [copper] = Ns12.section(plane=ZX)
  Np1_Section1.separate_bodies()
  Np2_Section1.separate_bodies()
  Np3_Section1.separate_bodies()
  Np4_Section1.separate_bodies()
  Np5_Section1.separate_bodies()
  Np6_Section1.separate_bodies()
  Np7_Section1.separate_bodies()
  Np8_Section1.separate_bodies()
  Np9_Section1.separate_bodies()
  Np10_Section1.separate_bodies()
  Np11_Section1.separate_bodies()
  Np12_Section1.separate_bodies()
  Ns1_Section1.separate_bodies()
  Ns2_Section1.separate_bodies()
  Ns3_Section1.separate_bodies()
  Ns4_Section1.separate_bodies()
  Ns5_Section1.separate_bodies()
  Ns6_Section1.separate_bodies()
  Ns7_Section1.separate_bodies()
  Ns8_Section1.separate_bodies()
  Ns9_Section1.separate_bodies()
  Ns10_Section1.separate_bodies()
  Ns11_Section1.separate_bodies()
  Ns12_Section1.separate_bodies()
  group core_assembled_edgewise1 = Np1, Np10, Np11, Np12, Np2..Np9, Ns1, Ns10, Ns11, Ns12, Ns2..Ns9, SIDE1, SIDE1_1, SIDE1_2, Np1_Section1, Np2_Section1, Np3_Section1, Np4_Section1, Np5_Section1, Np6_Section1, Np7_Section1, Np8_Section1, Np9_Section1, Np10_Section1, Np11_Section1, Np12_Section1, Ns1_Section1, Ns2_Section1, Ns3_Section1, Ns4_Section1, Ns5_Section1, Ns6_Section1, Ns7_Section1, Ns8_Section1, Ns9_Section1, Ns10_Section1, Ns11_Section1, Ns12_Section1
  group core_together_2 = Body1, Body1_1, Body1_2
  group core_together1 = Body1_3, Body1_4, Body1_5
boundaries and excitations:
  Np_1: Coil Terminal Objects=Np1_Section1 Conductor_number=1 Winding=Pri Point_out_of_terminal=false
  Np_2: Coil Terminal Objects=Np2_Section1 Conductor_number=1 Winding=Pri Point_out_of_terminal=false
  Np_3: Coil Terminal Objects=Np3_Section1 Conductor_number=1 Winding=Pri Point_out_of_terminal=false
  Np_4: Coil Terminal Objects=Np4_Section1 Conductor_number=1 Winding=Pri Point_out_of_terminal=false
  Np_5: Coil Terminal Objects=Np5_Section1 Conductor_number=1 Winding=Pri Point_out_of_terminal=false
  Np_6: Coil Terminal Objects=Np6_Section1 Conductor_number=1 Winding=Pri Point_out_of_terminal=false
  Np_7: Coil Terminal Objects=Np7_Section1 Conductor_number=1 Winding=Pri Point_out_of_terminal=false
  Np_8: Coil Terminal Objects=Np8_Section1 Conductor_number=1 Winding=Pri Point_out_of_terminal=false
  Np_9: Coil Terminal Objects=Np9_Section1 Conductor_number=1 Winding=Pri Point_out_of_terminal=false
  Np_10: Coil Terminal Objects=Np10_Section1 Conductor_number=1 Winding=Pri Point_out_of_terminal=false
  Np_11: Coil Terminal Objects=Np11_Section1 Conductor_number=1 Winding=Pri Point_out_of_terminal=false
  Np_12: Coil Terminal Objects=Np12_Section1 Conductor_number=1 Winding=Pri Point_out_of_terminal=false
  Ns_1: Coil Terminal Objects=Ns1_Section1 Conductor_number=1 Winding=Sec Point_out_of_terminal=true
  Ns_2: Coil Terminal Objects=Ns2_Section1 Conductor_number=1 Winding=Sec Point_out_of_terminal=true
  Ns_3: Coil Terminal Objects=Ns3_Section1 Conductor_number=1 Winding=Sec Point_out_of_terminal=true
  Ns_4: Coil Terminal Objects=Ns4_Section1 Conductor_number=1 Winding=Sec Point_out_of_terminal=true
  Ns_5: Coil Terminal Objects=Ns5_Section1 Conductor_number=1 Winding=Sec Point_out_of_terminal=true
  Ns_6: Coil Terminal Objects=Ns6_Section1 Conductor_number=1 Winding=Sec Point_out_of_terminal=true
  Ns_7: Coil Terminal Objects=Ns7_Section1 Conductor_number=1 Winding=Sec Point_out_of_terminal=true
  Ns_8: Coil Terminal Objects=Ns8_Section1 Conductor_number=1 Winding=Sec Point_out_of_terminal=true
  Ns_9: Coil Terminal Objects=Ns9_Section1 Conductor_number=1 Winding=Sec Point_out_of_terminal=true
  Ns_10: Coil Terminal Objects=Ns10_Section1 Conductor_number=1 Winding=Sec Point_out_of_terminal=true
  Ns_11: Coil Terminal Objects=Ns11_Section1 Conductor_number=1 Winding=Sec Point_out_of_terminal=true
  Ns_12: Coil Terminal Objects=Ns12_Section1 Conductor_number=1 Winding=Sec Point_out_of_terminal=true
  Pri: Winding Group Type=Voltage IsSolid=true Current=0mA Resistance=0ohm Inductance=0nH Voltage=141V ParallelBranchesNum=1 Phase=0deg
  Sec: Winding Group Type=Current IsSolid=true Current=0mA ParallelBranchesNum=1 Phase=0deg
  eddy effects on: Np1, Np10, Np11, Np12, Np2..Np9, Ns1, Ns10, Ns11, Ns12, Ns2..Ns9, Body1_1, Body1_2, Body1_4, Body1_5
  core loss on: Body1, Body1_3
parameters:
  Matrix1: Matrix Pri, Sec:
mesh:
  Length1: LengthBased Objects=[SIDE1, SIDE1_1, SIDE1_2, Np1..Np12, Ns1..Ns12] MaxLength=2mm
  Length2: LengthBased Objects=[Body1, Body1_1, Body1_2, Body1_4, Body1_5, Body1_3] MaxLength=5mm
  initial mesh: GlobalSurfApproximation{CurvedSurfaceApproxChoice=UseSlider SliderMeshSettings=9} GlobalCurvilinear{Apply} MeshMethod=AnsoftClassic
setups:
  Setup1: EddyCurrent MaximumPasses=20 MinimumPasses=2 MinimumConvergedPasses=1 PercentRefinement=30 PercentError=1 NonLinearResidual=0.0001 Frequency=28.5kHz LossAdaptiveCtrl=0.5

design 12turns_3D_Thermal_FullInterleaved_Edgewise_TIM_WindingLoss (Maxwell 3D, EddyCurrent, model units mm)
geometry:
  Np1, Np10, Np11, Np12, Np2..Np9, Ns1, Ns10, Ns11, Ns12, Ns2..Ns9 [copper] = imported_body(C:\Users\karlr\Documents\core_edgewise_TIMSIDE.step)
  SIDE1, SIDE1_1, SIDE1_2 [Al_N] = imported_body(C:\Users\karlr\Documents\core_edgewise_TIMSIDE.step)
  SIDE1_3, SIDE1_4, SIDE1_5 = imported_body(C:\Users\karlr\Documents\core_edgewise_TIMSIDE.step)
  Body1 [ferrite - Copy] = imported_body(C:\Users\karlr\Documents\core_edgewise_TIMSIDE.step)
  Body1_1, Body1_2 [aluminum] = imported_body(C:\Users\karlr\Documents\core_edgewise_TIMSIDE.step)
  Body1_3 [ferrite - Copy] = imported_body(C:\Users\karlr\Documents\core_edgewise_TIMSIDE.step)
  Body1_4, Body1_5 [aluminum] = imported_body(C:\Users\karlr\Documents\core_edgewise_TIMSIDE.step)
  Region [vacuum] = region(percentage_offset=0 on all sides)
  SIDE1_2.unite(SIDE1_3, SIDE1_4, SIDE1_5)
  Np1_Section1 [copper] = Np1.section(plane=ZX)
  Np2_Section1 [copper] = Np2.section(plane=ZX)
  Np3_Section1 [copper] = Np3.section(plane=ZX)
  Np4_Section1 [copper] = Np4.section(plane=ZX)
  Np5_Section1 [copper] = Np5.section(plane=ZX)
  Np6_Section1 [copper] = Np6.section(plane=ZX)
  Np7_Section1 [copper] = Np7.section(plane=ZX)
  Np8_Section1 [copper] = Np8.section(plane=ZX)
  Np9_Section1 [copper] = Np9.section(plane=ZX)
  Np10_Section1 [copper] = Np10.section(plane=ZX)
  Np11_Section1 [copper] = Np11.section(plane=ZX)
  Np12_Section1 [copper] = Np12.section(plane=ZX)
  Ns1_Section1 [copper] = Ns1.section(plane=ZX)
  Ns2_Section1 [copper] = Ns2.section(plane=ZX)
  Ns3_Section1 [copper] = Ns3.section(plane=ZX)
  Ns4_Section1 [copper] = Ns4.section(plane=ZX)
  Ns5_Section1 [copper] = Ns5.section(plane=ZX)
  Ns6_Section1 [copper] = Ns6.section(plane=ZX)
  Ns7_Section1 [copper] = Ns7.section(plane=ZX)
  Ns8_Section1 [copper] = Ns8.section(plane=ZX)
  Ns9_Section1 [copper] = Ns9.section(plane=ZX)
  Ns10_Section1 [copper] = Ns10.section(plane=ZX)
  Ns11_Section1 [copper] = Ns11.section(plane=ZX)
  Ns12_Section1 [copper] = Ns12.section(plane=ZX)
  Np1_Section1.separate_bodies()
  Np2_Section1.separate_bodies()
  Np3_Section1.separate_bodies()
  Np4_Section1.separate_bodies()
  Np5_Section1.separate_bodies()
  Np6_Section1.separate_bodies()
  Np7_Section1.separate_bodies()
  Np8_Section1.separate_bodies()
  Np9_Section1.separate_bodies()
  Np10_Section1.separate_bodies()
  Np11_Section1.separate_bodies()
  Np12_Section1.separate_bodies()
  Ns1_Section1.separate_bodies()
  Ns2_Section1.separate_bodies()
  Ns3_Section1.separate_bodies()
  Ns4_Section1.separate_bodies()
  Ns5_Section1.separate_bodies()
  Ns6_Section1.separate_bodies()
  Ns7_Section1.separate_bodies()
  Ns8_Section1.separate_bodies()
  Ns9_Section1.separate_bodies()
  Ns10_Section1.separate_bodies()
  Ns11_Section1.separate_bodies()
  Ns12_Section1.separate_bodies()
  group core_assembled_edgewise1 = Np1, Np10, Np11, Np12, Np2..Np9, Ns1, Ns10, Ns11, Ns12, Ns2..Ns9, SIDE1, SIDE1_1, SIDE1_2, Np1_Section1, Np2_Section1, Np3_Section1, Np4_Section1, Np5_Section1, Np6_Section1, Np7_Section1, Np8_Section1, Np9_Section1, Np10_Section1, Np11_Section1, Np12_Section1, Ns1_Section1, Ns2_Section1, Ns3_Section1, Ns4_Section1, Ns5_Section1, Ns6_Section1, Ns7_Section1, Ns8_Section1, Ns9_Section1, Ns10_Section1, Ns11_Section1, Ns12_Section1
  group core_together_2 = Body1, Body1_1, Body1_2
  group core_together1 = Body1_3, Body1_4, Body1_5
boundaries and excitations:
  Np_1: Coil Terminal Objects=Np1_Section1 Conductor_number=1 Winding=Pri Point_out_of_terminal=false
  Np_2: Coil Terminal Objects=Np2_Section1 Conductor_number=1 Winding=Pri Point_out_of_terminal=false
  Np_3: Coil Terminal Objects=Np3_Section1 Conductor_number=1 Winding=Pri Point_out_of_terminal=false
  Np_4: Coil Terminal Objects=Np4_Section1 Conductor_number=1 Winding=Pri Point_out_of_terminal=false
  Np_5: Coil Terminal Objects=Np5_Section1 Conductor_number=1 Winding=Pri Point_out_of_terminal=false
  Np_6: Coil Terminal Objects=Np6_Section1 Conductor_number=1 Winding=Pri Point_out_of_terminal=false
  Np_7: Coil Terminal Objects=Np7_Section1 Conductor_number=1 Winding=Pri Point_out_of_terminal=false
  Np_8: Coil Terminal Objects=Np8_Section1 Conductor_number=1 Winding=Pri Point_out_of_terminal=false
  Np_9: Coil Terminal Objects=Np9_Section1 Conductor_number=1 Winding=Pri Point_out_of_terminal=false
  Np_10: Coil Terminal Objects=Np10_Section1 Conductor_number=1 Winding=Pri Point_out_of_terminal=false
  Np_11: Coil Terminal Objects=Np11_Section1 Conductor_number=1 Winding=Pri Point_out_of_terminal=false
  Np_12: Coil Terminal Objects=Np12_Section1 Conductor_number=1 Winding=Pri Point_out_of_terminal=false
  Ns_1: Coil Terminal Objects=Ns1_Section1 Conductor_number=1 Winding=Sec Point_out_of_terminal=true
  Ns_2: Coil Terminal Objects=Ns2_Section1 Conductor_number=1 Winding=Sec Point_out_of_terminal=true
  Ns_3: Coil Terminal Objects=Ns3_Section1 Conductor_number=1 Winding=Sec Point_out_of_terminal=true
  Ns_4: Coil Terminal Objects=Ns4_Section1 Conductor_number=1 Winding=Sec Point_out_of_terminal=true
  Ns_5: Coil Terminal Objects=Ns5_Section1 Conductor_number=1 Winding=Sec Point_out_of_terminal=true
  Ns_6: Coil Terminal Objects=Ns6_Section1 Conductor_number=1 Winding=Sec Point_out_of_terminal=true
  Ns_7: Coil Terminal Objects=Ns7_Section1 Conductor_number=1 Winding=Sec Point_out_of_terminal=true
  Ns_8: Coil Terminal Objects=Ns8_Section1 Conductor_number=1 Winding=Sec Point_out_of_terminal=true
  Ns_9: Coil Terminal Objects=Ns9_Section1 Conductor_number=1 Winding=Sec Point_out_of_terminal=true
  Ns_10: Coil Terminal Objects=Ns10_Section1 Conductor_number=1 Winding=Sec Point_out_of_terminal=true
  Ns_11: Coil Terminal Objects=Ns11_Section1 Conductor_number=1 Winding=Sec Point_out_of_terminal=true
  Ns_12: Coil Terminal Objects=Ns12_Section1 Conductor_number=1 Winding=Sec Point_out_of_terminal=true
  Pri: Winding Group Type=Current IsSolid=true Current=16.36A ParallelBranchesNum=1 Phase=0deg
  Sec: Winding Group Type=Current IsSolid=true Current=15.96A ParallelBranchesNum=1 Phase=0.1522rad
  eddy effects on: Np1, Np10, Np11, Np12, Np2..Np9, Ns1, Ns10, Ns11, Ns12, Ns2..Ns9, Body1_1, Body1_2, Body1_4, Body1_5
parameters:
  Matrix1: Matrix Pri, Sec:
mesh:
  Length1: LengthBased Objects=[SIDE1, SIDE1_1, SIDE1_2, Np1..Np12, Ns1..Ns12] MaxLength=2mm
  Length2: LengthBased Objects=[Body1, Body1_1, Body1_2, Body1_4, Body1_5, Body1_3] MaxLength=5mm
  initial mesh: GlobalSurfApproximation{CurvedSurfaceApproxChoice=UseSlider SliderMeshSettings=9} GlobalCurvilinear{Apply} MeshMethod=AnsoftClassic
setups:
  Setup1: EddyCurrent MaximumPasses=20 MinimumPasses=2 MinimumConvergedPasses=1 PercentRefinement=30 PercentError=1 NonLinearResidual=0.0001 Frequency=28.5kHz LossAdaptiveCtrl=0.5

design 12turns_3D_Thermal_FullInterleaved (Icepak, SteadyState TemperatureAndFlow, model units mm)
options: Default_Fluid_Material=air Default_Solid_Material=Al-Extruded Default_Surface_Material=Steel-oxidised-surface AmbientTemperature=20cel AmbientPressure=0n_per_meter_sq AmbientRadiationTemperature=20cel Gravity_Vector_CS_ID=Global Gravity_Vector_Axis=Z Positive=false Altitude=0meter OperatingPressure=101325n_per_meter_sq OperatingDensity=1.225kg_per_m3
geometry:
  Region [air] = region(percentage_offset=1000 on all sides)
  Np1 [copper] = imported_body(C:\Users\karlr\Documents\core_assembled_flatwise_12turns.step)
  Np1_Section1 = Np1.section(plane=ZX)
  Np10 [copper] = imported_body(C:\Users\karlr\Documents\core_assembled_flatwise_12turns.step)
  Np10_Section1 = Np10.section(plane=ZX)
  Np11 [copper] = imported_body(C:\Users\karlr\Documents\core_assembled_flatwise_12turns.step)
  Np11_Section1 = Np11.section(plane=ZX)
  Np12 [copper] = imported_body(C:\Users\karlr\Documents\core_assembled_flatwise_12turns.step)
  Np12_Section1 = Np12.section(plane=ZX)
  Np2 [copper] = imported_body(C:\Users\karlr\Documents\core_assembled_flatwise_12turns.step)
  Np2_Section1 = Np2.section(plane=ZX)
  Np3 [copper] = imported_body(C:\Users\karlr\Documents\core_assembled_flatwise_12turns.step)
  Np3_Section1 = Np3.section(plane=ZX)
  Np4 [copper] = imported_body(C:\Users\karlr\Documents\core_assembled_flatwise_12turns.step)
  Np4_Section1 = Np4.section(plane=ZX)
  Np5 [copper] = imported_body(C:\Users\karlr\Documents\core_assembled_flatwise_12turns.step)
  Np5_Section1 = Np5.section(plane=ZX)
  Np6 [copper] = imported_body(C:\Users\karlr\Documents\core_assembled_flatwise_12turns.step)
  Np6_Section1 = Np6.section(plane=ZX)
  Np7 [copper] = imported_body(C:\Users\karlr\Documents\core_assembled_flatwise_12turns.step)
  Np7_Section1 = Np7.section(plane=ZX)
  Np8 [copper] = imported_body(C:\Users\karlr\Documents\core_assembled_flatwise_12turns.step)
  Np8_Section1 = Np8.section(plane=ZX)
  Np9 [copper] = imported_body(C:\Users\karlr\Documents\core_assembled_flatwise_12turns.step)
  Np9_Section1 = Np9.section(plane=ZX)
  Ns1 [copper] = imported_body(C:\Users\karlr\Documents\core_assembled_flatwise_12turns.step)
  Ns1_Section1 = Ns1.section(plane=ZX)
  Ns10 [copper] = imported_body(C:\Users\karlr\Documents\core_assembled_flatwise_12turns.step)
  Ns10_Section1 = Ns10.section(plane=ZX)
  Ns11 [copper] = imported_body(C:\Users\karlr\Documents\core_assembled_flatwise_12turns.step)
  Ns11_Section1 = Ns11.section(plane=ZX)
  Ns12 [copper] = imported_body(C:\Users\karlr\Documents\core_assembled_flatwise_12turns.step)
  Ns12_Section1 = Ns12.section(plane=ZX)
  Ns2 [copper] = imported_body(C:\Users\karlr\Documents\core_assembled_flatwise_12turns.step)
  Ns2_Section1 = Ns2.section(plane=ZX)
  Ns3 [copper] = imported_body(C:\Users\karlr\Documents\core_assembled_flatwise_12turns.step)
  Ns3_Section1 = Ns3.section(plane=ZX)
  Ns4 [copper] = imported_body(C:\Users\karlr\Documents\core_assembled_flatwise_12turns.step)
  Ns4_Section1 = Ns4.section(plane=ZX)
  Ns5 [copper] = imported_body(C:\Users\karlr\Documents\core_assembled_flatwise_12turns.step)
  Ns5_Section1 = Ns5.section(plane=ZX)
  Ns6 [copper] = imported_body(C:\Users\karlr\Documents\core_assembled_flatwise_12turns.step)
  Ns6_Section1 = Ns6.section(plane=ZX)
  Ns7 [copper] = imported_body(C:\Users\karlr\Documents\core_assembled_flatwise_12turns.step)
  Ns7_Section1 = Ns7.section(plane=ZX)
  Ns8 [copper] = imported_body(C:\Users\karlr\Documents\core_assembled_flatwise_12turns.step)
  Ns8_Section1 = Ns8.section(plane=ZX)
  Ns9 [copper] = imported_body(C:\Users\karlr\Documents\core_assembled_flatwise_12turns.step)
  Ns9_Section1 = Ns9.section(plane=ZX)
  plate_1, plate_2 [Al_N] = imported_body(C:\Users\karlr\Documents\core_assembled_flatwise_12turns.step)
  Body1 [ferrite - Copy] = imported_body(C:\Users\karlr\Documents\core_assembled_flatwise_12turns.step)
  Body1_1, Body1_2 [aluminum] = imported_body(C:\Users\karlr\Documents\core_assembled_flatwise_12turns.step)
  Body1_3 [ferrite - Copy] = imported_body(C:\Users\karlr\Documents\core_assembled_flatwise_12turns.step)
  Body1_4, Body1_5 [aluminum] = imported_body(C:\Users\karlr\Documents\core_assembled_flatwise_12turns.step)
  Np1_Section1.separate_bodies()
  Np2_Section1.separate_bodies()
  Np3_Section1.separate_bodies()
  Np4_Section1.separate_bodies()
  Np5_Section1.separate_bodies()
  Np6_Section1.separate_bodies()
  Np7_Section1.separate_bodies()
  Np8_Section1.separate_bodies()
  Np9_Section1.separate_bodies()
  Np10_Section1.separate_bodies()
  Np11_Section1.separate_bodies()
  Np12_Section1.separate_bodies()
  Ns1_Section1.separate_bodies()
  Ns2_Section1.separate_bodies()
  Ns3_Section1.separate_bodies()
  Ns4_Section1.separate_bodies()
  Ns5_Section1.separate_bodies()
  Ns6_Section1.separate_bodies()
  Ns7_Section1.separate_bodies()
  Ns8_Section1.separate_bodies()
  Ns9_Section1.separate_bodies()
  Ns10_Section1.separate_bodies()
  Ns11_Section1.separate_bodies()
  Ns12_Section1_Separate1 = Ns12_Section1.separate_bodies()
  Ns12_Section1.delete()
  MeshRegion1_SubRegion [air, non-model] = sub_region(of=Np2, plate_1, plate_2, Np1, Np6, Np3, Ns10, Np4, Np5, Ns3, Np7..Np12, Ns9, Ns1, Ns8, Ns2, Ns4..Ns7, Ns11, Ns12, percentage_offset=0 on all sides)
  group core_assembled_flatwise = Np1, Np10, Np11, Np12, Np2..Np9, Ns1, Ns10, Ns11, Ns12, Ns2..Ns9, plate_1, plate_2, Np1_Section1, Np2_Section1, Np3_Section1, Np4_Section1, Np5_Section1, Np6_Section1, Np7_Section1, Np8_Section1, Np9_Section1, Np10_Section1, Np11_Section1, Np12_Section1, Ns1_Section1, Ns2_Section1, Ns3_Section1, Ns4_Section1, Ns5_Section1, Ns6_Section1, Ns7_Section1, Ns8_Section1, Ns9_Section1, Ns10_Section1, Ns11_Section1, Ns12_Section1_Separate1
  group core_together_1 = Body1, Body1_1, Body1_2
  group core_together = Body1_3, Body1_4, Body1_5
boundaries and excitations:
  Opening1: Opening Faces=Region.face(-y) Temperature=AmbientTemp External_Rad._Temperature=AmbientRadTemp Inlet_Type=Pressure Total_Pressure=AmbientPressure
  Opening2: Opening Faces=Region.face(+y) Temperature=AmbientTemp External_Rad._Temperature=AmbientRadTemp Inlet_Type=Velocity Static_Pressure=AmbientPressure X_Velocity=0m_per_sec Y_Velocity=0m_per_sec Z_Velocity=0m_per_sec
  EMLoss1: EM Loss Objects=[Body1_4, Body1_5, Body1_3, Body1_1, Body1_2, Body1] LinkID=143 Project="This Project*" Product="Maxwell 3D" Design=12turns_3D_CoreLoss_FullInterleaved ForceSourceToSolve PreservePartnerSoln PathRelativeTo=TargetProject Intrinsics(28.5kHz) LossMultiplier=1
  EMLoss2: EM Loss Objects=[Np1..Np12, Ns1..Ns12] LinkID=146 Project="This Project*" Product="Maxwell 3D" Design=12turns_3D_WindingLoss_FullInterleaved ForceSourceToSolve PreservePartnerSoln PathRelativeTo=TargetProject Intrinsics(28.5kHz) LossMultiplier=1
mesh:
  Global:  MeshMethod=MesherHD ComputeGap MeshRegionResolution=5 MinGapX=1mm MinGapY=1mm MinGapZ=1mm Objects=Region FacetLevel=5 ProximitySizeFunction CurvatureSizeFunction OptimizePCBMesh
  MeshRegion1:  MeshMethod=MesherHD MeshRegionResolution=5 MinGapX=1mm MinGapY=1mm MinGapZ=0.72mm Objects=MeshRegion1_SubRegion ProximitySizeFunction CurvatureSizeFunction OptimizePCBMesh
setups:
  Setup1: IcepakSteadyState Flow_Regime=Laminar Include_Temperature=true Include_Flow=true Include_Gravity Solution_Initialization_-_Z_Velocity=0.000980665m_per_sec Convergence_Criteria_-_Flow=0.001 Convergence_Criteria_-_Energy=1e-07 Convergence_Criteria_-_Discrete_Ordinates=1e-06 GPU_Convergence_Criteria_-_Flow=0.001 GPU_Convergence_Criteria_-_Energy=1e-05 GPU_Convergence_Criteria_-_Discrete_Ordinates=1e-05 Radiation_Model="Discrete Ordinates Model" Flow_Iteration_Per_Radiation_Iteration=10 Time_Step_Interval=1 ThetaDivision=2 PhiDivision=2 ThetaPixels=2 PhiPixels=2 Under-relaxation_-_Pressure=0.7 Under-relaxation_-_Momentum=0.3 Under-relaxation_-_Temperature=1 Under-relaxation_-_Body_Force=1 Discretization_Scheme_-_Pressure=Standard Discretization_Scheme_-_Momentum=First Discretization_Scheme_-_Temperature=First Discretization_Scheme_-_Discrete_Ordinates=First Convergence_Criteria_-_Max_Iterations=120
field plots:
  Temperature1: Temperature on Setup1 : SteadyState

design 12turns_3D_Thermal_FullInterleaved_tempdependent (Icepak, SteadyState TemperatureAndFlow, model units mm)
options: Default_Fluid_Material=air Default_Solid_Material=Al-Extruded Default_Surface_Material=Steel-oxidised-surface AmbientTemperature=20cel AmbientPressure=0n_per_meter_sq AmbientRadiationTemperature=20cel Gravity_Vector_CS_ID=Global Gravity_Vector_Axis=Z Positive=false Altitude=0meter OperatingPressure=101325n_per_meter_sq OperatingDensity=1.225kg_per_m3
geometry:
  Np1 [copper - tempDependent] = imported_body(C:\Users\karlr\Documents\core_assembled_flatwise_12turns.step)
  Np1_Section1 [copper] = Np1.section(plane=ZX)
  Np10 [copper - tempDependent] = imported_body(C:\Users\karlr\Documents\core_assembled_flatwise_12turns.step)
  Np10_Section1 [copper] = Np10.section(plane=ZX)
  Np11 [copper - tempDependent] = imported_body(C:\Users\karlr\Documents\core_assembled_flatwise_12turns.step)
  Np11_Section1 [copper] = Np11.section(plane=ZX)
  Np12 [copper - tempDependent] = imported_body(C:\Users\karlr\Documents\core_assembled_flatwise_12turns.step)
  Np12_Section1 [copper] = Np12.section(plane=ZX)
  Np2 [copper - tempDependent] = imported_body(C:\Users\karlr\Documents\core_assembled_flatwise_12turns.step)
  Np2_Section1 [copper] = Np2.section(plane=ZX)
  Np3 [copper - tempDependent] = imported_body(C:\Users\karlr\Documents\core_assembled_flatwise_12turns.step)
  Np3_Section1 [copper] = Np3.section(plane=ZX)
  Np4 [copper - tempDependent] = imported_body(C:\Users\karlr\Documents\core_assembled_flatwise_12turns.step)
  Np4_Section1 [copper] = Np4.section(plane=ZX)
  Np5 [copper - tempDependent] = imported_body(C:\Users\karlr\Documents\core_assembled_flatwise_12turns.step)
  Np5_Section1 [copper] = Np5.section(plane=ZX)
  Np6 [copper - tempDependent] = imported_body(C:\Users\karlr\Documents\core_assembled_flatwise_12turns.step)
  Np6_Section1 [copper] = Np6.section(plane=ZX)
  Np7 [copper - tempDependent] = imported_body(C:\Users\karlr\Documents\core_assembled_flatwise_12turns.step)
  Np7_Section1 [copper] = Np7.section(plane=ZX)
  Np8 [copper - tempDependent] = imported_body(C:\Users\karlr\Documents\core_assembled_flatwise_12turns.step)
  Np8_Section1 [copper] = Np8.section(plane=ZX)
  Np9 [copper - tempDependent] = imported_body(C:\Users\karlr\Documents\core_assembled_flatwise_12turns.step)
  Np9_Section1 [copper] = Np9.section(plane=ZX)
  Ns1 [copper - tempDependent] = imported_body(C:\Users\karlr\Documents\core_assembled_flatwise_12turns.step)
  Ns1_Section1 [copper] = Ns1.section(plane=ZX)
  Ns10 [copper - tempDependent] = imported_body(C:\Users\karlr\Documents\core_assembled_flatwise_12turns.step)
  Ns10_Section1 [copper] = Ns10.section(plane=ZX)
  Ns11 [copper - tempDependent] = imported_body(C:\Users\karlr\Documents\core_assembled_flatwise_12turns.step)
  Ns11_Section1 [copper] = Ns11.section(plane=ZX)
  Ns12 [copper - tempDependent] = imported_body(C:\Users\karlr\Documents\core_assembled_flatwise_12turns.step)
  Ns12_Section1 = Ns12.section(plane=ZX)
  Ns2 [copper - tempDependent] = imported_body(C:\Users\karlr\Documents\core_assembled_flatwise_12turns.step)
  Ns2_Section1 [copper] = Ns2.section(plane=ZX)
  Ns3 [copper - tempDependent] = imported_body(C:\Users\karlr\Documents\core_assembled_flatwise_12turns.step)
  Ns3_Section1 [copper] = Ns3.section(plane=ZX)
  Ns4 [copper - tempDependent] = imported_body(C:\Users\karlr\Documents\core_assembled_flatwise_12turns.step)
  Ns4_Section1 [copper] = Ns4.section(plane=ZX)
  Ns5 [copper - tempDependent] = imported_body(C:\Users\karlr\Documents\core_assembled_flatwise_12turns.step)
  Ns5_Section1 [copper] = Ns5.section(plane=ZX)
  Ns6 [copper - tempDependent] = imported_body(C:\Users\karlr\Documents\core_assembled_flatwise_12turns.step)
  Ns6_Section1 [copper] = Ns6.section(plane=ZX)
  Ns7 [copper - tempDependent] = imported_body(C:\Users\karlr\Documents\core_assembled_flatwise_12turns.step)
  Ns7_Section1 [copper] = Ns7.section(plane=ZX)
  Ns8 [copper - tempDependent] = imported_body(C:\Users\karlr\Documents\core_assembled_flatwise_12turns.step)
  Ns8_Section1 [copper] = Ns8.section(plane=ZX)
  Ns9 [copper - tempDependent] = imported_body(C:\Users\karlr\Documents\core_assembled_flatwise_12turns.step)
  Ns9_Section1 [copper] = Ns9.section(plane=ZX)
  plate_1, plate_2 [Al_N] = imported_body(C:\Users\karlr\Documents\core_assembled_flatwise_12turns.step)
  Body1 [ferrite_tempdependent] = imported_body(C:\Users\karlr\Documents\core_assembled_flatwise_12turns.step)
  Body1_1, Body1_2 [aluminum] = imported_body(C:\Users\karlr\Documents\core_assembled_flatwise_12turns.step)
  Body1_3 [ferrite_tempdependent] = imported_body(C:\Users\karlr\Documents\core_assembled_flatwise_12turns.step)
  Body1_4, Body1_5 [aluminum] = imported_body(C:\Users\karlr\Documents\core_assembled_flatwise_12turns.step)
  Np1_Section1.separate_bodies()
  Np2_Section1.separate_bodies()
  Np3_Section1.separate_bodies()
  Np4_Section1.separate_bodies()
  Np5_Section1.separate_bodies()
  Np6_Section1.separate_bodies()
  Np7_Section1.separate_bodies()
  Np8_Section1.separate_bodies()
  Np9_Section1.separate_bodies()
  Np10_Section1.separate_bodies()
  Np11_Section1.separate_bodies()
  Np12_Section1.separate_bodies()
  Ns1_Section1.separate_bodies()
  Ns2_Section1.separate_bodies()
  Ns3_Section1.separate_bodies()
  Ns4_Section1.separate_bodies()
  Ns5_Section1.separate_bodies()
  Ns6_Section1.separate_bodies()
  Ns7_Section1.separate_bodies()
  Ns8_Section1.separate_bodies()
  Ns9_Section1.separate_bodies()
  Ns10_Section1.separate_bodies()
  Ns11_Section1.separate_bodies()
  Ns12_Section1_Separate1 [copper] = Ns12_Section1.separate_bodies()
  Ns12_Section1.delete()
  Rectangle1 [non-model] = rectangle(corner=(45.8mm, 22.75mm, 0mm), z_size=20mm, x_size=-45.8mm)
  Region [air] = region(percentage_offset=1000 on all sides)
  MeshRegion1_SubRegion [air, non-model] = sub_region(of=Np5, Np2, plate_1, Np10, plate_2, Ns3, Np3, Ns6, Np1, Np4, Np6, Ns5, Np7, Ns8, Np8, Ns2, Np9, Np11, Ns9, Np12, Ns1, Ns4, Ns10, Ns7, Ns11, Ns12, percentage_offset=0 on all sides)
  group core_assembled_flatwise = Np1, Np10, Np11, Np12, Np2..Np9, Ns1, Ns10, Ns11, Ns12, Ns2..Ns9, plate_1, plate_2, Np1_Section1, Np2_Section1, Np3_Section1, Np4_Section1, Np5_Section1, Np6_Section1, Np7_Section1, Np8_Section1, Np9_Section1, Np10_Section1, Np11_Section1, Np12_Section1, Ns1_Section1, Ns2_Section1, Ns3_Section1, Ns4_Section1, Ns5_Section1, Ns6_Section1, Ns7_Section1, Ns8_Section1, Ns9_Section1, Ns10_Section1, Ns11_Section1, Ns12_Section1_Separate1
  group core_together_1 = Body1, Body1_1, Body1_2
  group core_together = Body1_3, Body1_4, Body1_5
boundaries and excitations:
  EMLoss1: EM Loss Objects=[Body1_1, Body1_2, Body1_4, Body1_5, Body1_3, Body1] LinkID=7 Project="This Project*" Product="Maxwell 3D" Design=12turns_3D_CoreLoss_FullInterleaved_tempdependent ForceSourceToSolve PreservePartnerSoln PathRelativeTo=TargetProject Intrinsics(28.5kHz) LossMultiplier=1
  EMLoss2: EM Loss Objects=[Np1..Np12, Ns1..Ns12] LinkID=34 Project="This Project*" Product="Maxwell 3D" Design=12turns_3D_WindingLoss_FullInterleaved_tempdependent ForceSourceToSolve PreservePartnerSoln PathRelativeTo=TargetProject Intrinsics(28.5kHz) LossMultiplier=1
  Opening1: Opening Faces=Region.face(-y) Temperature=AmbientTemp External_Rad._Temperature=AmbientRadTemp Inlet_Type=Pressure Total_Pressure=AmbientPressure
  Opening2: Opening Faces=Region.face(+y) Temperature=AmbientTemp External_Rad._Temperature=AmbientRadTemp Inlet_Type=Velocity Static_Pressure=AmbientPressure X_Velocity=0m_per_sec Y_Velocity=0m_per_sec Z_Velocity=0m_per_sec
mesh:
  Global:  MeshMethod=MesherHD ComputeGap MeshRegionResolution=5 MinGapX=1mm MinGapY=1mm MinGapZ=1mm Objects=Region FacetLevel=5 ProximitySizeFunction CurvatureSizeFunction OptimizePCBMesh
  MeshRegion1:  MeshMethod=MesherHD MeshRegionResolution=5 MinGapX=1mm MinGapY=1mm MinGapZ=0.72mm Objects=MeshRegion1_SubRegion ProximitySizeFunction CurvatureSizeFunction OptimizePCBMesh
setups:
  Setup1: IcepakSteadyState Flow_Regime=Laminar Include_Temperature=true Include_Flow=true Include_Gravity Solution_Initialization_-_Z_Velocity=0.000980665m_per_sec Convergence_Criteria_-_Flow=0.001 Convergence_Criteria_-_Energy=1e-07 Convergence_Criteria_-_Discrete_Ordinates=1e-06 GPU_Convergence_Criteria_-_Flow=0.001 GPU_Convergence_Criteria_-_Energy=1e-05 GPU_Convergence_Criteria_-_Discrete_Ordinates=1e-05 Radiation_Model="Discrete Ordinates Model" Flow_Iteration_Per_Radiation_Iteration=10 Time_Step_Interval=1 ThetaDivision=2 PhiDivision=2 ThetaPixels=2 PhiPixels=2 Under-relaxation_-_Pressure=0.7 Under-relaxation_-_Momentum=0.3 Under-relaxation_-_Temperature=1 Under-relaxation_-_Body_Force=1 Discretization_Scheme_-_Pressure=Standard Discretization_Scheme_-_Momentum=First Discretization_Scheme_-_Temperature=First Discretization_Scheme_-_Discrete_Ordinates=First 2WayCoupling{NumCouplingIters=2 ContinueIcepakIterations IcepakIterationsPerCoupling=30} Convergence_Criteria_-_Max_Iterations=120
field plots:
  Temperature1: Temperature over Np1.face(all 10) Np10.face(all 10) Np11.face(all 10) Np12.face(all 10) Np2.face(all 10) Np3.face(all 10) Np4.face(all 10) Np5.face(all 10) Np6.face(all 10) Np7.face(all 10) Np8.face(all 10) Np9.face(all 10) Ns1.face(all 10) Ns10.face(all 10) Ns11.face(all 10) Ns12.face(all 10) Ns2.face(all 10) Ns3.face(all 10) Ns4.face(all 10) Ns5.face(all 10) Ns6.face(all 10) Ns7.face(all 10) Ns8.face(all 10) Ns9.face(all 10) plate_1.face(all 10) plate_2.face(all 10) Body1.face(all 14) Body1_1.face(all 10) Body1_2.face(all 10) Body1_3.face(all 14) Body1_4.face(all 10) Body1_5.face(all 10) on Setup1 : SteadyState

design edgewise_thermal (Icepak, SteadyState TemperatureAndFlow, model units mm)
options: Default_Fluid_Material=air Default_Solid_Material=Al-Extruded Default_Surface_Material=Steel-oxidised-surface AmbientTemperature=20cel AmbientPressure=0n_per_meter_sq AmbientRadiationTemperature=20cel Gravity_Vector_CS_ID=Global Gravity_Vector_Axis=Z Positive=false Altitude=0meter OperatingPressure=101325n_per_meter_sq OperatingDensity=1.225kg_per_m3
geometry:
  Np1 [copper] = imported_body(C:\Users\karlr\Documents\core_assembled_edgewise v3again.step)
  Np1_Section1 [copper] = Np1.section(plane=ZX)
  Np10 [copper] = imported_body(C:\Users\karlr\Documents\core_assembled_edgewise v3again.step)
  Np10_Section1 [copper] = Np10.section(plane=ZX)
  Np11 [copper] = imported_body(C:\Users\karlr\Documents\core_assembled_edgewise v3again.step)
  Np11_Section1 [copper] = Np11.section(plane=ZX)
  Np12 [copper] = imported_body(C:\Users\karlr\Documents\core_assembled_edgewise v3again.step)
  Np12_Section1 [copper] = Np12.section(plane=ZX)
  Np2 [copper] = imported_body(C:\Users\karlr\Documents\core_assembled_edgewise v3again.step)
  Np2_Section1 [copper] = Np2.section(plane=ZX)
  Np3 [copper] = imported_body(C:\Users\karlr\Documents\core_assembled_edgewise v3again.step)
  Np3_Section1 [copper] = Np3.section(plane=ZX)
  Np4 [copper] = imported_body(C:\Users\karlr\Documents\core_assembled_edgewise v3again.step)
  Np4_Section1 [copper] = Np4.section(plane=ZX)
  Np5 [copper] = imported_body(C:\Users\karlr\Documents\core_assembled_edgewise v3again.step)
  Np5_Section1 [copper] = Np5.section(plane=ZX)
  Np6 [copper] = imported_body(C:\Users\karlr\Documents\core_assembled_edgewise v3again.step)
  Np6_Section1 [copper] = Np6.section(plane=ZX)
  Np7 [copper] = imported_body(C:\Users\karlr\Documents\core_assembled_edgewise v3again.step)
  Np7_Section1 [copper] = Np7.section(plane=ZX)
  Np8 [copper] = imported_body(C:\Users\karlr\Documents\core_assembled_edgewise v3again.step)
  Np8_Section1 [copper] = Np8.section(plane=ZX)
  Np9 [copper] = imported_body(C:\Users\karlr\Documents\core_assembled_edgewise v3again.step)
  Np9_Section1 [copper] = Np9.section(plane=ZX)
  Ns1 [copper] = imported_body(C:\Users\karlr\Documents\core_assembled_edgewise v3again.step)
  Ns1_Section1 [copper] = Ns1.section(plane=ZX)
  Ns10 [copper] = imported_body(C:\Users\karlr\Documents\core_assembled_edgewise v3again.step)
  Ns10_Section1 [copper] = Ns10.section(plane=ZX)
  Ns11 [copper] = imported_body(C:\Users\karlr\Documents\core_assembled_edgewise v3again.step)
  Ns11_Section1 [copper] = Ns11.section(plane=ZX)
  Ns12 [copper] = imported_body(C:\Users\karlr\Documents\core_assembled_edgewise v3again.step)
  Ns12_Section1 [copper] = Ns12.section(plane=ZX)
  Ns2 [copper] = imported_body(C:\Users\karlr\Documents\core_assembled_edgewise v3again.step)
  Ns2_Section1 [copper] = Ns2.section(plane=ZX)
  Ns3 [copper] = imported_body(C:\Users\karlr\Documents\core_assembled_edgewise v3again.step)
  Ns3_Section1 [copper] = Ns3.section(plane=ZX)
  Ns4 [copper] = imported_body(C:\Users\karlr\Documents\core_assembled_edgewise v3again.step)
  Ns4_Section1 [copper] = Ns4.section(plane=ZX)
  Ns5 [copper] = imported_body(C:\Users\karlr\Documents\core_assembled_edgewise v3again.step)
  Ns5_Section1 [copper] = Ns5.section(plane=ZX)
  Ns6 [copper] = imported_body(C:\Users\karlr\Documents\core_assembled_edgewise v3again.step)
  Ns6_Section1 [copper] = Ns6.section(plane=ZX)
  Ns7 [copper] = imported_body(C:\Users\karlr\Documents\core_assembled_edgewise v3again.step)
  Ns7_Section1 [copper] = Ns7.section(plane=ZX)
  Ns8 [copper] = imported_body(C:\Users\karlr\Documents\core_assembled_edgewise v3again.step)
  Ns8_Section1 [copper] = Ns8.section(plane=ZX)
  Ns9 [copper] = imported_body(C:\Users\karlr\Documents\core_assembled_edgewise v3again.step)
  Ns9_Section1 [copper] = Ns9.section(plane=ZX)
  plate1, plate2 [Al_N] = imported_body(C:\Users\karlr\Documents\core_assembled_edgewise v3again.step)
  Body1 [ferrite - Copy] = imported_body(C:\Users\karlr\Documents\core_assembled_edgewise v3again.step)
  Body1_1, Body1_2 [aluminum] = imported_body(C:\Users\karlr\Documents\core_assembled_edgewise v3again.step)
  Body1_3 [ferrite - Copy] = imported_body(C:\Users\karlr\Documents\core_assembled_edgewise v3again.step)
  Body1_4, Body1_5 [aluminum] = imported_body(C:\Users\karlr\Documents\core_assembled_edgewise v3again.step)
  Np1_Section1.separate_bodies()
  Np2_Section1.separate_bodies()
  Np3_Section1.separate_bodies()
  Np4_Section1.separate_bodies()
  Np5_Section1.separate_bodies()
  Np6_Section1.separate_bodies()
  Np7_Section1.separate_bodies()
  Np8_Section1.separate_bodies()
  Np9_Section1.separate_bodies()
  Np10_Section1.separate_bodies()
  Np11_Section1.separate_bodies()
  Np12_Section1.separate_bodies()
  Ns1_Section1.separate_bodies()
  Ns2_Section1.separate_bodies()
  Ns3_Section1.separate_bodies()
  Ns4_Section1.separate_bodies()
  Ns5_Section1.separate_bodies()
  Ns6_Section1.separate_bodies()
  Ns7_Section1.separate_bodies()
  Ns8_Section1.separate_bodies()
  Ns9_Section1.separate_bodies()
  Ns10_Section1.separate_bodies()
  Ns11_Section1.separate_bodies()
  Ns12_Section1.separate_bodies()
  Region [air] = region(percentage_offset=1000 on all sides)
  MeshRegion1_SubRegion [air, non-model] = sub_region(of=plate1, percentage_offset=0 on all sides)
  MeshRegion2_SubRegion [air, non-model] = sub_region(of=plate2, percentage_offset=0 on all sides)
  Rectangle1 [Al-Extruded, non-model] = rectangle(corner=(0mm, 22.75mm, 0mm), z_size=22.7mm, x_size=40.8mm)
  group core_assembled_edgewise = Np1, Np10, Np11, Np12, Np2..Np9, Ns1, Ns10, Ns11, Ns12, Ns2..Ns9, plate1, plate2, Np1_Section1, Np2_Section1, Np3_Section1, Np4_Section1, Np5_Section1, Np6_Section1, Np7_Section1, Np8_Section1, Np9_Section1, Np10_Section1, Np11_Section1, Np12_Section1, Ns1_Section1, Ns2_Section1, Ns3_Section1, Ns4_Section1, Ns5_Section1, Ns6_Section1, Ns7_Section1, Ns8_Section1, Ns9_Section1, Ns10_Section1, Ns11_Section1, Ns12_Section1
  group core_together_1 = Body1, Body1_1, Body1_2
  group core_together = Body1_3, Body1_4, Body1_5
boundaries and excitations:
  EMLoss1: EM Loss Objects=[Np1..Np12, Ns1..Ns12] LinkID=8 Project="This Project*" Product="Maxwell 3D" Design=12turns_3D_Thermal_FullInterleaved_Edgewise_winding ForceSourceToSolve PreservePartnerSoln PathRelativeTo=TargetProject Intrinsics(28.5kHz) LossMultiplier=1
  EMLoss2: EM Loss Objects=[Body1_4, Body1_5, Body1_3, Body1_1, Body1_2, Body1] LinkID=11 Project="This Project*" Product="Maxwell 3D" Design=12turns_3D_Thermal_FullInterleaved_Edgewise ForceSourceToSolve PreservePartnerSoln PathRelativeTo=TargetProject Intrinsics(28.5kHz) LossMultiplier=1
  Opening1: Opening Faces=Region.face(-y) Temperature=AmbientTemp External_Rad._Temperature=AmbientRadTemp Inlet_Type=Pressure Total_Pressure=AmbientPressure
  Opening2: Opening Faces=Region.face(+y) Temperature=AmbientTemp External_Rad._Temperature=AmbientRadTemp Inlet_Type=Velocity Static_Pressure=AmbientPressure X_Velocity=0m_per_sec Y_Velocity=0m_per_sec Z_Velocity=0m_per_sec
mesh:
  Global:  MeshMethod=MesherHD ComputeGap MeshRegionResolution=5 MinGapX=1mm MinGapY=1mm MinGapZ=1mm Objects=Region FacetLevel=5 ProximitySizeFunction CurvatureSizeFunction OptimizePCBMesh
  MeshRegion1:  MeshMethod=MesherHD MeshRegionResolution=5 MinGapX=1mm MinGapY=1mm MinGapZ=0.0099999983mm Objects=MeshRegion1_SubRegion ProximitySizeFunction CurvatureSizeFunction OptimizePCBMesh
  MeshRegion2:  MeshMethod=MesherHD MeshRegionResolution=5 MinGapX=1mm MinGapY=1mm MinGapZ=0.0099999983mm Objects=MeshRegion2_SubRegion ProximitySizeFunction CurvatureSizeFunction OptimizePCBMesh
setups:
  Setup1: IcepakSteadyState Flow_Regime=Laminar Include_Temperature=true Include_Flow=true Include_Gravity Solution_Initialization_-_Z_Velocity=0.000980665m_per_sec Convergence_Criteria_-_Flow=0.001 Convergence_Criteria_-_Energy=1e-07 Convergence_Criteria_-_Discrete_Ordinates=1e-06 GPU_Convergence_Criteria_-_Flow=0.001 GPU_Convergence_Criteria_-_Energy=1e-05 GPU_Convergence_Criteria_-_Discrete_Ordinates=1e-05 Radiation_Model="Discrete Ordinates Model" Flow_Iteration_Per_Radiation_Iteration=10 Time_Step_Interval=1 ThetaDivision=2 PhiDivision=2 ThetaPixels=2 PhiPixels=2 Under-relaxation_-_Pressure=0.7 Under-relaxation_-_Momentum=0.3 Under-relaxation_-_Temperature=1 Under-relaxation_-_Body_Force=1 Discretization_Scheme_-_Pressure=Standard Discretization_Scheme_-_Momentum=First Discretization_Scheme_-_Temperature=First Discretization_Scheme_-_Discrete_Ordinates=First Convergence_Criteria_-_Max_Iterations=60
field plots:
  Temperature2: Temperature over a plane on Setup1 : SteadyState
  Temperature1: Temperature over Np1.face(all 10) Np10.face(all 10) Np11.face(all 10) Np12.face(all 10) Np2.face(all 10) Np3.face(all 10) Np4.face(all 10) Np5.face(all 10) Np6.face(all 10) Np7.face(all 10) Np8.face(all 10) Np9.face(all 10) Ns1.face(all 10) Ns10.face(all 10) Ns11.face(all 10) Ns12.face(all 10) Ns2.face(all 10) Ns3.face(all 10) Ns4.face(all 10) Ns5.face(all 10) Ns6.face(all 10) Ns7.face(all 10) Ns8.face(all 10) Ns9.face(all 10) plate1.face(all 10) plate2.face(all 10) Body1.face(all 14) Body1_1.face(all 10) Body1_2.face(all 10) Body1_3.face(all 14) Body1_4.face(all 10) Body1_5.face(all 10) on Setup1 : SteadyState

design edgewise_thermal1 (Icepak, SteadyState TemperatureAndFlow, model units mm)
options: Default_Fluid_Material=air Default_Solid_Material=Al-Extruded Default_Surface_Material=Steel-oxidised-surface AmbientTemperature=20cel AmbientPressure=0n_per_meter_sq AmbientRadiationTemperature=20cel Gravity_Vector_CS_ID=Global Gravity_Vector_Axis=Z Positive=false Altitude=0meter OperatingPressure=101325n_per_meter_sq OperatingDensity=1.225kg_per_m3
geometry:
  Np1 [copper] = imported_body(C:\Users\karlr\Documents\core_assembled_edgewise v3again.step)
  Np1_Section1 [copper] = Np1.section(plane=ZX)
  Np10 [copper] = imported_body(C:\Users\karlr\Documents\core_assembled_edgewise v3again.step)
  Np10_Section1 [copper] = Np10.section(plane=ZX)
  Np11 [copper] = imported_body(C:\Users\karlr\Documents\core_assembled_edgewise v3again.step)
  Np11_Section1 [copper] = Np11.section(plane=ZX)
  Np12 [copper] = imported_body(C:\Users\karlr\Documents\core_assembled_edgewise v3again.step)
  Np12_Section1 [copper] = Np12.section(plane=ZX)
  Np2 [copper] = imported_body(C:\Users\karlr\Documents\core_assembled_edgewise v3again.step)
  Np2_Section1 [copper] = Np2.section(plane=ZX)
  Np3 [copper] = imported_body(C:\Users\karlr\Documents\core_assembled_edgewise v3again.step)
  Np3_Section1 [copper] = Np3.section(plane=ZX)
  Np4 [copper] = imported_body(C:\Users\karlr\Documents\core_assembled_edgewise v3again.step)
  Np4_Section1 [copper] = Np4.section(plane=ZX)
  Np5 [copper] = imported_body(C:\Users\karlr\Documents\core_assembled_edgewise v3again.step)
  Np5_Section1 [copper] = Np5.section(plane=ZX)
  Np6 [copper] = imported_body(C:\Users\karlr\Documents\core_assembled_edgewise v3again.step)
  Np6_Section1 [copper] = Np6.section(plane=ZX)
  Np7 [copper] = imported_body(C:\Users\karlr\Documents\core_assembled_edgewise v3again.step)
  Np7_Section1 [copper] = Np7.section(plane=ZX)
  Np8 [copper] = imported_body(C:\Users\karlr\Documents\core_assembled_edgewise v3again.step)
  Np8_Section1 [copper] = Np8.section(plane=ZX)
  Np9 [copper] = imported_body(C:\Users\karlr\Documents\core_assembled_edgewise v3again.step)
  Np9_Section1 [copper] = Np9.section(plane=ZX)
  Ns1 [copper] = imported_body(C:\Users\karlr\Documents\core_assembled_edgewise v3again.step)
  Ns1_Section1 [copper] = Ns1.section(plane=ZX)
  Ns10 [copper] = imported_body(C:\Users\karlr\Documents\core_assembled_edgewise v3again.step)
  Ns10_Section1 [copper] = Ns10.section(plane=ZX)
  Ns11 [copper] = imported_body(C:\Users\karlr\Documents\core_assembled_edgewise v3again.step)
  Ns11_Section1 [copper] = Ns11.section(plane=ZX)
  Ns12 [copper] = imported_body(C:\Users\karlr\Documents\core_assembled_edgewise v3again.step)
  Ns12_Section1 [copper] = Ns12.section(plane=ZX)
  Ns2 [copper] = imported_body(C:\Users\karlr\Documents\core_assembled_edgewise v3again.step)
  Ns2_Section1 [copper] = Ns2.section(plane=ZX)
  Ns3 [copper] = imported_body(C:\Users\karlr\Documents\core_assembled_edgewise v3again.step)
  Ns3_Section1 [copper] = Ns3.section(plane=ZX)
  Ns4 [copper] = imported_body(C:\Users\karlr\Documents\core_assembled_edgewise v3again.step)
  Ns4_Section1 [copper] = Ns4.section(plane=ZX)
  Ns5 [copper] = imported_body(C:\Users\karlr\Documents\core_assembled_edgewise v3again.step)
  Ns5_Section1 [copper] = Ns5.section(plane=ZX)
  Ns6 [copper] = imported_body(C:\Users\karlr\Documents\core_assembled_edgewise v3again.step)
  Ns6_Section1 [copper] = Ns6.section(plane=ZX)
  Ns7 [copper] = imported_body(C:\Users\karlr\Documents\core_assembled_edgewise v3again.step)
  Ns7_Section1 [copper] = Ns7.section(plane=ZX)
  Ns8 [copper] = imported_body(C:\Users\karlr\Documents\core_assembled_edgewise v3again.step)
  Ns8_Section1 [copper] = Ns8.section(plane=ZX)
  Ns9 [copper] = imported_body(C:\Users\karlr\Documents\core_assembled_edgewise v3again.step)
  Ns9_Section1 [copper] = Ns9.section(plane=ZX)
  plate1, plate2 [Al_N] = imported_body(C:\Users\karlr\Documents\core_assembled_edgewise v3again.step)
  Body1 [ferrite - Copy] = imported_body(C:\Users\karlr\Documents\core_assembled_edgewise v3again.step)
  Body1_1, Body1_2 [aluminum] = imported_body(C:\Users\karlr\Documents\core_assembled_edgewise v3again.step)
  Body1_3 [ferrite - Copy] = imported_body(C:\Users\karlr\Documents\core_assembled_edgewise v3again.step)
  Body1_4, Body1_5 [aluminum] = imported_body(C:\Users\karlr\Documents\core_assembled_edgewise v3again.step)
  Np1_Section1.separate_bodies()
  Np2_Section1.separate_bodies()
  Np3_Section1.separate_bodies()
  Np4_Section1.separate_bodies()
  Np5_Section1.separate_bodies()
  Np6_Section1.separate_bodies()
  Np7_Section1.separate_bodies()
  Np8_Section1.separate_bodies()
  Np9_Section1.separate_bodies()
  Np10_Section1.separate_bodies()
  Np11_Section1.separate_bodies()
  Np12_Section1.separate_bodies()
  Ns1_Section1.separate_bodies()
  Ns2_Section1.separate_bodies()
  Ns3_Section1.separate_bodies()
  Ns4_Section1.separate_bodies()
  Ns5_Section1.separate_bodies()
  Ns6_Section1.separate_bodies()
  Ns7_Section1.separate_bodies()
  Ns8_Section1.separate_bodies()
  Ns9_Section1.separate_bodies()
  Ns10_Section1.separate_bodies()
  Ns11_Section1.separate_bodies()
  Ns12_Section1.separate_bodies()
  Region [air] = region(percentage_offset=1000 on all sides)
  MeshRegion1_SubRegion [air, non-model] = sub_region(of=plate1, percentage_offset=0 on all sides)
  MeshRegion2_SubRegion [air, non-model] = sub_region(of=plate2, percentage_offset=0 on all sides)
  Rectangle1 [Al-Extruded, non-model] = rectangle(corner=(0mm, 22.75mm, 0mm), z_size=22.7mm, x_size=40.8mm)
  group core_assembled_edgewise = Np1, Np10, Np11, Np12, Np2..Np9, Ns1, Ns10, Ns11, Ns12, Ns2..Ns9, plate1, plate2, Np1_Section1, Np2_Section1, Np3_Section1, Np4_Section1, Np5_Section1, Np6_Section1, Np7_Section1, Np8_Section1, Np9_Section1, Np10_Section1, Np11_Section1, Np12_Section1, Ns1_Section1, Ns2_Section1, Ns3_Section1, Ns4_Section1, Ns5_Section1, Ns6_Section1, Ns7_Section1, Ns8_Section1, Ns9_Section1, Ns10_Section1, Ns11_Section1, Ns12_Section1
  group core_together_1 = Body1, Body1_1, Body1_2
  group core_together = Body1_3, Body1_4, Body1_5
boundaries and excitations:
  EMLoss1: EM Loss Objects=[Np1..Np12, Ns1..Ns12] LinkID=8 Project="This Project*" Product="Maxwell 3D" Design=12turns_3D_Thermal_FullInterleaved_Edgewise_winding ForceSourceToSolve PreservePartnerSoln PathRelativeTo=TargetProject Intrinsics(28.5kHz) LossMultiplier=1
  EMLoss2: EM Loss Objects=[Body1_4, Body1_5, Body1_3, Body1_1, Body1_2, Body1] LinkID=11 Project="This Project*" Product="Maxwell 3D" Design=12turns_3D_Thermal_FullInterleaved_Edgewise ForceSourceToSolve PreservePartnerSoln PathRelativeTo=TargetProject Intrinsics(28.5kHz) LossMultiplier=1
  Opening1: Opening Faces=Region.face(-y) Temperature=AmbientTemp External_Rad._Temperature=AmbientRadTemp Inlet_Type=Pressure Total_Pressure=AmbientPressure
  Opening2: Opening Faces=Region.face(+y) Temperature=AmbientTemp External_Rad._Temperature=AmbientRadTemp Inlet_Type=Velocity Static_Pressure=AmbientPressure X_Velocity=0m_per_sec Y_Velocity=0m_per_sec Z_Velocity=0m_per_sec
mesh:
  Global:  MeshMethod=MesherHD ComputeGap MeshRegionResolution=5 MinGapX=1mm MinGapY=1mm MinGapZ=1mm Objects=Region FacetLevel=5 ProximitySizeFunction CurvatureSizeFunction OptimizePCBMesh
  MeshRegion1:  MeshMethod=MesherHD MeshRegionResolution=5 MinGapX=1mm MinGapY=1mm MinGapZ=0.0099999983mm Objects=MeshRegion1_SubRegion ProximitySizeFunction CurvatureSizeFunction OptimizePCBMesh
  MeshRegion2:  MeshMethod=MesherHD MeshRegionResolution=5 MinGapX=1mm MinGapY=1mm MinGapZ=0.0099999983mm Objects=MeshRegion2_SubRegion ProximitySizeFunction CurvatureSizeFunction OptimizePCBMesh
setups:
  Setup1: IcepakSteadyState Flow_Regime=Laminar Include_Temperature=true Include_Flow=true Include_Gravity Solution_Initialization_-_Z_Velocity=0.000980665m_per_sec Convergence_Criteria_-_Flow=0.001 Convergence_Criteria_-_Energy=1e-07 Convergence_Criteria_-_Discrete_Ordinates=1e-06 GPU_Convergence_Criteria_-_Flow=0.001 GPU_Convergence_Criteria_-_Energy=1e-05 GPU_Convergence_Criteria_-_Discrete_Ordinates=1e-05 Radiation_Model="Discrete Ordinates Model" Flow_Iteration_Per_Radiation_Iteration=10 Time_Step_Interval=1 ThetaDivision=2 PhiDivision=2 ThetaPixels=2 PhiPixels=2 Under-relaxation_-_Pressure=0.7 Under-relaxation_-_Momentum=0.3 Under-relaxation_-_Temperature=1 Under-relaxation_-_Body_Force=1 Discretization_Scheme_-_Pressure=Standard Discretization_Scheme_-_Momentum=First Discretization_Scheme_-_Temperature=First Discretization_Scheme_-_Discrete_Ordinates=First Convergence_Criteria_-_Max_Iterations=500
field plots:
  Temperature2: Temperature over a plane on Setup1 : SteadyState
  Temperature1: Temperature over Np1.face(all 10) Np10.face(all 10) Np11.face(all 10) Np12.face(all 10) Np2.face(all 10) Np3.face(all 10) Np4.face(all 10) Np5.face(all 10) Np6.face(all 10) Np7.face(all 10) Np8.face(all 10) Np9.face(all 10) Ns1.face(all 10) Ns10.face(all 10) Ns11.face(all 10) Ns12.face(all 10) Ns2.face(all 10) Ns3.face(all 10) Ns4.face(all 10) Ns5.face(all 10) Ns6.face(all 10) Ns7.face(all 10) Ns8.face(all 10) Ns9.face(all 10) plate1.face(all 10) plate2.face(all 10) Body1.face(all 14) Body1_1.face(all 10) Body1_2.face(all 10) Body1_3.face(all 14) Body1_4.face(all 10) Body1_5.face(all 10) on Setup1 : SteadyState

design 12turns_3D_Thermal_FullInterleaved1 (Icepak, SteadyState TemperatureAndFlow, model units mm)
options: Default_Fluid_Material=air Default_Solid_Material=Al-Extruded Default_Surface_Material=Steel-oxidised-surface AmbientTemperature=20cel AmbientPressure=0n_per_meter_sq AmbientRadiationTemperature=20cel Gravity_Vector_CS_ID=Global Gravity_Vector_Axis=Z Positive=false Altitude=0meter OperatingPressure=101325n_per_meter_sq OperatingDensity=1.225kg_per_m3
geometry:
  Np1 [copper] = imported_body(C:\Users\karlr\Documents\core_assembled_flatwise_12turns.step)
  Np1_Section1 [copper] = Np1.section(plane=ZX)
  Np10 [copper] = imported_body(C:\Users\karlr\Documents\core_assembled_flatwise_12turns.step)
  Np10_Section1 [copper] = Np10.section(plane=ZX)
  Np11 [copper] = imported_body(C:\Users\karlr\Documents\core_assembled_flatwise_12turns.step)
  Np11_Section1 [copper] = Np11.section(plane=ZX)
  Np12 [copper] = imported_body(C:\Users\karlr\Documents\core_assembled_flatwise_12turns.step)
  Np12_Section1 [copper] = Np12.section(plane=ZX)
  Np2 [copper] = imported_body(C:\Users\karlr\Documents\core_assembled_flatwise_12turns.step)
  Np2_Section1 [copper] = Np2.section(plane=ZX)
  Np3 [copper] = imported_body(C:\Users\karlr\Documents\core_assembled_flatwise_12turns.step)
  Np3_Section1 [copper] = Np3.section(plane=ZX)
  Np4 [copper] = imported_body(C:\Users\karlr\Documents\core_assembled_flatwise_12turns.step)
  Np4_Section1 [copper] = Np4.section(plane=ZX)
  Np5 [copper] = imported_body(C:\Users\karlr\Documents\core_assembled_flatwise_12turns.step)
  Np5_Section1 [copper] = Np5.section(plane=ZX)
  Np6 [copper] = imported_body(C:\Users\karlr\Documents\core_assembled_flatwise_12turns.step)
  Np6_Section1 [copper] = Np6.section(plane=ZX)
  Np7 [copper] = imported_body(C:\Users\karlr\Documents\core_assembled_flatwise_12turns.step)
  Np7_Section1 [copper] = Np7.section(plane=ZX)
  Np8 [copper] = imported_body(C:\Users\karlr\Documents\core_assembled_flatwise_12turns.step)
  Np8_Section1 [copper] = Np8.section(plane=ZX)
  Np9 [copper] = imported_body(C:\Users\karlr\Documents\core_assembled_flatwise_12turns.step)
  Np9_Section1 [copper] = Np9.section(plane=ZX)
  Ns1 [copper] = imported_body(C:\Users\karlr\Documents\core_assembled_flatwise_12turns.step)
  Ns1_Section1 [copper] = Ns1.section(plane=ZX)
  Ns10 [copper] = imported_body(C:\Users\karlr\Documents\core_assembled_flatwise_12turns.step)
  Ns10_Section1 [copper] = Ns10.section(plane=ZX)
  Ns11 [copper] = imported_body(C:\Users\karlr\Documents\core_assembled_flatwise_12turns.step)
  Ns11_Section1 [copper] = Ns11.section(plane=ZX)
  Ns12 [copper] = imported_body(C:\Users\karlr\Documents\core_assembled_flatwise_12turns.step)
  Ns12_Section1 = Ns12.section(plane=ZX)
  Ns2 [copper] = imported_body(C:\Users\karlr\Documents\core_assembled_flatwise_12turns.step)
  Ns2_Section1 [copper] = Ns2.section(plane=ZX)
  Ns3 [copper] = imported_body(C:\Users\karlr\Documents\core_assembled_flatwise_12turns.step)
  Ns3_Section1 [copper] = Ns3.section(plane=ZX)
  Ns4 [copper] = imported_body(C:\Users\karlr\Documents\core_assembled_flatwise_12turns.step)
  Ns4_Section1 [copper] = Ns4.section(plane=ZX)
  Ns5 [copper] = imported_body(C:\Users\karlr\Documents\core_assembled_flatwise_12turns.step)
  Ns5_Section1 [copper] = Ns5.section(plane=ZX)
  Ns6 [copper] = imported_body(C:\Users\karlr\Documents\core_assembled_flatwise_12turns.step)
  Ns6_Section1 [copper] = Ns6.section(plane=ZX)
  Ns7 [copper] = imported_body(C:\Users\karlr\Documents\core_assembled_flatwise_12turns.step)
  Ns7_Section1 [copper] = Ns7.section(plane=ZX)
  Ns8 [copper] = imported_body(C:\Users\karlr\Documents\core_assembled_flatwise_12turns.step)
  Ns8_Section1 [copper] = Ns8.section(plane=ZX)
  Ns9 [copper] = imported_body(C:\Users\karlr\Documents\core_assembled_flatwise_12turns.step)
  Ns9_Section1 [copper] = Ns9.section(plane=ZX)
  plate_1, plate_2 [Al_N] = imported_body(C:\Users\karlr\Documents\core_assembled_flatwise_12turns.step)
  Body1 [ferrite - Copy] = imported_body(C:\Users\karlr\Documents\core_assembled_flatwise_12turns.step)
  Body1_1, Body1_2 [aluminum] = imported_body(C:\Users\karlr\Documents\core_assembled_flatwise_12turns.step)
  Body1_3 [ferrite - Copy] = imported_body(C:\Users\karlr\Documents\core_assembled_flatwise_12turns.step)
  Body1_4, Body1_5 [aluminum] = imported_body(C:\Users\karlr\Documents\core_assembled_flatwise_12turns.step)
  Np1_Section1.separate_bodies()
  Np2_Section1.separate_bodies()
  Np3_Section1.separate_bodies()
  Np4_Section1.separate_bodies()
  Np5_Section1.separate_bodies()
  Np6_Section1.separate_bodies()
  Np7_Section1.separate_bodies()
  Np8_Section1.separate_bodies()
  Np9_Section1.separate_bodies()
  Np10_Section1.separate_bodies()
  Np11_Section1.separate_bodies()
  Np12_Section1.separate_bodies()
  Ns1_Section1.separate_bodies()
  Ns2_Section1.separate_bodies()
  Ns3_Section1.separate_bodies()
  Ns4_Section1.separate_bodies()
  Ns5_Section1.separate_bodies()
  Ns6_Section1.separate_bodies()
  Ns7_Section1.separate_bodies()
  Ns8_Section1.separate_bodies()
  Ns9_Section1.separate_bodies()
  Ns10_Section1.separate_bodies()
  Ns11_Section1.separate_bodies()
  Ns12_Section1_Separate1 [copper] = Ns12_Section1.separate_bodies()
  Ns12_Section1.delete()
  Rectangle1 [non-model] = rectangle(corner=(45.8mm, 22.75mm, 0mm), z_size=20mm, x_size=-45.8mm)
  Region [air] = region(percentage_offset=1000 on all sides)
  MeshRegion1_SubRegion [air, non-model] = sub_region(of=Np5, Np2, plate_1, Np10, plate_2, Ns3, Np3, Ns6, Np1, Np4, Np6, Ns5, Np7, Ns8, Np8, Ns2, Np9, Np11, Ns9, Np12, Ns1, Ns4, Ns10, Ns7, Ns11, Ns12, percentage_offset=0 on all sides)
  group core_assembled_flatwise = Np1, Np10, Np11, Np12, Np2..Np9, Ns1, Ns10, Ns11, Ns12, Ns2..Ns9, plate_1, plate_2, Np1_Section1, Np2_Section1, Np3_Section1, Np4_Section1, Np5_Section1, Np6_Section1, Np7_Section1, Np8_Section1, Np9_Section1, Np10_Section1, Np11_Section1, Np12_Section1, Ns1_Section1, Ns2_Section1, Ns3_Section1, Ns4_Section1, Ns5_Section1, Ns6_Section1, Ns7_Section1, Ns8_Section1, Ns9_Section1, Ns10_Section1, Ns11_Section1, Ns12_Section1_Separate1
  group core_together_1 = Body1, Body1_1, Body1_2
  group core_together = Body1_3, Body1_4, Body1_5
boundaries and excitations:
  EMLoss1: EM Loss Objects=[Body1_1, Body1_2, Body1_4, Body1_5, Body1_3, Body1] LinkID=7 Project="This Project*" Product="Maxwell 3D" Design=12turns_3D_CoreLoss_FullInterleaved ForceSourceToSolve PreservePartnerSoln PathRelativeTo=TargetProject Intrinsics(28.5kHz) LossMultiplier=1
  EMLoss2: EM Loss Objects=[Np1..Np12, Ns1..Ns12] LinkID=34 Project="This Project*" Product="Maxwell 3D" Design=12turns_3D_WindingLoss_FullInterleaved ForceSourceToSolve PreservePartnerSoln PathRelativeTo=TargetProject Intrinsics(28.5kHz) LossMultiplier=1
  Opening1: Opening Faces=Region.face(-y) Temperature=AmbientTemp External_Rad._Temperature=AmbientRadTemp Inlet_Type=Pressure Total_Pressure=AmbientPressure
  Opening2: Opening Faces=Region.face(+y) Temperature=AmbientTemp External_Rad._Temperature=AmbientRadTemp Inlet_Type=Velocity Static_Pressure=AmbientPressure X_Velocity=0m_per_sec Y_Velocity=0m_per_sec Z_Velocity=0m_per_sec
mesh:
  Global:  MeshMethod=MesherHD ComputeGap MeshRegionResolution=5 MinGapX=1mm MinGapY=1mm MinGapZ=1mm Objects=Region FacetLevel=5 ProximitySizeFunction CurvatureSizeFunction OptimizePCBMesh
  MeshRegion1:  MeshMethod=MesherHD MeshRegionResolution=5 MinGapX=1mm MinGapY=1mm MinGapZ=0.72mm Objects=MeshRegion1_SubRegion ProximitySizeFunction CurvatureSizeFunction OptimizePCBMesh
setups:
  Setup1: IcepakSteadyState Flow_Regime=Laminar Include_Temperature=true Include_Flow=true Include_Gravity Solution_Initialization_-_Z_Velocity=0.000980665m_per_sec Convergence_Criteria_-_Flow=0.001 Convergence_Criteria_-_Energy=1e-07 Convergence_Criteria_-_Discrete_Ordinates=1e-06 GPU_Convergence_Criteria_-_Flow=0.001 GPU_Convergence_Criteria_-_Energy=1e-05 GPU_Convergence_Criteria_-_Discrete_Ordinates=1e-05 Radiation_Model="Discrete Ordinates Model" Flow_Iteration_Per_Radiation_Iteration=10 Time_Step_Interval=1 ThetaDivision=2 PhiDivision=2 ThetaPixels=2 PhiPixels=2 Under-relaxation_-_Pressure=0.7 Under-relaxation_-_Momentum=0.3 Under-relaxation_-_Temperature=1 Under-relaxation_-_Body_Force=1 Discretization_Scheme_-_Pressure=Standard Discretization_Scheme_-_Momentum=First Discretization_Scheme_-_Temperature=First Discretization_Scheme_-_Discrete_Ordinates=First Convergence_Criteria_-_Max_Iterations=500
field plots:
  Temperature1: Temperature over Np1.face(all 10) Np10.face(all 10) Np11.face(all 10) Np12.face(all 10) Np2.face(all 10) Np3.face(all 10) Np4.face(all 10) Np5.face(all 10) Np6.face(all 10) Np7.face(all 10) Np8.face(all 10) Np9.face(all 10) Ns1.face(all 10) Ns10.face(all 10) Ns11.face(all 10) Ns12.face(all 10) Ns2.face(all 10) Ns3.face(all 10) Ns4.face(all 10) Ns5.face(all 10) Ns6.face(all 10) Ns7.face(all 10) Ns8.face(all 10) Ns9.face(all 10) plate_1.face(all 10) plate_2.face(all 10) Body1.face(all 14) Body1_1.face(all 10) Body1_2.face(all 10) Body1_3.face(all 14) Body1_4.face(all 10) Body1_5.face(all 10) on Setup1 : SteadyState

design 12turns_3D_Thermal_Flatwise_TIM (Icepak, SteadyState TemperatureAndFlow, model units mm)
options: Default_Fluid_Material=air Default_Solid_Material=Al-Extruded Default_Surface_Material=Steel-oxidised-surface AmbientTemperature=20cel AmbientPressure=0n_per_meter_sq AmbientRadiationTemperature=20cel Gravity_Vector_CS_ID=Global Gravity_Vector_Axis=Z Positive=false Altitude=0meter OperatingPressure=101325n_per_meter_sq OperatingDensity=1.225kg_per_m3
geometry:
  Region [air] = region(percentage_offset=1000 on all sides)
  SubRegion [air, non-model] = sub_region(of=, percentage_offset=0 on all sides)
  Np1, Np10, Np11, Np12, Np2..Np9, Ns1, Ns10, Ns11, Ns12, Ns2..Ns9 [copper] = imported_body(C:\Users\karlr\Documents\core_flatwise_TIMSIDE.step)
  SIDE1, SIDE1_1, SIDE1_3 [Al_N] = imported_body(C:\Users\karlr\Documents\core_flatwise_TIMSIDE.step)
  SIDE1_4, SIDE1_5, SIDE1_2 = imported_body(C:\Users\karlr\Documents\core_flatwise_TIMSIDE.step)
  SIDE1_3.unite(SIDE1_4, SIDE1_5, SIDE1_2)
  Body1 [ferrite - Copy] = imported_body(C:\Users\karlr\Documents\core_flatwise_TIMSIDE.step)
  Body1_1, Body1_2 [aluminum] = imported_body(C:\Users\karlr\Documents\core_flatwise_TIMSIDE.step)
  Body1_3 [ferrite - Copy] = imported_body(C:\Users\karlr\Documents\core_flatwise_TIMSIDE.step)
  Body1_4, Body1_5 [aluminum] = imported_body(C:\Users\karlr\Documents\core_flatwise_TIMSIDE.step)
  MeshRegion2_SubRegion [air, non-model] = sub_region(of=Np2, SIDE1, SIDE1_3, SIDE1_1, Np1, Np3, Np4, Ns10, Np5, Np6, Ns4, Np7, Np8, Np10, Np9, Np11, Ns12, Np12, Ns1, Ns3, Ns2, Ns5..Ns9, Ns11, percentage_offset=0 on all sides)
  Rectangle1 [Al-Extruded, non-model] = rectangle(corner=(45.8mm, 22.75mm, 0mm), z_size=20.2mm, x_size=-45.8mm)
  group core_assembled_flatwise = Np1, Np10, Np11, Np12, Np2..Np9, Ns1, Ns10, Ns11, Ns12, Ns2..Ns9, SIDE1, SIDE1_1, SIDE1_3
  group core_together_1 = Body1, Body1_1, Body1_2
  group core_together = Body1_3, Body1_4, Body1_5
boundaries and excitations:
  Opening1: Opening Faces=Region.face(-y) Temperature=AmbientTemp External_Rad._Temperature=AmbientRadTemp Inlet_Type=Pressure Total_Pressure=AmbientPressure
  Opening2: Opening Faces=Region.face(+y) Temperature=AmbientTemp External_Rad._Temperature=AmbientRadTemp Inlet_Type=Velocity Static_Pressure=AmbientPressure X_Velocity=0m_per_sec Y_Velocity=0m_per_sec Z_Velocity=0m_per_sec
  EMLoss1: EM Loss Objects=[Np1..Np12, Ns1..Ns12] LinkID=248 Project="This Project*" Product="Maxwell 3D" Design=12turns_3D_WindingLoss_FullInterleaved_Flatwise_TIMSIDE ForceSourceToSolve PreservePartnerSoln PathRelativeTo=TargetProject Intrinsics(28.5kHz) LossMultiplier=1
  EMLoss2: EM Loss Objects=[Body1, Body1_1..Body1_5] LinkID=251 Project="This Project*" Product="Maxwell 3D" Design=12turns_3D_CoreLoss_FullInterleaved_FLATWISE_TIMSIDE ForceSourceToSolve PreservePartnerSoln PathRelativeTo=TargetProject Intrinsics(28.5kHz) LossMultiplier=1
mesh:
  Global:  MeshMethod=MesherHD ComputeGap MeshRegionResolution=5 MinGapX=1mm MinGapY=1mm MinGapZ=1mm Objects=Region FacetLevel=5 ProximitySizeFunction CurvatureSizeFunction OptimizePCBMesh
  MeshRegion2:  MeshMethod=MesherHD MeshRegionResolution=5 MinGapX=1mm MinGapY=1mm MinGapZ=0.72mm Objects=MeshRegion2_SubRegion ProximitySizeFunction CurvatureSizeFunction OptimizePCBMesh
setups:
  Setup1: IcepakSteadyState Flow_Regime=Laminar Include_Temperature=true Include_Flow=true Include_Gravity Solution_Initialization_-_Z_Velocity=0.000980665m_per_sec Convergence_Criteria_-_Flow=0.001 Convergence_Criteria_-_Energy=1e-07 Convergence_Criteria_-_Discrete_Ordinates=1e-06 GPU_Convergence_Criteria_-_Flow=0.001 GPU_Convergence_Criteria_-_Energy=1e-05 GPU_Convergence_Criteria_-_Discrete_Ordinates=1e-05 Radiation_Model="Discrete Ordinates Model" Flow_Iteration_Per_Radiation_Iteration=10 Time_Step_Interval=1 ThetaDivision=2 PhiDivision=2 ThetaPixels=2 PhiPixels=2 Under-relaxation_-_Pressure=0.7 Under-relaxation_-_Momentum=0.3 Under-relaxation_-_Temperature=1 Under-relaxation_-_Body_Force=1 Discretization_Scheme_-_Pressure=Standard Discretization_Scheme_-_Momentum=First Discretization_Scheme_-_Temperature=First Discretization_Scheme_-_Discrete_Ordinates=First Convergence_Criteria_-_Max_Iterations=120
field plots:
  Temperature1: Temperature over Np1, Np10, Np11, Np12, Np2..Np9, Ns1, Ns10, Ns11, Ns12, Ns2..Ns9, SIDE1, SIDE1_1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 on Setup1 : SteadyState
  Temperature2: Temperature over a plane on Setup1 : SteadyState

design 12turns_3D_Thermal_Edgewise_TIM (Icepak, SteadyState TemperatureAndFlow, model units mm)
options: Default_Fluid_Material=air Default_Solid_Material=Al-Extruded Default_Surface_Material=Steel-oxidised-surface AmbientTemperature=20cel AmbientPressure=0n_per_meter_sq AmbientRadiationTemperature=20cel Gravity_Vector_CS_ID=Global Gravity_Vector_Axis=Z Positive=false Altitude=0meter OperatingPressure=101325n_per_meter_sq OperatingDensity=1.225kg_per_m3
geometry:
  Region [air] = region(percentage_offset=1000 on all sides)
  Np1 [copper] = imported_body(C:\Users\karlr\Documents\core_edgewise_TIMSIDE.step)
  Np1_Section1 [copper] = Np1.section(plane=ZX)
  Np10 [copper] = imported_body(C:\Users\karlr\Documents\core_edgewise_TIMSIDE.step)
  Np10_Section1 [copper] = Np10.section(plane=ZX)
  Np11 [copper] = imported_body(C:\Users\karlr\Documents\core_edgewise_TIMSIDE.step)
  Np11_Section1 [copper] = Np11.section(plane=ZX)
  Np12 [copper] = imported_body(C:\Users\karlr\Documents\core_edgewise_TIMSIDE.step)
  Np12_Section1 [copper] = Np12.section(plane=ZX)
  Np2 [copper] = imported_body(C:\Users\karlr\Documents\core_edgewise_TIMSIDE.step)
  Np2_Section1 [copper] = Np2.section(plane=ZX)
  Np3 [copper] = imported_body(C:\Users\karlr\Documents\core_edgewise_TIMSIDE.step)
  Np3_Section1 [copper] = Np3.section(plane=ZX)
  Np4 [copper] = imported_body(C:\Users\karlr\Documents\core_edgewise_TIMSIDE.step)
  Np4_Section1 [copper] = Np4.section(plane=ZX)
  Np5 [copper] = imported_body(C:\Users\karlr\Documents\core_edgewise_TIMSIDE.step)
  Np5_Section1 [copper] = Np5.section(plane=ZX)
  Np6 [copper] = imported_body(C:\Users\karlr\Documents\core_edgewise_TIMSIDE.step)
  Np6_Section1 [copper] = Np6.section(plane=ZX)
  Np7 [copper] = imported_body(C:\Users\karlr\Documents\core_edgewise_TIMSIDE.step)
  Np7_Section1 [copper] = Np7.section(plane=ZX)
  Np8 [copper] = imported_body(C:\Users\karlr\Documents\core_edgewise_TIMSIDE.step)
  Np8_Section1 [copper] = Np8.section(plane=ZX)
  Np9 [copper] = imported_body(C:\Users\karlr\Documents\core_edgewise_TIMSIDE.step)
  Np9_Section1 [copper] = Np9.section(plane=ZX)
  Ns1 [copper] = imported_body(C:\Users\karlr\Documents\core_edgewise_TIMSIDE.step)
  Ns1_Section1 [copper] = Ns1.section(plane=ZX)
  Ns10 [copper] = imported_body(C:\Users\karlr\Documents\core_edgewise_TIMSIDE.step)
  Ns10_Section1 [copper] = Ns10.section(plane=ZX)
  Ns11 [copper] = imported_body(C:\Users\karlr\Documents\core_edgewise_TIMSIDE.step)
  Ns11_Section1 [copper] = Ns11.section(plane=ZX)
  Ns12 [copper] = imported_body(C:\Users\karlr\Documents\core_edgewise_TIMSIDE.step)
  Ns12_Section1 [copper] = Ns12.section(plane=ZX)
  Ns2 [copper] = imported_body(C:\Users\karlr\Documents\core_edgewise_TIMSIDE.step)
  Ns2_Section1 [copper] = Ns2.section(plane=ZX)
  Ns3 [copper] = imported_body(C:\Users\karlr\Documents\core_edgewise_TIMSIDE.step)
  Ns3_Section1 [copper] = Ns3.section(plane=ZX)
  Ns4 [copper] = imported_body(C:\Users\karlr\Documents\core_edgewise_TIMSIDE.step)
  Ns4_Section1 [copper] = Ns4.section(plane=ZX)
  Ns5 [copper] = imported_body(C:\Users\karlr\Documents\core_edgewise_TIMSIDE.step)
  Ns5_Section1 [copper] = Ns5.section(plane=ZX)
  Ns6 [copper] = imported_body(C:\Users\karlr\Documents\core_edgewise_TIMSIDE.step)
  Ns6_Section1 [copper] = Ns6.section(plane=ZX)
  Ns7 [copper] = imported_body(C:\Users\karlr\Documents\core_edgewise_TIMSIDE.step)
  Ns7_Section1 [copper] = Ns7.section(plane=ZX)
  Ns8 [copper] = imported_body(C:\Users\karlr\Documents\core_edgewise_TIMSIDE.step)
  Ns8_Section1 [copper] = Ns8.section(plane=ZX)
  Ns9 [copper] = imported_body(C:\Users\karlr\Documents\core_edgewise_TIMSIDE.step)
  Ns9_Section1 [copper] = Ns9.section(plane=ZX)
  SIDE1, SIDE1_1, SIDE1_2 [Al_N] = imported_body(C:\Users\karlr\Documents\core_edgewise_TIMSIDE.step)
  SIDE1_3, SIDE1_4, SIDE1_5 = imported_body(C:\Users\karlr\Documents\core_edgewise_TIMSIDE.step)
  SIDE1_2.unite(SIDE1_3, SIDE1_4, SIDE1_5)
  Body1 [ferrite - Copy] = imported_body(C:\Users\karlr\Documents\core_edgewise_TIMSIDE.step)
  Body1_1, Body1_2 [aluminum] = imported_body(C:\Users\karlr\Documents\core_edgewise_TIMSIDE.step)
  Body1_3 [ferrite - Copy] = imported_body(C:\Users\karlr\Documents\core_edgewise_TIMSIDE.step)
  Body1_4, Body1_5 [aluminum] = imported_body(C:\Users\karlr\Documents\core_edgewise_TIMSIDE.step)
  Np1_Section1.separate_bodies()
  Np2_Section1.separate_bodies()
  Np3_Section1.separate_bodies()
  Np4_Section1.separate_bodies()
  Np5_Section1.separate_bodies()
  Np6_Section1.separate_bodies()
  Np7_Section1.separate_bodies()
  Np8_Section1.separate_bodies()
  Np9_Section1.separate_bodies()
  Np10_Section1.separate_bodies()
  Np11_Section1.separate_bodies()
  Np12_Section1.separate_bodies()
  Ns1_Section1.separate_bodies()
  Ns2_Section1.separate_bodies()
  Ns3_Section1.separate_bodies()
  Ns4_Section1.separate_bodies()
  Ns5_Section1.separate_bodies()
  Ns6_Section1.separate_bodies()
  Ns7_Section1.separate_bodies()
  Ns8_Section1.separate_bodies()
  Ns9_Section1.separate_bodies()
  Ns10_Section1.separate_bodies()
  Ns11_Section1.separate_bodies()
  Ns12_Section1.separate_bodies()
  MeshRegion1_SubRegion [air, non-model] = sub_region(of=Np2, SIDE1_2, Ns11, SIDE1, Np9, SIDE1_1, Np3, Ns12, Np1, Np4, Np12, Np5, Ns10, Np6, Np7, Np8, Ns7, Np10, Np11, Ns4, Ns1, Ns2, Ns3, Ns5, Ns6, Ns8, Ns9, percentage_offset=0 on all sides)
  Rectangle1 [Al-Extruded, non-model] = rectangle(corner=(40.8mm, 22.75mm, 0mm), z_size=22.7mm, x_size=-40.8mm)
  group core_assembled_edgewise1 = Np1, Np10, Np11, Np12, Np2..Np9, Ns1, Ns10, Ns11, Ns12, Ns2..Ns9, SIDE1, SIDE1_1, SIDE1_2, Np1_Section1, Np2_Section1, Np3_Section1, Np4_Section1, Np5_Section1, Np6_Section1, Np7_Section1, Np8_Section1, Np9_Section1, Np10_Section1, Np11_Section1, Np12_Section1, Ns1_Section1, Ns2_Section1, Ns3_Section1, Ns4_Section1, Ns5_Section1, Ns6_Section1, Ns7_Section1, Ns8_Section1, Ns9_Section1, Ns10_Section1, Ns11_Section1, Ns12_Section1
  group core_together_2 = Body1, Body1_1, Body1_2
  group core_together1 = Body1_3, Body1_4, Body1_5
boundaries and excitations:
  Opening1: Opening Faces=Region.face(-y) Temperature=AmbientTemp External_Rad._Temperature=AmbientRadTemp Inlet_Type=Pressure Total_Pressure=AmbientPressure
  Opening2: Opening Faces=Region.face(+y) Temperature=AmbientTemp External_Rad._Temperature=AmbientRadTemp Inlet_Type=Velocity Static_Pressure=AmbientPressure X_Velocity=0m_per_sec Y_Velocity=0m_per_sec Z_Velocity=0m_per_sec
  EMLoss1: EM Loss Objects=[Body1_1, Body1_2, Body1, Body1_4, Body1_5, Body1_3] LinkID=286 Project="This Project*" Product="Maxwell 3D" Design=12turns_3D_Thermal_FullInterleaved_Edgewise_TIM_CoreLoss ForceSourceToSolve PreservePartnerSoln PathRelativeTo=TargetProject Intrinsics(28.5kHz) LossMultiplier=1
  EMLoss2: EM Loss Objects=[Np1..Np12, Ns1..Ns12] LinkID=289 Project="This Project*" Product="Maxwell 3D" Design=12turns_3D_Thermal_FullInterleaved_Edgewise_TIM_WindingLoss ForceSourceToSolve PreservePartnerSoln PathRelativeTo=TargetProject Intrinsics(28.5kHz) LossMultiplier=1
mesh:
  Global:  MeshMethod=MesherHD ComputeGap MeshRegionResolution=5 MinGapX=1mm MinGapY=1mm MinGapZ=1mm Objects=Region FacetLevel=5 ProximitySizeFunction CurvatureSizeFunction OptimizePCBMesh
  MeshRegion1:  MeshMethod=MesherHD MeshRegionResolution=5 MinGapX=1mm MinGapY=1mm MinGapZ=0.97mm Objects=MeshRegion1_SubRegion ProximitySizeFunction CurvatureSizeFunction OptimizePCBMesh
setups:
  Setup1: IcepakSteadyState Flow_Regime=Laminar Include_Temperature=true Include_Flow=true Include_Gravity Solution_Initialization_-_Z_Velocity=0.000980665m_per_sec Convergence_Criteria_-_Flow=0.001 Convergence_Criteria_-_Energy=1e-07 Convergence_Criteria_-_Discrete_Ordinates=1e-06 GPU_Convergence_Criteria_-_Flow=0.001 GPU_Convergence_Criteria_-_Energy=1e-05 GPU_Convergence_Criteria_-_Discrete_Ordinates=1e-05 Radiation_Model="Discrete Ordinates Model" Flow_Iteration_Per_Radiation_Iteration=10 Time_Step_Interval=1 ThetaDivision=2 PhiDivision=2 ThetaPixels=2 PhiPixels=2 Under-relaxation_-_Pressure=0.7 Under-relaxation_-_Momentum=0.3 Under-relaxation_-_Temperature=1 Under-relaxation_-_Body_Force=1 Discretization_Scheme_-_Pressure=Standard Discretization_Scheme_-_Momentum=First Discretization_Scheme_-_Temperature=First Discretization_Scheme_-_Discrete_Ordinates=First Convergence_Criteria_-_Max_Iterations=120
field plots:
  Temperature1: Temperature over Np1, Np10, Np11, Np12, Np2..Np9, Ns1, Ns10, Ns11, Ns12, Ns2..Ns9, SIDE1, SIDE1_1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 on Setup1 : SteadyState
  Temperature2: Temperature over a plane on Setup1 : SteadyState

design edgewise_thermal2 (Icepak, SteadyState TemperatureAndFlow, model units mm)
options: Default_Fluid_Material=air Default_Solid_Material=Al-Extruded Default_Surface_Material=Steel-oxidised-surface AmbientTemperature=20cel AmbientPressure=0n_per_meter_sq AmbientRadiationTemperature=20cel Gravity_Vector_CS_ID=Global Gravity_Vector_Axis=Z Positive=false Altitude=0meter OperatingPressure=101325n_per_meter_sq OperatingDensity=1.225kg_per_m3
geometry:
  Np1 [copper] = imported_body(C:\Users\karlr\Documents\core_assembled_edgewise v3again.step)
  Np1_Section1 [copper] = Np1.section(plane=ZX)
  Np10 [copper] = imported_body(C:\Users\karlr\Documents\core_assembled_edgewise v3again.step)
  Np10_Section1 [copper] = Np10.section(plane=ZX)
  Np11 [copper] = imported_body(C:\Users\karlr\Documents\core_assembled_edgewise v3again.step)
  Np11_Section1 [copper] = Np11.section(plane=ZX)
  Np12 [copper] = imported_body(C:\Users\karlr\Documents\core_assembled_edgewise v3again.step)
  Np12_Section1 [copper] = Np12.section(plane=ZX)
  Np2 [copper] = imported_body(C:\Users\karlr\Documents\core_assembled_edgewise v3again.step)
  Np2_Section1 [copper] = Np2.section(plane=ZX)
  Np3 [copper] = imported_body(C:\Users\karlr\Documents\core_assembled_edgewise v3again.step)
  Np3_Section1 [copper] = Np3.section(plane=ZX)
  Np4 [copper] = imported_body(C:\Users\karlr\Documents\core_assembled_edgewise v3again.step)
  Np4_Section1 [copper] = Np4.section(plane=ZX)
  Np5 [copper] = imported_body(C:\Users\karlr\Documents\core_assembled_edgewise v3again.step)
  Np5_Section1 [copper] = Np5.section(plane=ZX)
  Np6 [copper] = imported_body(C:\Users\karlr\Documents\core_assembled_edgewise v3again.step)
  Np6_Section1 [copper] = Np6.section(plane=ZX)
  Np7 [copper] = imported_body(C:\Users\karlr\Documents\core_assembled_edgewise v3again.step)
  Np7_Section1 [copper] = Np7.section(plane=ZX)
  Np8 [copper] = imported_body(C:\Users\karlr\Documents\core_assembled_edgewise v3again.step)
  Np8_Section1 [copper] = Np8.section(plane=ZX)
  Np9 [copper] = imported_body(C:\Users\karlr\Documents\core_assembled_edgewise v3again.step)
  Np9_Section1 [copper] = Np9.section(plane=ZX)
  Ns1 [copper] = imported_body(C:\Users\karlr\Documents\core_assembled_edgewise v3again.step)
  Ns1_Section1 [copper] = Ns1.section(plane=ZX)
  Ns10 [copper] = imported_body(C:\Users\karlr\Documents\core_assembled_edgewise v3again.step)
  Ns10_Section1 [copper] = Ns10.section(plane=ZX)
  Ns11 [copper] = imported_body(C:\Users\karlr\Documents\core_assembled_edgewise v3again.step)
  Ns11_Section1 [copper] = Ns11.section(plane=ZX)
  Ns12 [copper] = imported_body(C:\Users\karlr\Documents\core_assembled_edgewise v3again.step)
  Ns12_Section1 [copper] = Ns12.section(plane=ZX)
  Ns2 [copper] = imported_body(C:\Users\karlr\Documents\core_assembled_edgewise v3again.step)
  Ns2_Section1 [copper] = Ns2.section(plane=ZX)
  Ns3 [copper] = imported_body(C:\Users\karlr\Documents\core_assembled_edgewise v3again.step)
  Ns3_Section1 [copper] = Ns3.section(plane=ZX)
  Ns4 [copper] = imported_body(C:\Users\karlr\Documents\core_assembled_edgewise v3again.step)
  Ns4_Section1 [copper] = Ns4.section(plane=ZX)
  Ns5 [copper] = imported_body(C:\Users\karlr\Documents\core_assembled_edgewise v3again.step)
  Ns5_Section1 [copper] = Ns5.section(plane=ZX)
  Ns6 [copper] = imported_body(C:\Users\karlr\Documents\core_assembled_edgewise v3again.step)
  Ns6_Section1 [copper] = Ns6.section(plane=ZX)
  Ns7 [copper] = imported_body(C:\Users\karlr\Documents\core_assembled_edgewise v3again.step)
  Ns7_Section1 [copper] = Ns7.section(plane=ZX)
  Ns8 [copper] = imported_body(C:\Users\karlr\Documents\core_assembled_edgewise v3again.step)
  Ns8_Section1 [copper] = Ns8.section(plane=ZX)
  Ns9 [copper] = imported_body(C:\Users\karlr\Documents\core_assembled_edgewise v3again.step)
  Ns9_Section1 [copper] = Ns9.section(plane=ZX)
  plate1, plate2 [Al_N] = imported_body(C:\Users\karlr\Documents\core_assembled_edgewise v3again.step)
  Body1 [ferrite - Copy] = imported_body(C:\Users\karlr\Documents\core_assembled_edgewise v3again.step)
  Body1_1, Body1_2 [aluminum] = imported_body(C:\Users\karlr\Documents\core_assembled_edgewise v3again.step)
  Body1_3 [ferrite - Copy] = imported_body(C:\Users\karlr\Documents\core_assembled_edgewise v3again.step)
  Body1_4, Body1_5 [aluminum] = imported_body(C:\Users\karlr\Documents\core_assembled_edgewise v3again.step)
  Np1_Section1.separate_bodies()
  Np2_Section1.separate_bodies()
  Np3_Section1.separate_bodies()
  Np4_Section1.separate_bodies()
  Np5_Section1.separate_bodies()
  Np6_Section1.separate_bodies()
  Np7_Section1.separate_bodies()
  Np8_Section1.separate_bodies()
  Np9_Section1.separate_bodies()
  Np10_Section1.separate_bodies()
  Np11_Section1.separate_bodies()
  Np12_Section1.separate_bodies()
  Ns1_Section1.separate_bodies()
  Ns2_Section1.separate_bodies()
  Ns3_Section1.separate_bodies()
  Ns4_Section1.separate_bodies()
  Ns5_Section1.separate_bodies()
  Ns6_Section1.separate_bodies()
  Ns7_Section1.separate_bodies()
  Ns8_Section1.separate_bodies()
  Ns9_Section1.separate_bodies()
  Ns10_Section1.separate_bodies()
  Ns11_Section1.separate_bodies()
  Ns12_Section1.separate_bodies()
  Region [air] = region(percentage_offset=1000 on all sides)
  MeshRegion1_SubRegion [air, non-model] = sub_region(of=plate1, percentage_offset=0 on all sides)
  MeshRegion2_SubRegion [air, non-model] = sub_region(of=plate2, percentage_offset=0 on all sides)
  Rectangle1 [Al-Extruded, non-model] = rectangle(corner=(0mm, 22.75mm, 0mm), z_size=22.7mm, x_size=40.8mm)
  group core_assembled_edgewise = Np1, Np10, Np11, Np12, Np2..Np9, Ns1, Ns10, Ns11, Ns12, Ns2..Ns9, plate1, plate2, Np1_Section1, Np2_Section1, Np3_Section1, Np4_Section1, Np5_Section1, Np6_Section1, Np7_Section1, Np8_Section1, Np9_Section1, Np10_Section1, Np11_Section1, Np12_Section1, Ns1_Section1, Ns2_Section1, Ns3_Section1, Ns4_Section1, Ns5_Section1, Ns6_Section1, Ns7_Section1, Ns8_Section1, Ns9_Section1, Ns10_Section1, Ns11_Section1, Ns12_Section1
  group core_together_1 = Body1, Body1_1, Body1_2
  group core_together = Body1_3, Body1_4, Body1_5
boundaries and excitations:
  EMLoss1: EM Loss Objects=[Np1..Np12, Ns1..Ns12] LinkID=8 Project="This Project*" Product="Maxwell 3D" Design=12turns_3D_Thermal_FullInterleaved_Edgewise_winding ForceSourceToSolve PreservePartnerSoln PathRelativeTo=TargetProject Intrinsics(28.5kHz) LossMultiplier=1
  EMLoss2: EM Loss Objects=[Body1_4, Body1_5, Body1_3, Body1_1, Body1_2, Body1] LinkID=11 Project="This Project*" Product="Maxwell 3D" Design=12turns_3D_Thermal_FullInterleaved_Edgewise ForceSourceToSolve PreservePartnerSoln PathRelativeTo=TargetProject Intrinsics(28.5kHz) LossMultiplier=1
  Opening1: Opening Faces=Region.face(-y) Temperature=AmbientTemp External_Rad._Temperature=AmbientRadTemp Inlet_Type=Pressure Total_Pressure=AmbientPressure
  Opening2: Opening Faces=Region.face(+y) Temperature=AmbientTemp External_Rad._Temperature=AmbientRadTemp Inlet_Type=Velocity Static_Pressure=AmbientPressure X_Velocity=0m_per_sec Y_Velocity=0m_per_sec Z_Velocity=0m_per_sec
mesh:
  Global:  MeshMethod=MesherHD ComputeGap MeshRegionResolution=5 MinGapX=1mm MinGapY=1mm MinGapZ=1mm Objects=Region FacetLevel=5 ProximitySizeFunction CurvatureSizeFunction OptimizePCBMesh
  MeshRegion1:  MeshMethod=MesherHD MeshRegionResolution=5 MinGapX=1mm MinGapY=1mm MinGapZ=0.0099999983mm Objects=MeshRegion1_SubRegion ProximitySizeFunction CurvatureSizeFunction OptimizePCBMesh
  MeshRegion2:  MeshMethod=MesherHD MeshRegionResolution=5 MinGapX=1mm MinGapY=1mm MinGapZ=0.0099999983mm Objects=MeshRegion2_SubRegion ProximitySizeFunction CurvatureSizeFunction OptimizePCBMesh
setups:
  Setup1: IcepakSteadyState Flow_Regime=Laminar Include_Temperature=true Include_Flow=true Include_Gravity Solution_Initialization_-_Z_Velocity=0.000980665m_per_sec Convergence_Criteria_-_Flow=0.001 Convergence_Criteria_-_Energy=1e-07 Convergence_Criteria_-_Discrete_Ordinates=1e-06 GPU_Convergence_Criteria_-_Flow=0.001 GPU_Convergence_Criteria_-_Energy=1e-05 GPU_Convergence_Criteria_-_Discrete_Ordinates=1e-05 Radiation_Model="Discrete Ordinates Model" Flow_Iteration_Per_Radiation_Iteration=10 Time_Step_Interval=1 ThetaDivision=2 PhiDivision=2 ThetaPixels=2 PhiPixels=2 Under-relaxation_-_Pressure=0.7 Under-relaxation_-_Momentum=0.3 Under-relaxation_-_Temperature=1 Under-relaxation_-_Body_Force=1 Discretization_Scheme_-_Pressure=Standard Discretization_Scheme_-_Momentum=First Discretization_Scheme_-_Temperature=First Discretization_Scheme_-_Discrete_Ordinates=First Convergence_Criteria_-_Max_Iterations=120
field plots:
  Temperature2: Temperature over a plane on Setup1 : SteadyState
  Temperature1: Temperature over Np1.face(all 10) Np10.face(all 10) Np11.face(all 10) Np12.face(all 10) Np2.face(all 10) Np3.face(all 10) Np4.face(all 10) Np5.face(all 10) Np6.face(all 10) Np7.face(all 10) Np8.face(all 10) Np9.face(all 10) Ns1.face(all 10) Ns10.face(all 10) Ns11.face(all 10) Ns12.face(all 10) Ns2.face(all 10) Ns3.face(all 10) Ns4.face(all 10) Ns5.face(all 10) Ns6.face(all 10) Ns7.face(all 10) Ns8.face(all 10) Ns9.face(all 10) plate1.face(all 10) plate2.face(all 10) Body1.face(all 14) Body1_1.face(all 10) Body1_2.face(all 10) Body1_3.face(all 14) Body1_4.face(all 10) Body1_5.face(all 10) on Setup1 : SteadyState

design edgewise_thermal3 (Icepak, SteadyState TemperatureAndFlow, model units mm)
options: Default_Fluid_Material=air Default_Solid_Material=Al-Extruded Default_Surface_Material=Steel-oxidised-surface AmbientTemperature=20cel AmbientPressure=0n_per_meter_sq AmbientRadiationTemperature=20cel Gravity_Vector_CS_ID=Global Gravity_Vector_Axis=Z Positive=false Altitude=0meter OperatingPressure=101325n_per_meter_sq OperatingDensity=1.225kg_per_m3
geometry:
  Np1 [copper] = imported_body(C:\Users\karlr\Documents\core_assembled_edgewise v3again.step)
  Np1_Section1 [copper] = Np1.section(plane=ZX)
  Np10 [copper] = imported_body(C:\Users\karlr\Documents\core_assembled_edgewise v3again.step)
  Np10_Section1 [copper] = Np10.section(plane=ZX)
  Np11 [copper] = imported_body(C:\Users\karlr\Documents\core_assembled_edgewise v3again.step)
  Np11_Section1 [copper] = Np11.section(plane=ZX)
  Np12 [copper] = imported_body(C:\Users\karlr\Documents\core_assembled_edgewise v3again.step)
  Np12_Section1 [copper] = Np12.section(plane=ZX)
  Np2 [copper] = imported_body(C:\Users\karlr\Documents\core_assembled_edgewise v3again.step)
  Np2_Section1 [copper] = Np2.section(plane=ZX)
  Np3 [copper] = imported_body(C:\Users\karlr\Documents\core_assembled_edgewise v3again.step)
  Np3_Section1 [copper] = Np3.section(plane=ZX)
  Np4 [copper] = imported_body(C:\Users\karlr\Documents\core_assembled_edgewise v3again.step)
  Np4_Section1 [copper] = Np4.section(plane=ZX)
  Np5 [copper] = imported_body(C:\Users\karlr\Documents\core_assembled_edgewise v3again.step)
  Np5_Section1 [copper] = Np5.section(plane=ZX)
  Np6 [copper] = imported_body(C:\Users\karlr\Documents\core_assembled_edgewise v3again.step)
  Np6_Section1 [copper] = Np6.section(plane=ZX)
  Np7 [copper] = imported_body(C:\Users\karlr\Documents\core_assembled_edgewise v3again.step)
  Np7_Section1 [copper] = Np7.section(plane=ZX)
  Np8 [copper] = imported_body(C:\Users\karlr\Documents\core_assembled_edgewise v3again.step)
  Np8_Section1 [copper] = Np8.section(plane=ZX)
  Np9 [copper] = imported_body(C:\Users\karlr\Documents\core_assembled_edgewise v3again.step)
  Np9_Section1 [copper] = Np9.section(plane=ZX)
  Ns1 [copper] = imported_body(C:\Users\karlr\Documents\core_assembled_edgewise v3again.step)
  Ns1_Section1 [copper] = Ns1.section(plane=ZX)
  Ns10 [copper] = imported_body(C:\Users\karlr\Documents\core_assembled_edgewise v3again.step)
  Ns10_Section1 [copper] = Ns10.section(plane=ZX)
  Ns11 [copper] = imported_body(C:\Users\karlr\Documents\core_assembled_edgewise v3again.step)
  Ns11_Section1 [copper] = Ns11.section(plane=ZX)
  Ns12 [copper] = imported_body(C:\Users\karlr\Documents\core_assembled_edgewise v3again.step)
  Ns12_Section1 [copper] = Ns12.section(plane=ZX)
  Ns2 [copper] = imported_body(C:\Users\karlr\Documents\core_assembled_edgewise v3again.step)
  Ns2_Section1 [copper] = Ns2.section(plane=ZX)
  Ns3 [copper] = imported_body(C:\Users\karlr\Documents\core_assembled_edgewise v3again.step)
  Ns3_Section1 [copper] = Ns3.section(plane=ZX)
  Ns4 [copper] = imported_body(C:\Users\karlr\Documents\core_assembled_edgewise v3again.step)
  Ns4_Section1 [copper] = Ns4.section(plane=ZX)
  Ns5 [copper] = imported_body(C:\Users\karlr\Documents\core_assembled_edgewise v3again.step)
  Ns5_Section1 [copper] = Ns5.section(plane=ZX)
  Ns6 [copper] = imported_body(C:\Users\karlr\Documents\core_assembled_edgewise v3again.step)
  Ns6_Section1 [copper] = Ns6.section(plane=ZX)
  Ns7 [copper] = imported_body(C:\Users\karlr\Documents\core_assembled_edgewise v3again.step)
  Ns7_Section1 [copper] = Ns7.section(plane=ZX)
  Ns8 [copper] = imported_body(C:\Users\karlr\Documents\core_assembled_edgewise v3again.step)
  Ns8_Section1 [copper] = Ns8.section(plane=ZX)
  Ns9 [copper] = imported_body(C:\Users\karlr\Documents\core_assembled_edgewise v3again.step)
  Ns9_Section1 [copper] = Ns9.section(plane=ZX)
  plate1, plate2 [Al_N] = imported_body(C:\Users\karlr\Documents\core_assembled_edgewise v3again.step)
  Body1 [ferrite - Copy] = imported_body(C:\Users\karlr\Documents\core_assembled_edgewise v3again.step)
  Body1_1, Body1_2 [aluminum] = imported_body(C:\Users\karlr\Documents\core_assembled_edgewise v3again.step)
  Body1_3 [ferrite - Copy] = imported_body(C:\Users\karlr\Documents\core_assembled_edgewise v3again.step)
  Body1_4, Body1_5 [aluminum] = imported_body(C:\Users\karlr\Documents\core_assembled_edgewise v3again.step)
  Np1_Section1.separate_bodies()
  Np2_Section1.separate_bodies()
  Np3_Section1.separate_bodies()
  Np4_Section1.separate_bodies()
  Np5_Section1.separate_bodies()
  Np6_Section1.separate_bodies()
  Np7_Section1.separate_bodies()
  Np8_Section1.separate_bodies()
  Np9_Section1.separate_bodies()
  Np10_Section1.separate_bodies()
  Np11_Section1.separate_bodies()
  Np12_Section1.separate_bodies()
  Ns1_Section1.separate_bodies()
  Ns2_Section1.separate_bodies()
  Ns3_Section1.separate_bodies()
  Ns4_Section1.separate_bodies()
  Ns5_Section1.separate_bodies()
  Ns6_Section1.separate_bodies()
  Ns7_Section1.separate_bodies()
  Ns8_Section1.separate_bodies()
  Ns9_Section1.separate_bodies()
  Ns10_Section1.separate_bodies()
  Ns11_Section1.separate_bodies()
  Ns12_Section1.separate_bodies()
  Region [air] = region(percentage_offset=1000 on all sides)
  MeshRegion1_SubRegion [air, non-model] = sub_region(of=plate1, percentage_offset=0 on all sides)
  MeshRegion2_SubRegion [air, non-model] = sub_region(of=plate2, percentage_offset=0 on all sides)
  Rectangle1 [Al-Extruded, non-model] = rectangle(corner=(0mm, 22.75mm, 0mm), z_size=22.7mm, x_size=40.8mm)
  group core_assembled_edgewise = Np1, Np10, Np11, Np12, Np2..Np9, Ns1, Ns10, Ns11, Ns12, Ns2..Ns9, plate1, plate2, Np1_Section1, Np2_Section1, Np3_Section1, Np4_Section1, Np5_Section1, Np6_Section1, Np7_Section1, Np8_Section1, Np9_Section1, Np10_Section1, Np11_Section1, Np12_Section1, Ns1_Section1, Ns2_Section1, Ns3_Section1, Ns4_Section1, Ns5_Section1, Ns6_Section1, Ns7_Section1, Ns8_Section1, Ns9_Section1, Ns10_Section1, Ns11_Section1, Ns12_Section1
  group core_together_1 = Body1, Body1_1, Body1_2
  group core_together = Body1_3, Body1_4, Body1_5
boundaries and excitations:
  EMLoss1: EM Loss Objects=[Np1..Np12, Ns1..Ns12] LinkID=8 Project="This Project*" Product="Maxwell 3D" Design=12turns_3D_Thermal_FullInterleaved_Edgewise_winding ForceSourceToSolve PreservePartnerSoln PathRelativeTo=TargetProject Intrinsics(28.5kHz) LossMultiplier=1
  EMLoss2: EM Loss Objects=[Body1_4, Body1_5, Body1_3, Body1_1, Body1_2, Body1] LinkID=11 Project="This Project*" Product="Maxwell 3D" Design=12turns_3D_Thermal_FullInterleaved_Edgewise ForceSourceToSolve PreservePartnerSoln PathRelativeTo=TargetProject Intrinsics(28.5kHz) LossMultiplier=1
  Opening1: Opening Faces=Region.face(-y) Temperature=AmbientTemp External_Rad._Temperature=AmbientRadTemp Inlet_Type=Pressure Total_Pressure=AmbientPressure
  Opening2: Opening Faces=Region.face(+y) Temperature=AmbientTemp External_Rad._Temperature=AmbientRadTemp Inlet_Type=Velocity Static_Pressure=AmbientPressure X_Velocity=0m_per_sec Y_Velocity=0m_per_sec Z_Velocity=0m_per_sec
mesh:
  Global:  MeshMethod=MesherHD ComputeGap MeshRegionResolution=5 MinGapX=1mm MinGapY=1mm MinGapZ=1mm Objects=Region FacetLevel=5 ProximitySizeFunction CurvatureSizeFunction OptimizePCBMesh
  MeshRegion1:  MeshMethod=MesherHD MeshRegionResolution=5 MinGapX=1mm MinGapY=1mm MinGapZ=0.0099999983mm Objects=MeshRegion1_SubRegion ProximitySizeFunction CurvatureSizeFunction OptimizePCBMesh
  MeshRegion2:  MeshMethod=MesherHD MeshRegionResolution=5 MinGapX=1mm MinGapY=1mm MinGapZ=0.0099999983mm Objects=MeshRegion2_SubRegion ProximitySizeFunction CurvatureSizeFunction OptimizePCBMesh
setups:
  Setup1: IcepakSteadyState Flow_Regime=Laminar Include_Temperature=true Include_Flow=true Include_Gravity Solution_Initialization_-_Z_Velocity=0.000980665m_per_sec Convergence_Criteria_-_Flow=0.001 Convergence_Criteria_-_Energy=1e-07 Convergence_Criteria_-_Discrete_Ordinates=1e-06 GPU_Convergence_Criteria_-_Flow=0.001 GPU_Convergence_Criteria_-_Energy=1e-05 GPU_Convergence_Criteria_-_Discrete_Ordinates=1e-05 Radiation_Model="Discrete Ordinates Model" Flow_Iteration_Per_Radiation_Iteration=10 Time_Step_Interval=1 ThetaDivision=2 PhiDivision=2 ThetaPixels=2 PhiPixels=2 Under-relaxation_-_Pressure=0.7 Under-relaxation_-_Momentum=0.3 Under-relaxation_-_Temperature=1 Under-relaxation_-_Body_Force=1 Discretization_Scheme_-_Pressure=Standard Discretization_Scheme_-_Momentum=First Discretization_Scheme_-_Temperature=First Discretization_Scheme_-_Discrete_Ordinates=First Convergence_Criteria_-_Max_Iterations=120
field plots:
  Temperature2: Temperature over a plane on Setup1 : SteadyState
  Temperature1: Temperature over Np1.face(all 10) Np10.face(all 10) Np11.face(all 10) Np12.face(all 10) Np2.face(all 10) Np3.face(all 10) Np4.face(all 10) Np5.face(all 10) Np6.face(all 10) Np7.face(all 10) Np8.face(all 10) Np9.face(all 10) Ns1.face(all 10) Ns10.face(all 10) Ns11.face(all 10) Ns12.face(all 10) Ns2.face(all 10) Ns3.face(all 10) Ns4.face(all 10) Ns5.face(all 10) Ns6.face(all 10) Ns7.face(all 10) Ns8.face(all 10) Ns9.face(all 10) plate1.face(all 10) plate2.face(all 10) Body1.face(all 14) Body1_1.face(all 10) Body1_2.face(all 10) Body1_3.face(all 14) Body1_4.face(all 10) Body1_5.face(all 10) on Setup1 : SteadyState

design [Corrected]_10turns_3D_CoreLoss_FullInterleaved (Maxwell 3D, EddyCurrent, model units mm)
geometry:
  Np1, Np10, Np2..Np9, Ns1, Ns10, Ns2..Ns9 [copper] = imported_body(C:\Users\karlr\Documents\flatwise_corrected.step)
  plate_1, plate_2 [silicon - Copy] = imported_body(C:\Users\karlr\Documents\flatwise_corrected.step)
  Body1 [ferrite - Copy] = imported_body(C:\Users\karlr\Documents\flatwise_corrected.step)
  Body1_1, Body1_2 [aluminum] = imported_body(C:\Users\karlr\Documents\flatwise_corrected.step)
  Body1_3 [ferrite - Copy] = imported_body(C:\Users\karlr\Documents\flatwise_corrected.step)
  Body1_4, Body1_5 [aluminum] = imported_body(C:\Users\karlr\Documents\flatwise_corrected.step)
  Region [vacuum] = region(percentage_offset=0 on all sides)
  Np1_Section1 [copper] = Np1.section(plane=ZX)
  Np2_Section1 [copper] = Np2.section(plane=ZX)
  Np3_Section1 [copper] = Np3.section(plane=ZX)
  Np4_Section1 [copper] = Np4.section(plane=ZX)
  Np5_Section1 [copper] = Np5.section(plane=ZX)
  Np6_Section1 [copper] = Np6.section(plane=ZX)
  Np7_Section1 [copper] = Np7.section(plane=ZX)
  Np8_Section1 [copper] = Np8.section(plane=ZX)
  Np9_Section1 [copper] = Np9.section(plane=ZX)
  Np10_Section1 [copper] = Np10.section(plane=ZX)
  Ns1_Section1 [copper] = Ns1.section(plane=ZX)
  Ns2_Section1 [copper] = Ns2.section(plane=ZX)
  Ns3_Section1 [copper] = Ns3.section(plane=ZX)
  Ns4_Section1 [copper] = Ns4.section(plane=ZX)
  Ns5_Section1 [copper] = Ns5.section(plane=ZX)
  Ns6_Section1 [copper] = Ns6.section(plane=ZX)
  Ns7_Section1 [copper] = Ns7.section(plane=ZX)
  Ns8_Section1 [copper] = Ns8.section(plane=ZX)
  Ns9_Section1 [copper] = Ns9.section(plane=ZX)
  Ns10_Section1 [copper] = Ns10.section(plane=ZX)
  Np1_Section1.separate_bodies()
  Np2_Section1.separate_bodies()
  Np3_Section1.separate_bodies()
  Np4_Section1.separate_bodies()
  Np5_Section1.separate_bodies()
  Np6_Section1.separate_bodies()
  Np7_Section1.separate_bodies()
  Np8_Section1.separate_bodies()
  Np9_Section1.separate_bodies()
  Np10_Section1.separate_bodies()
  Ns1_Section1.separate_bodies()
  Ns2_Section1.separate_bodies()
  Ns3_Section1.separate_bodies()
  Ns4_Section1.separate_bodies()
  Ns5_Section1.separate_bodies()
  Ns6_Section1.separate_bodies()
  Ns7_Section1.separate_bodies()
  Ns8_Section1.separate_bodies()
  Ns9_Section1.separate_bodies()
  Ns10_Section1.separate_bodies()
  group core_assembled_flatwise = Np1, Np10, Np2..Np9, Ns1, Ns10, Ns2..Ns9, plate_1, plate_2, Np1_Section1, Np2_Section1, Np3_Section1, Np4_Section1, Np5_Section1, Np6_Section1, Np7_Section1, Np8_Section1, Np9_Section1, Np10_Section1, Ns1_Section1, Ns2_Section1, Ns3_Section1, Ns4_Section1, Ns5_Section1, Ns6_Section1, Ns7_Section1, Ns8_Section1, Ns9_Section1, Ns10_Section1
  group core_together_1 = Body1, Body1_1, Body1_2
  group core_together = Body1_3, Body1_4, Body1_5
boundaries and excitations:
  Np_1: Coil Terminal Objects=Np1_Section1 Conductor_number=1 Winding=Np Point_out_of_terminal=false
  Np_2: Coil Terminal Objects=Np2_Section1 Conductor_number=1 Winding=Np Point_out_of_terminal=false
  Np_3: Coil Terminal Objects=Np3_Section1 Conductor_number=1 Winding=Np Point_out_of_terminal=false
  Np_4: Coil Terminal Objects=Np4_Section1 Conductor_number=1 Winding=Np Point_out_of_terminal=false
  Np_5: Coil Terminal Objects=Np5_Section1 Conductor_number=1 Winding=Np Point_out_of_terminal=false
  Np_6: Coil Terminal Objects=Np6_Section1 Conductor_number=1 Winding=Np Point_out_of_terminal=false
  Np_7: Coil Terminal Objects=Np7_Section1 Conductor_number=1 Winding=Np Point_out_of_terminal=false
  Np_8: Coil Terminal Objects=Np8_Section1 Conductor_number=1 Winding=Np Point_out_of_terminal=false
  Np_9: Coil Terminal Objects=Np9_Section1 Conductor_number=1 Winding=Np Point_out_of_terminal=false
  Np_10: Coil Terminal Objects=Np10_Section1 Conductor_number=1 Winding=Np Point_out_of_terminal=false
  Ns_1: Coil Terminal Objects=Ns1_Section1 Conductor_number=1 Winding=Ns Point_out_of_terminal=true
  Ns_2: Coil Terminal Objects=Ns2_Section1 Conductor_number=1 Winding=Ns Point_out_of_terminal=true
  Ns_3: Coil Terminal Objects=Ns3_Section1 Conductor_number=1 Winding=Ns Point_out_of_terminal=true
  Ns_4: Coil Terminal Objects=Ns4_Section1 Conductor_number=1 Winding=Ns Point_out_of_terminal=true
  Ns_5: Coil Terminal Objects=Ns5_Section1 Conductor_number=1 Winding=Ns Point_out_of_terminal=true
  Ns_6: Coil Terminal Objects=Ns6_Section1 Conductor_number=1 Winding=Ns Point_out_of_terminal=true
  Ns_7: Coil Terminal Objects=Ns7_Section1 Conductor_number=1 Winding=Ns Point_out_of_terminal=true
  Ns_8: Coil Terminal Objects=Ns8_Section1 Conductor_number=1 Winding=Ns Point_out_of_terminal=true
  Ns_9: Coil Terminal Objects=Ns9_Section1 Conductor_number=1 Winding=Ns Point_out_of_terminal=true
  Ns_10: Coil Terminal Objects=Ns10_Section1 Conductor_number=1 Winding=Ns Point_out_of_terminal=true
  Np: Winding Group Type=Voltage IsSolid=true Current=0A Resistance=0ohm Inductance=0nH Voltage=141V ParallelBranchesNum=1 Phase=0rad
  Ns: Winding Group Type=Current IsSolid=true Current=0mA ParallelBranchesNum=1 Phase=0deg
  eddy effects on: Np1, Np10, Np2..Np9, Ns1, Ns10, Ns2..Ns9, Body1_1, Body1_2, Body1_4, Body1_5
  core loss on: Body1, Body1_3
parameters:
  Matrix1: Matrix Np, Ns:
mesh:
  Length1: LengthBased Objects=[Np1..Np10, Ns1..Ns10, plate_1, plate_2] MaxLength=1.5mm
  Length2: LengthBased Objects=[Body1_4, Body1_5, Body1_3, Body1_1, Body1_2, Body1] MaxLength=4.5mm
  initial mesh: GlobalSurfApproximation{CurvedSurfaceApproxChoice=UseSlider SliderMeshSettings=9} GlobalCurvilinear{Apply} MeshMethod=AnsoftClassic
setups:
  Setup1: EddyCurrent MaximumPasses=20 MinimumPasses=2 MinimumConvergedPasses=1 PercentRefinement=30 PercentError=1 NonLinearResidual=0.0001 Frequency=28.5kHz LossAdaptiveCtrl=0.5
field plots:
  Mag_B1: B over Body1, Body1_3 on Setup1 : LastAdaptive at Freq=28.5kHz Phase=45deg
  EM_Loss2: EM-Loss over Body1_2 on Setup1 : LastAdaptive at Freq=28.5kHz Phase=0deg
  Temperature1: Temperature over Body1_2 on Setup1 : LastAdaptive at Freq=28.5kHz Phase=0deg

design [Corrected]_10turns_3D_WindingLoss_FullInterleaved (Maxwell 3D, EddyCurrent, model units mm)
geometry:
  Np1, Np10, Np2..Np9, Ns1, Ns10, Ns2..Ns9 [copper] = imported_body(C:\Users\karlr\Documents\flatwise_corrected.step)
  plate_1, plate_2 [silicon - Copy] = imported_body(C:\Users\karlr\Documents\flatwise_corrected.step)
  Body1 [ferrite - Copy] = imported_body(C:\Users\karlr\Documents\flatwise_corrected.step)
  Body1_1, Body1_2 [aluminum] = imported_body(C:\Users\karlr\Documents\flatwise_corrected.step)
  Body1_3 [ferrite - Copy] = imported_body(C:\Users\karlr\Documents\flatwise_corrected.step)
  Body1_4, Body1_5 [aluminum] = imported_body(C:\Users\karlr\Documents\flatwise_corrected.step)
  Region [vacuum] = region(percentage_offset=0 on all sides)
  Np1_Section1 [copper] = Np1.section(plane=ZX)
  Np2_Section1 [copper] = Np2.section(plane=ZX)
  Np3_Section1 [copper] = Np3.section(plane=ZX)
  Np4_Section1 [copper] = Np4.section(plane=ZX)
  Np5_Section1 [copper] = Np5.section(plane=ZX)
  Np6_Section1 [copper] = Np6.section(plane=ZX)
  Np7_Section1 [copper] = Np7.section(plane=ZX)
  Np8_Section1 [copper] = Np8.section(plane=ZX)
  Np9_Section1 [copper] = Np9.section(plane=ZX)
  Np10_Section1 [copper] = Np10.section(plane=ZX)
  Ns1_Section1 [copper] = Ns1.section(plane=ZX)
  Ns2_Section1 [copper] = Ns2.section(plane=ZX)
  Ns3_Section1 [copper] = Ns3.section(plane=ZX)
  Ns4_Section1 [copper] = Ns4.section(plane=ZX)
  Ns5_Section1 [copper] = Ns5.section(plane=ZX)
  Ns6_Section1 [copper] = Ns6.section(plane=ZX)
  Ns7_Section1 [copper] = Ns7.section(plane=ZX)
  Ns8_Section1 [copper] = Ns8.section(plane=ZX)
  Ns9_Section1 [copper] = Ns9.section(plane=ZX)
  Ns10_Section1 [copper] = Ns10.section(plane=ZX)
  Np1_Section1.separate_bodies()
  Np2_Section1.separate_bodies()
  Np3_Section1.separate_bodies()
  Np4_Section1.separate_bodies()
  Np5_Section1.separate_bodies()
  Np6_Section1.separate_bodies()
  Np7_Section1.separate_bodies()
  Np8_Section1.separate_bodies()
  Np9_Section1.separate_bodies()
  Np10_Section1.separate_bodies()
  Ns1_Section1.separate_bodies()
  Ns2_Section1.separate_bodies()
  Ns3_Section1.separate_bodies()
  Ns4_Section1.separate_bodies()
  Ns5_Section1.separate_bodies()
  Ns6_Section1.separate_bodies()
  Ns7_Section1.separate_bodies()
  Ns8_Section1.separate_bodies()
  Ns9_Section1.separate_bodies()
  Ns10_Section1.separate_bodies()
  group core_assembled_flatwise = Np1, Np10, Np2..Np9, Ns1, Ns10, Ns2..Ns9, plate_1, plate_2, Np1_Section1, Np2_Section1, Np3_Section1, Np4_Section1, Np5_Section1, Np6_Section1, Np7_Section1, Np8_Section1, Np9_Section1, Np10_Section1, Ns1_Section1, Ns2_Section1, Ns3_Section1, Ns4_Section1, Ns5_Section1, Ns6_Section1, Ns7_Section1, Ns8_Section1, Ns9_Section1, Ns10_Section1
  group core_together_1 = Body1, Body1_1, Body1_2
  group core_together = Body1_3, Body1_4, Body1_5
boundaries and excitations:
  Np_1: Coil Terminal Objects=Np1_Section1 Conductor_number=1 Winding=Np Point_out_of_terminal=false
  Np_2: Coil Terminal Objects=Np2_Section1 Conductor_number=1 Winding=Np Point_out_of_terminal=false
  Np_3: Coil Terminal Objects=Np3_Section1 Conductor_number=1 Winding=Np Point_out_of_terminal=false
  Np_4: Coil Terminal Objects=Np4_Section1 Conductor_number=1 Winding=Np Point_out_of_terminal=false
  Np_5: Coil Terminal Objects=Np5_Section1 Conductor_number=1 Winding=Np Point_out_of_terminal=false
  Np_6: Coil Terminal Objects=Np6_Section1 Conductor_number=1 Winding=Np Point_out_of_terminal=false
  Np_7: Coil Terminal Objects=Np7_Section1 Conductor_number=1 Winding=Np Point_out_of_terminal=false
  Np_8: Coil Terminal Objects=Np8_Section1 Conductor_number=1 Winding=Np Point_out_of_terminal=false
  Np_9: Coil Terminal Objects=Np9_Section1 Conductor_number=1 Winding=Np Point_out_of_terminal=false
  Np_10: Coil Terminal Objects=Np10_Section1 Conductor_number=1 Winding=Np Point_out_of_terminal=false
  Ns_1: Coil Terminal Objects=Ns1_Section1 Conductor_number=1 Winding=Ns Point_out_of_terminal=true
  Ns_2: Coil Terminal Objects=Ns2_Section1 Conductor_number=1 Winding=Ns Point_out_of_terminal=true
  Ns_3: Coil Terminal Objects=Ns3_Section1 Conductor_number=1 Winding=Ns Point_out_of_terminal=true
  Ns_4: Coil Terminal Objects=Ns4_Section1 Conductor_number=1 Winding=Ns Point_out_of_terminal=true
  Ns_5: Coil Terminal Objects=Ns5_Section1 Conductor_number=1 Winding=Ns Point_out_of_terminal=true
  Ns_6: Coil Terminal Objects=Ns6_Section1 Conductor_number=1 Winding=Ns Point_out_of_terminal=true
  Ns_7: Coil Terminal Objects=Ns7_Section1 Conductor_number=1 Winding=Ns Point_out_of_terminal=true
  Ns_8: Coil Terminal Objects=Ns8_Section1 Conductor_number=1 Winding=Ns Point_out_of_terminal=true
  Ns_9: Coil Terminal Objects=Ns9_Section1 Conductor_number=1 Winding=Ns Point_out_of_terminal=true
  Ns_10: Coil Terminal Objects=Ns10_Section1 Conductor_number=1 Winding=Ns Point_out_of_terminal=true
  Np: Winding Group Type=Current IsSolid=true Current=16.36A ParallelBranchesNum=1 Phase=0rad
  Ns: Winding Group Type=Current IsSolid=true Current=15.96A ParallelBranchesNum=1 Phase=0.1522rad
  eddy effects on: Np1, Np10, Np2..Np9, Ns1, Ns10, Ns2..Ns9, Body1_1, Body1_2, Body1_4, Body1_5
parameters:
  Matrix1: Matrix Np, Ns:
mesh:
  Length1: LengthBased Objects=[Np1..Np10, Ns1..Ns10, plate_1, plate_2] MaxLength=1.5mm
  Length2: LengthBased Objects=[Body1_4, Body1_5, Body1_3, Body1_1, Body1_2, Body1] MaxLength=4.5mm
  initial mesh: GlobalSurfApproximation{CurvedSurfaceApproxChoice=UseSlider SliderMeshSettings=9} GlobalCurvilinear{Apply} MeshMethod=AnsoftClassic
setups:
  Setup1: EddyCurrent MaximumPasses=20 MinimumPasses=2 MinimumConvergedPasses=1 PercentRefinement=30 PercentError=1 NonLinearResidual=0.0001 Frequency=28.5kHz LossAdaptiveCtrl=0.5
field plots:
  Mag_B1: B over Body1_3, Body1 on Setup1 : LastAdaptive at Freq=28.5kHz Phase=45deg
  Mag_J1: J over Np1..Np10, Ns1..Ns10 on Setup1 : LastAdaptive at Freq=28.5kHz Phase=45deg
  Mesh1: MeshPlots in Body1, Body1_3, Body1_5, Body1_4, Body1_2 on Setup1 : LastAdaptive at Freq=28.5kHz Phase=0deg
  Mesh2: MeshPlots in Np1..Np10, Ns1..Ns10 on Setup1 : LastAdaptive at Freq=28.5kHz Phase=0deg

design [Corrected]_10turns_3D_WindingLoss_PSSP (Maxwell 3D, EddyCurrent, model units mm)
geometry:
  Np1, Np10, Np2..Np9, Ns1, Ns10, Ns2..Ns9 [copper] = imported_body(C:\Users\karlr\Documents\flatwise_corrected.step)
  plate_1, plate_2 [silicon - Copy] = imported_body(C:\Users\karlr\Documents\flatwise_corrected.step)
  Body1 [ferrite - Copy] = imported_body(C:\Users\karlr\Documents\flatwise_corrected.step)
  Body1_1, Body1_2 [aluminum] = imported_body(C:\Users\karlr\Documents\flatwise_corrected.step)
  Body1_3 [ferrite - Copy] = imported_body(C:\Users\karlr\Documents\flatwise_corrected.step)
  Body1_4, Body1_5 [aluminum] = imported_body(C:\Users\karlr\Documents\flatwise_corrected.step)
  Region [vacuum] = region(percentage_offset=0 on all sides)
  Np1_Section1 [copper] = Np1.section(plane=ZX)
  Np2_Section1 [copper] = Np2.section(plane=ZX)
  Np3_Section1 [copper] = Np3.section(plane=ZX)
  Np4_Section1 [copper] = Np4.section(plane=ZX)
  Np5_Section1 [copper] = Np5.section(plane=ZX)
  Np6_Section1 [copper] = Np6.section(plane=ZX)
  Np7_Section1 [copper] = Np7.section(plane=ZX)
  Np8_Section1 [copper] = Np8.section(plane=ZX)
  Np9_Section1 [copper] = Np9.section(plane=ZX)
  Np10_Section1 [copper] = Np10.section(plane=ZX)
  Ns1_Section1 [copper] = Ns1.section(plane=ZX)
  Ns2_Section1 [copper] = Ns2.section(plane=ZX)
  Ns3_Section1 [copper] = Ns3.section(plane=ZX)
  Ns4_Section1 [copper] = Ns4.section(plane=ZX)
  Ns5_Section1 [copper] = Ns5.section(plane=ZX)
  Ns6_Section1 [copper] = Ns6.section(plane=ZX)
  Ns7_Section1 [copper] = Ns7.section(plane=ZX)
  Ns8_Section1 [copper] = Ns8.section(plane=ZX)
  Ns9_Section1 [copper] = Ns9.section(plane=ZX)
  Ns10_Section1 [copper] = Ns10.section(plane=ZX)
  Np1_Section1.separate_bodies()
  Np2_Section1.separate_bodies()
  Np3_Section1.separate_bodies()
  Np4_Section1.separate_bodies()
  Np5_Section1.separate_bodies()
  Np6_Section1.separate_bodies()
  Np7_Section1.separate_bodies()
  Np8_Section1.separate_bodies()
  Np9_Section1.separate_bodies()
  Np10_Section1.separate_bodies()
  Ns1_Section1.separate_bodies()
  Ns2_Section1.separate_bodies()
  Ns3_Section1.separate_bodies()
  Ns4_Section1.separate_bodies()
  Ns5_Section1.separate_bodies()
  Ns6_Section1.separate_bodies()
  Ns7_Section1.separate_bodies()
  Ns8_Section1.separate_bodies()
  Ns9_Section1.separate_bodies()
  Ns10_Section1.separate_bodies()
  group core_assembled_flatwise = Np1, Np10, Np2..Np9, Ns1, Ns10, Ns2..Ns9, plate_1, plate_2, Np1_Section1, Np2_Section1, Np3_Section1, Np4_Section1, Np5_Section1, Np6_Section1, Np7_Section1, Np8_Section1, Np9_Section1, Np10_Section1, Ns1_Section1, Ns2_Section1, Ns3_Section1, Ns4_Section1, Ns5_Section1, Ns6_Section1, Ns7_Section1, Ns8_Section1, Ns9_Section1, Ns10_Section1
  group core_together_1 = Body1, Body1_1, Body1_2
  group core_together = Body1_3, Body1_4, Body1_5
boundaries and excitations:
  Np_1: Coil Terminal Objects=Np1_Section1 Conductor_number=1 Winding=Np Point_out_of_terminal=false
  Np_2: Coil Terminal Objects=Np3_Section1 Conductor_number=1 Winding=Np Point_out_of_terminal=false
  Np_3: Coil Terminal Objects=Np5_Section1 Conductor_number=1 Winding=Np Point_out_of_terminal=false
  Np_4: Coil Terminal Objects=Np7_Section1 Conductor_number=1 Winding=Np Point_out_of_terminal=false
  Np_5: Coil Terminal Objects=Np9_Section1 Conductor_number=1 Winding=Np Point_out_of_terminal=false
  Np_6: Coil Terminal Objects=Ns2_Section1 Conductor_number=1 Winding=Np Point_out_of_terminal=false
  Np_7: Coil Terminal Objects=Ns4_Section1 Conductor_number=1 Winding=Np Point_out_of_terminal=false
  Np_8: Coil Terminal Objects=Ns6_Section1 Conductor_number=1 Winding=Np Point_out_of_terminal=false
  Np_9: Coil Terminal Objects=Ns8_Section1 Conductor_number=1 Winding=Np Point_out_of_terminal=false
  Np_10: Coil Terminal Objects=Ns10_Section1 Conductor_number=1 Winding=Np Point_out_of_terminal=false
  Ns_1: Coil Terminal Objects=Np2_Section1 Conductor_number=1 Winding=Ns Point_out_of_terminal=true
  Ns_2: Coil Terminal Objects=Np4_Section1 Conductor_number=1 Winding=Ns Point_out_of_terminal=true
  Ns_3: Coil Terminal Objects=Np6_Section1 Conductor_number=1 Winding=Ns Point_out_of_terminal=true
  Ns_4: Coil Terminal Objects=Np8_Section1 Conductor_number=1 Winding=Ns Point_out_of_terminal=true
  Ns_5: Coil Terminal Objects=Np10_Section1 Conductor_number=1 Winding=Ns Point_out_of_terminal=true
  Ns_6: Coil Terminal Objects=Ns1_Section1 Conductor_number=1 Winding=Ns Point_out_of_terminal=true
  Ns_7: Coil Terminal Objects=Ns3_Section1 Conductor_number=1 Winding=Ns Point_out_of_terminal=true
  Ns_8: Coil Terminal Objects=Ns5_Section1 Conductor_number=1 Winding=Ns Point_out_of_terminal=true
  Ns_9: Coil Terminal Objects=Ns7_Section1 Conductor_number=1 Winding=Ns Point_out_of_terminal=true
  Ns_10: Coil Terminal Objects=Ns9_Section1 Conductor_number=1 Winding=Ns Point_out_of_terminal=true
  Np: Winding Group Type=Current IsSolid=true Current=16.36A ParallelBranchesNum=1 Phase=0rad
  Ns: Winding Group Type=Current IsSolid=true Current=15.96A ParallelBranchesNum=1 Phase=0.1522rad
  eddy effects on: Np1, Np10, Np2..Np9, Ns1, Ns10, Ns2..Ns9, Body1_1, Body1_2, Body1_4, Body1_5
parameters:
  Matrix1: Matrix Np, Ns:
mesh:
  Length1: LengthBased Objects=[Np1..Np10, Ns1..Ns10, plate_1, plate_2] MaxLength=1.5mm
  Length2: LengthBased Objects=[Body1_4, Body1_5, Body1_3, Body1_1, Body1_2, Body1] MaxLength=4.5mm
  initial mesh: GlobalSurfApproximation{CurvedSurfaceApproxChoice=UseSlider SliderMeshSettings=9} GlobalCurvilinear{Apply} MeshMethod=AnsoftClassic
setups:
  Setup1: EddyCurrent MaximumPasses=20 MinimumPasses=2 MinimumConvergedPasses=1 PercentRefinement=30 PercentError=1 NonLinearResidual=0.0001 Frequency=28.5kHz LossAdaptiveCtrl=0.5

design [Corrected]_10turns_3D_CoreLoss_PSSP (Maxwell 3D, EddyCurrent, model units mm)
geometry:
  Np1, Np10, Np2..Np9, Ns1, Ns10, Ns2..Ns9 [copper] = imported_body(C:\Users\karlr\Documents\flatwise_corrected.step)
  plate_1, plate_2 [silicon - Copy] = imported_body(C:\Users\karlr\Documents\flatwise_corrected.step)
  Body1 [ferrite - Copy] = imported_body(C:\Users\karlr\Documents\flatwise_corrected.step)
  Body1_1, Body1_2 [aluminum] = imported_body(C:\Users\karlr\Documents\flatwise_corrected.step)
  Body1_3 [ferrite - Copy] = imported_body(C:\Users\karlr\Documents\flatwise_corrected.step)
  Body1_4, Body1_5 [aluminum] = imported_body(C:\Users\karlr\Documents\flatwise_corrected.step)
  Region [vacuum] = region(percentage_offset=0 on all sides)
  Np1_Section1 [copper] = Np1.section(plane=ZX)
  Np2_Section1 [copper] = Np2.section(plane=ZX)
  Np3_Section1 [copper] = Np3.section(plane=ZX)
  Np4_Section1 [copper] = Np4.section(plane=ZX)
  Np5_Section1 [copper] = Np5.section(plane=ZX)
  Np6_Section1 [copper] = Np6.section(plane=ZX)
  Np7_Section1 [copper] = Np7.section(plane=ZX)
  Np8_Section1 [copper] = Np8.section(plane=ZX)
  Np9_Section1 [copper] = Np9.section(plane=ZX)
  Np10_Section1 [copper] = Np10.section(plane=ZX)
  Ns1_Section1 [copper] = Ns1.section(plane=ZX)
  Ns2_Section1 [copper] = Ns2.section(plane=ZX)
  Ns3_Section1 [copper] = Ns3.section(plane=ZX)
  Ns4_Section1 [copper] = Ns4.section(plane=ZX)
  Ns5_Section1 [copper] = Ns5.section(plane=ZX)
  Ns6_Section1 [copper] = Ns6.section(plane=ZX)
  Ns7_Section1 [copper] = Ns7.section(plane=ZX)
  Ns8_Section1 [copper] = Ns8.section(plane=ZX)
  Ns9_Section1 [copper] = Ns9.section(plane=ZX)
  Ns10_Section1 [copper] = Ns10.section(plane=ZX)
  Np1_Section1.separate_bodies()
  Np2_Section1.separate_bodies()
  Np3_Section1.separate_bodies()
  Np4_Section1.separate_bodies()
  Np5_Section1.separate_bodies()
  Np6_Section1.separate_bodies()
  Np7_Section1.separate_bodies()
  Np8_Section1.separate_bodies()
  Np9_Section1.separate_bodies()
  Np10_Section1.separate_bodies()
  Ns1_Section1.separate_bodies()
  Ns2_Section1.separate_bodies()
  Ns3_Section1.separate_bodies()
  Ns4_Section1.separate_bodies()
  Ns5_Section1.separate_bodies()
  Ns6_Section1.separate_bodies()
  Ns7_Section1.separate_bodies()
  Ns8_Section1.separate_bodies()
  Ns9_Section1.separate_bodies()
  Ns10_Section1.separate_bodies()
  group core_assembled_flatwise = Np1, Np10, Np2..Np9, Ns1, Ns10, Ns2..Ns9, plate_1, plate_2, Np1_Section1, Np2_Section1, Np3_Section1, Np4_Section1, Np5_Section1, Np6_Section1, Np7_Section1, Np8_Section1, Np9_Section1, Np10_Section1, Ns1_Section1, Ns2_Section1, Ns3_Section1, Ns4_Section1, Ns5_Section1, Ns6_Section1, Ns7_Section1, Ns8_Section1, Ns9_Section1, Ns10_Section1
  group core_together_1 = Body1, Body1_1, Body1_2
  group core_together = Body1_3, Body1_4, Body1_5
boundaries and excitations:
  Np_1: Coil Terminal Objects=Np1_Section1 Conductor_number=1 Winding=Np Point_out_of_terminal=false
  Np_2: Coil Terminal Objects=Np3_Section1 Conductor_number=1 Winding=Np Point_out_of_terminal=false
  Np_3: Coil Terminal Objects=Np5_Section1 Conductor_number=1 Winding=Np Point_out_of_terminal=false
  Np_4: Coil Terminal Objects=Np7_Section1 Conductor_number=1 Winding=Np Point_out_of_terminal=false
  Np_5: Coil Terminal Objects=Np9_Section1 Conductor_number=1 Winding=Np Point_out_of_terminal=false
  Np_6: Coil Terminal Objects=Ns2_Section1 Conductor_number=1 Winding=Np Point_out_of_terminal=false
  Np_7: Coil Terminal Objects=Ns4_Section1 Conductor_number=1 Winding=Np Point_out_of_terminal=false
  Np_8: Coil Terminal Objects=Ns6_Section1 Conductor_number=1 Winding=Np Point_out_of_terminal=false
  Np_9: Coil Terminal Objects=Ns8_Section1 Conductor_number=1 Winding=Np Point_out_of_terminal=false
  Np_10: Coil Terminal Objects=Ns10_Section1 Conductor_number=1 Winding=Np Point_out_of_terminal=false
  Ns_1: Coil Terminal Objects=Np2_Section1 Conductor_number=1 Winding=Ns Point_out_of_terminal=true
  Ns_2: Coil Terminal Objects=Np4_Section1 Conductor_number=1 Winding=Ns Point_out_of_terminal=true
  Ns_3: Coil Terminal Objects=Np6_Section1 Conductor_number=1 Winding=Ns Point_out_of_terminal=true
  Ns_4: Coil Terminal Objects=Np8_Section1 Conductor_number=1 Winding=Ns Point_out_of_terminal=true
  Ns_5: Coil Terminal Objects=Np10_Section1 Conductor_number=1 Winding=Ns Point_out_of_terminal=true
  Ns_6: Coil Terminal Objects=Ns1_Section1 Conductor_number=1 Winding=Ns Point_out_of_terminal=true
  Ns_7: Coil Terminal Objects=Ns3_Section1 Conductor_number=1 Winding=Ns Point_out_of_terminal=true
  Ns_8: Coil Terminal Objects=Ns5_Section1 Conductor_number=1 Winding=Ns Point_out_of_terminal=true
  Ns_9: Coil Terminal Objects=Ns7_Section1 Conductor_number=1 Winding=Ns Point_out_of_terminal=true
  Ns_10: Coil Terminal Objects=Ns9_Section1 Conductor_number=1 Winding=Ns Point_out_of_terminal=true
  Np: Winding Group Type=Voltage IsSolid=true Current=16.36A Resistance=0ohm Inductance=0nH Voltage=141V ParallelBranchesNum=1 Phase=0rad
  Ns: Winding Group Type=Current IsSolid=true Current=0A ParallelBranchesNum=1 Phase=0rad
  eddy effects on: Np1, Np10, Np2..Np9, Ns1, Ns10, Ns2..Ns9, Body1_1, Body1_2, Body1_4, Body1_5
  core loss on: Body1, Body1_3
parameters:
  Matrix1: Matrix Np, Ns:
mesh:
  Length1: LengthBased Objects=[Np1..Np10, Ns1..Ns10, plate_1, plate_2] MaxLength=1.5mm
  Length2: LengthBased Objects=[Body1_4, Body1_5, Body1_3, Body1_1, Body1_2, Body1] MaxLength=4.5mm
  initial mesh: GlobalSurfApproximation{CurvedSurfaceApproxChoice=UseSlider SliderMeshSettings=9} GlobalCurvilinear{Apply} MeshMethod=AnsoftClassic
setups:
  Setup1: EddyCurrent MaximumPasses=20 MinimumPasses=2 MinimumConvergedPasses=1 PercentRefinement=30 PercentError=1 NonLinearResidual=0.0001 Frequency=28.5kHz LossAdaptiveCtrl=0.5

design [Corrected]_10turns_3D_Thermal_FullInterleaved (Icepak, SteadyState TemperatureAndFlow, model units mm)
options: Default_Fluid_Material=air Default_Solid_Material=Al-Extruded Default_Surface_Material=Steel-oxidised-surface AmbientTemperature=20cel AmbientPressure=0n_per_meter_sq AmbientRadiationTemperature=20cel Gravity_Vector_CS_ID=Global Gravity_Vector_Axis=Z Positive=false Altitude=0meter OperatingPressure=101325n_per_meter_sq OperatingDensity=1.225kg_per_m3
geometry:
  Region [air] = region(percentage_offset=1000 on all sides)
  Np1 [copper] = imported_body(C:\Users\karlr\Documents\flatwise_corrected.step)
  Np1_Section1 [copper] = Np1.section(plane=ZX)
  Np10 [copper] = imported_body(C:\Users\karlr\Documents\flatwise_corrected.step)
  Np10_Section1 [copper] = Np10.section(plane=ZX)
  Np2 [copper] = imported_body(C:\Users\karlr\Documents\flatwise_corrected.step)
  Np2_Section1 [copper] = Np2.section(plane=ZX)
  Np3 [copper] = imported_body(C:\Users\karlr\Documents\flatwise_corrected.step)
  Np3_Section1 [copper] = Np3.section(plane=ZX)
  Np4 [copper] = imported_body(C:\Users\karlr\Documents\flatwise_corrected.step)
  Np4_Section1 [copper] = Np4.section(plane=ZX)
  Np5 [copper] = imported_body(C:\Users\karlr\Documents\flatwise_corrected.step)
  Np5_Section1 [copper] = Np5.section(plane=ZX)
  Np6 [copper] = imported_body(C:\Users\karlr\Documents\flatwise_corrected.step)
  Np6_Section1 [copper] = Np6.section(plane=ZX)
  Np7 [copper] = imported_body(C:\Users\karlr\Documents\flatwise_corrected.step)
  Np7_Section1 [copper] = Np7.section(plane=ZX)
  Np8 [copper] = imported_body(C:\Users\karlr\Documents\flatwise_corrected.step)
  Np8_Section1 [copper] = Np8.section(plane=ZX)
  Np9 [copper] = imported_body(C:\Users\karlr\Documents\flatwise_corrected.step)
  Np9_Section1 [copper] = Np9.section(plane=ZX)
  Ns1 [copper] = imported_body(C:\Users\karlr\Documents\flatwise_corrected.step)
  Ns1_Section1 [copper] = Ns1.section(plane=ZX)
  Ns10 [copper] = imported_body(C:\Users\karlr\Documents\flatwise_corrected.step)
  Ns10_Section1 [copper] = Ns10.section(plane=ZX)
  Ns2 [copper] = imported_body(C:\Users\karlr\Documents\flatwise_corrected.step)
  Ns2_Section1 [copper] = Ns2.section(plane=ZX)
  Ns3 [copper] = imported_body(C:\Users\karlr\Documents\flatwise_corrected.step)
  Ns3_Section1 [copper] = Ns3.section(plane=ZX)
  Ns4 [copper] = imported_body(C:\Users\karlr\Documents\flatwise_corrected.step)
  Ns4_Section1 [copper] = Ns4.section(plane=ZX)
  Ns5 [copper] = imported_body(C:\Users\karlr\Documents\flatwise_corrected.step)
  Ns5_Section1 [copper] = Ns5.section(plane=ZX)
  Ns6 [copper] = imported_body(C:\Users\karlr\Documents\flatwise_corrected.step)
  Ns6_Section1 [copper] = Ns6.section(plane=ZX)
  Ns7 [copper] = imported_body(C:\Users\karlr\Documents\flatwise_corrected.step)
  Ns7_Section1 [copper] = Ns7.section(plane=ZX)
  Ns8 [copper] = imported_body(C:\Users\karlr\Documents\flatwise_corrected.step)
  Ns8_Section1 [copper] = Ns8.section(plane=ZX)
  Ns9 [copper] = imported_body(C:\Users\karlr\Documents\flatwise_corrected.step)
  Ns9_Section1 [copper] = Ns9.section(plane=ZX)
  plate_1, plate_2 [silicon - Copy (2)] = imported_body(C:\Users\karlr\Documents\flatwise_corrected.step)
  Body1 [ferrite - Copy] = imported_body(C:\Users\karlr\Documents\flatwise_corrected.step)
  Body1_1, Body1_2 [aluminum] = imported_body(C:\Users\karlr\Documents\flatwise_corrected.step)
  Body1_3 [ferrite - Copy] = imported_body(C:\Users\karlr\Documents\flatwise_corrected.step)
  Body1_4, Body1_5 [aluminum] = imported_body(C:\Users\karlr\Documents\flatwise_corrected.step)
  Np1_Section1.separate_bodies()
  Np2_Section1.separate_bodies()
  Np3_Section1.separate_bodies()
  Np4_Section1.separate_bodies()
  Np5_Section1.separate_bodies()
  Np6_Section1.separate_bodies()
  Np7_Section1.separate_bodies()
  Np8_Section1.separate_bodies()
  Np9_Section1.separate_bodies()
  Np10_Section1.separate_bodies()
  Ns1_Section1.separate_bodies()
  Ns2_Section1.separate_bodies()
  Ns3_Section1.separate_bodies()
  Ns4_Section1.separate_bodies()
  Ns5_Section1.separate_bodies()
  Ns6_Section1.separate_bodies()
  Ns7_Section1.separate_bodies()
  Ns8_Section1.separate_bodies()
  Ns9_Section1.separate_bodies()
  Ns10_Section1.separate_bodies()
  MeshRegion1_SubRegion [air, non-model] = sub_region(of=Np3, Np1, Ns7, Np7, Ns2, Np2, Np4, Np5, Np6, Np8, Np9, Np10, Ns1, Ns3..Ns6, Ns8, Ns9, Ns10, plate_1, plate_2, percentage_offset=0 on all sides)
  Rectangle1 [Al-Extruded, non-model] = rectangle(corner=(122mm, 18.25mm, 0mm), z_size=39mm, x_size=-122mm)
  group core_assembled_flatwise = Np1, Np10, Np2..Np9, Ns1, Ns10, Ns2..Ns9, plate_1, plate_2, Np1_Section1, Np2_Section1, Np3_Section1, Np4_Section1, Np5_Section1, Np6_Section1, Np7_Section1, Np8_Section1, Np9_Section1, Np10_Section1, Ns1_Section1, Ns2_Section1, Ns3_Section1, Ns4_Section1, Ns5_Section1, Ns6_Section1, Ns7_Section1, Ns8_Section1, Ns9_Section1, Ns10_Section1
  group core_together_1 = Body1, Body1_1, Body1_2
  group core_together = Body1_3, Body1_4, Body1_5
boundaries and excitations:
  Opening1: Opening Faces=Region.face(-y) Temperature=AmbientTemp External_Rad._Temperature=AmbientRadTemp Inlet_Type=Pressure Total_Pressure=AmbientPressure
  Opening2: Opening Faces=Region.face(+y) Temperature=AmbientTemp External_Rad._Temperature=AmbientRadTemp Inlet_Type=Velocity Static_Pressure=AmbientPressure X_Velocity=0m_per_sec Y_Velocity=0m_per_sec Z_Velocity=0m_per_sec
  EMLoss3: EM Loss Objects=[Np1..Np10, Ns1..Ns10] LinkID=222 Project="This Project*" Product="Maxwell 3D" Design=[Corrected]_10turns_3D_WindingLoss_FullInterleaved ForceSourceToSolve PreservePartnerSoln PathRelativeTo=TargetProject Intrinsics(28.5kHz) LossMultiplier=1
  EMLoss4: EM Loss Objects=[Body1, Body1_1..Body1_5] LinkID=227 Project="This Project*" Product="Maxwell 3D" Design=[Corrected]_10turns_3D_CoreLoss_FullInterleaved ForceSourceToSolve PreservePartnerSoln PathRelativeTo=TargetProject Intrinsics(28.5kHz) LossMultiplier=1
mesh:
  Global:  MeshMethod=MesherHD ComputeGap MeshRegionResolution=5 MinGapX=1mm MinGapY=1mm MinGapZ=1mm Objects=Region FacetLevel=5 ProximitySizeFunction CurvatureSizeFunction OptimizePCBMesh
  MeshRegion1:  MeshMethod=MesherHD MeshRegionResolution=5 MinGapX=1mm MinGapY=1mm MinGapZ=0.9mm Objects=MeshRegion1_SubRegion ProximitySizeFunction CurvatureSizeFunction OptimizePCBMesh
setups:
  Setup1: IcepakSteadyState Flow_Regime=Laminar Include_Temperature=true Include_Flow=true Include_Gravity Solution_Initialization_-_Z_Velocity=0.000980665m_per_sec Convergence_Criteria_-_Flow=0.001 Convergence_Criteria_-_Energy=1e-07 Convergence_Criteria_-_Discrete_Ordinates=1e-06 GPU_Convergence_Criteria_-_Flow=0.001 GPU_Convergence_Criteria_-_Energy=1e-05 GPU_Convergence_Criteria_-_Discrete_Ordinates=1e-05 Radiation_Model="Discrete Ordinates Model" Flow_Iteration_Per_Radiation_Iteration=10 Time_Step_Interval=1 ThetaDivision=2 PhiDivision=2 ThetaPixels=2 PhiPixels=2 Under-relaxation_-_Pressure=0.7 Under-relaxation_-_Momentum=0.3 Under-relaxation_-_Temperature=1 Under-relaxation_-_Body_Force=1 Discretization_Scheme_-_Pressure=Standard Discretization_Scheme_-_Momentum=First Discretization_Scheme_-_Temperature=First Discretization_Scheme_-_Discrete_Ordinates=First Convergence_Criteria_-_Max_Iterations=200
field plots:
  Temperature1: Temperature on Setup1 : SteadyState
  Temperature2: Temperature over a plane on Setup1 : SteadyState

design [Corrected]_10turns_3D_CoreLoss_NoInterleaving (Maxwell 3D, EddyCurrent, model units mm)
geometry:
  Np1, Np10, Np2..Np9, Ns1, Ns10, Ns2..Ns9 [copper] = imported_body(C:\Users\karlr\Documents\flatwise_corrected.step)
  plate_1, plate_2 [silicon - Copy] = imported_body(C:\Users\karlr\Documents\flatwise_corrected.step)
  Body1 [ferrite - Copy] = imported_body(C:\Users\karlr\Documents\flatwise_corrected.step)
  Body1_1, Body1_2 [aluminum] = imported_body(C:\Users\karlr\Documents\flatwise_corrected.step)
  Body1_3 [ferrite - Copy] = imported_body(C:\Users\karlr\Documents\flatwise_corrected.step)
  Body1_4, Body1_5 [aluminum] = imported_body(C:\Users\karlr\Documents\flatwise_corrected.step)
  Region [vacuum] = region(percentage_offset=0 on all sides)
  Np1_Section1 [copper] = Np1.section(plane=ZX)
  Np2_Section1 [copper] = Np2.section(plane=ZX)
  Np3_Section1 [copper] = Np3.section(plane=ZX)
  Np4_Section1 [copper] = Np4.section(plane=ZX)
  Np5_Section1 [copper] = Np5.section(plane=ZX)
  Np6_Section1 [copper] = Np6.section(plane=ZX)
  Np7_Section1 [copper] = Np7.section(plane=ZX)
  Np8_Section1 [copper] = Np8.section(plane=ZX)
  Np9_Section1 [copper] = Np9.section(plane=ZX)
  Np10_Section1 [copper] = Np10.section(plane=ZX)
  Ns1_Section1 [copper] = Ns1.section(plane=ZX)
  Ns2_Section1 [copper] = Ns2.section(plane=ZX)
  Ns3_Section1 [copper] = Ns3.section(plane=ZX)
  Ns4_Section1 [copper] = Ns4.section(plane=ZX)
  Ns5_Section1 [copper] = Ns5.section(plane=ZX)
  Ns6_Section1 [copper] = Ns6.section(plane=ZX)
  Ns7_Section1 [copper] = Ns7.section(plane=ZX)
  Ns8_Section1 [copper] = Ns8.section(plane=ZX)
  Ns9_Section1 [copper] = Ns9.section(plane=ZX)
  Ns10_Section1 [copper] = Ns10.section(plane=ZX)
  Np1_Section1.separate_bodies()
  Np2_Section1.separate_bodies()
  Np3_Section1.separate_bodies()
  Np4_Section1.separate_bodies()
  Np5_Section1.separate_bodies()
  Np6_Section1.separate_bodies()
  Np7_Section1.separate_bodies()
  Np8_Section1.separate_bodies()
  Np9_Section1.separate_bodies()
  Np10_Section1.separate_bodies()
  Ns1_Section1.separate_bodies()
  Ns2_Section1.separate_bodies()
  Ns3_Section1.separate_bodies()
  Ns4_Section1.separate_bodies()
  Ns5_Section1.separate_bodies()
  Ns6_Section1.separate_bodies()
  Ns7_Section1.separate_bodies()
  Ns8_Section1.separate_bodies()
  Ns9_Section1.separate_bodies()
  Ns10_Section1.separate_bodies()
  group core_assembled_flatwise = Np1, Np10, Np2..Np9, Ns1, Ns10, Ns2..Ns9, plate_1, plate_2, Np1_Section1, Np2_Section1, Np3_Section1, Np4_Section1, Np5_Section1, Np6_Section1, Np7_Section1, Np8_Section1, Np9_Section1, Np10_Section1, Ns1_Section1, Ns2_Section1, Ns3_Section1, Ns4_Section1, Ns5_Section1, Ns6_Section1, Ns7_Section1, Ns8_Section1, Ns9_Section1, Ns10_Section1
  group core_together_1 = Body1, Body1_1, Body1_2
  group core_together = Body1_3, Body1_4, Body1_5
boundaries and excitations:
  Np_1: Coil Terminal Objects=Np1_Section1 Conductor_number=1 Winding=Np Point_out_of_terminal=false
  Np_2: Coil Terminal Objects=Np2_Section1 Conductor_number=1 Winding=Np Point_out_of_terminal=false
  Np_3: Coil Terminal Objects=Np3_Section1 Conductor_number=1 Winding=Np Point_out_of_terminal=false
  Np_4: Coil Terminal Objects=Np4_Section1 Conductor_number=1 Winding=Np Point_out_of_terminal=false
  Np_5: Coil Terminal Objects=Np5_Section1 Conductor_number=1 Winding=Np Point_out_of_terminal=false
  Np_6: Coil Terminal Objects=Ns2_Section1 Conductor_number=1 Winding=Np Point_out_of_terminal=false
  Np_7: Coil Terminal Objects=Ns1_Section1 Conductor_number=1 Winding=Np Point_out_of_terminal=false
  Np_8: Coil Terminal Objects=Ns3_Section1 Conductor_number=1 Winding=Np Point_out_of_terminal=false
  Np_9: Coil Terminal Objects=Ns4_Section1 Conductor_number=1 Winding=Np Point_out_of_terminal=false
  Np_10: Coil Terminal Objects=Ns5_Section1 Conductor_number=1 Winding=Np Point_out_of_terminal=false
  Ns_1: Coil Terminal Objects=Np6_Section1 Conductor_number=1 Winding=Ns Point_out_of_terminal=true
  Ns_2: Coil Terminal Objects=Np7_Section1 Conductor_number=1 Winding=Ns Point_out_of_terminal=true
  Ns_3: Coil Terminal Objects=Np8_Section1 Conductor_number=1 Winding=Ns Point_out_of_terminal=true
  Ns_4: Coil Terminal Objects=Np9_Section1 Conductor_number=1 Winding=Ns Point_out_of_terminal=true
  Ns_5: Coil Terminal Objects=Np10_Section1 Conductor_number=1 Winding=Ns Point_out_of_terminal=true
  Ns_6: Coil Terminal Objects=Ns6_Section1 Conductor_number=1 Winding=Ns Point_out_of_terminal=true
  Ns_7: Coil Terminal Objects=Ns7_Section1 Conductor_number=1 Winding=Ns Point_out_of_terminal=true
  Ns_8: Coil Terminal Objects=Ns8_Section1 Conductor_number=1 Winding=Ns Point_out_of_terminal=true
  Ns_9: Coil Terminal Objects=Ns9_Section1 Conductor_number=1 Winding=Ns Point_out_of_terminal=true
  Ns_10: Coil Terminal Objects=Ns10_Section1 Conductor_number=1 Winding=Ns Point_out_of_terminal=true
  Np: Winding Group Type=Voltage IsSolid=true Current=16.36A Resistance=0ohm Inductance=0nH Voltage=141V ParallelBranchesNum=1 Phase=0rad
  Ns: Winding Group Type=Current IsSolid=true Current=0A ParallelBranchesNum=1 Phase=0rad
  eddy effects on: Np1, Np10, Np2..Np9, Ns1, Ns10, Ns2..Ns9, Body1_1, Body1_2, Body1_4, Body1_5
  core loss on: Body1, Body1_3
parameters:
  Matrix1: Matrix Np, Ns:
mesh:
  Length1: LengthBased Objects=[Np1..Np10, Ns1..Ns10, plate_1, plate_2] MaxLength=1.5mm
  Length2: LengthBased Objects=[Body1_4, Body1_5, Body1_3, Body1_1, Body1_2, Body1] MaxLength=4.5mm
  initial mesh: GlobalSurfApproximation{CurvedSurfaceApproxChoice=UseSlider SliderMeshSettings=9} GlobalCurvilinear{Apply} MeshMethod=AnsoftClassic
setups:
  Setup1: EddyCurrent MaximumPasses=20 MinimumPasses=2 MinimumConvergedPasses=1 PercentRefinement=30 PercentError=1 NonLinearResidual=0.0001 Frequency=28.5kHz LossAdaptiveCtrl=0.5

design [Corrected]_10turns_3D_WindingLoss_NoInterleaving (Maxwell 3D, EddyCurrent, model units mm)
geometry:
  Np1, Np10, Np2..Np9, Ns1, Ns10, Ns2..Ns9 [copper] = imported_body(C:\Users\karlr\Documents\flatwise_corrected.step)
  plate_1, plate_2 [silicon - Copy] = imported_body(C:\Users\karlr\Documents\flatwise_corrected.step)
  Body1 [ferrite - Copy] = imported_body(C:\Users\karlr\Documents\flatwise_corrected.step)
  Body1_1, Body1_2 [aluminum] = imported_body(C:\Users\karlr\Documents\flatwise_corrected.step)
  Body1_3 [ferrite - Copy] = imported_body(C:\Users\karlr\Documents\flatwise_corrected.step)
  Body1_4, Body1_5 [aluminum] = imported_body(C:\Users\karlr\Documents\flatwise_corrected.step)
  Region [vacuum] = region(percentage_offset=0 on all sides)
  Np1_Section1 [copper] = Np1.section(plane=ZX)
  Np2_Section1 [copper] = Np2.section(plane=ZX)
  Np3_Section1 [copper] = Np3.section(plane=ZX)
  Np4_Section1 [copper] = Np4.section(plane=ZX)
  Np5_Section1 [copper] = Np5.section(plane=ZX)
  Np6_Section1 [copper] = Np6.section(plane=ZX)
  Np7_Section1 [copper] = Np7.section(plane=ZX)
  Np8_Section1 [copper] = Np8.section(plane=ZX)
  Np9_Section1 [copper] = Np9.section(plane=ZX)
  Np10_Section1 [copper] = Np10.section(plane=ZX)
  Ns1_Section1 [copper] = Ns1.section(plane=ZX)
  Ns2_Section1 [copper] = Ns2.section(plane=ZX)
  Ns3_Section1 [copper] = Ns3.section(plane=ZX)
  Ns4_Section1 [copper] = Ns4.section(plane=ZX)
  Ns5_Section1 [copper] = Ns5.section(plane=ZX)
  Ns6_Section1 [copper] = Ns6.section(plane=ZX)
  Ns7_Section1 [copper] = Ns7.section(plane=ZX)
  Ns8_Section1 [copper] = Ns8.section(plane=ZX)
  Ns9_Section1 [copper] = Ns9.section(plane=ZX)
  Ns10_Section1 [copper] = Ns10.section(plane=ZX)
  Np1_Section1.separate_bodies()
  Np2_Section1.separate_bodies()
  Np3_Section1.separate_bodies()
  Np4_Section1.separate_bodies()
  Np5_Section1.separate_bodies()
  Np6_Section1.separate_bodies()
  Np7_Section1.separate_bodies()
  Np8_Section1.separate_bodies()
  Np9_Section1.separate_bodies()
  Np10_Section1.separate_bodies()
  Ns1_Section1.separate_bodies()
  Ns2_Section1.separate_bodies()
  Ns3_Section1.separate_bodies()
  Ns4_Section1.separate_bodies()
  Ns5_Section1.separate_bodies()
  Ns6_Section1.separate_bodies()
  Ns7_Section1.separate_bodies()
  Ns8_Section1.separate_bodies()
  Ns9_Section1.separate_bodies()
  Ns10_Section1.separate_bodies()
  group core_assembled_flatwise = Np1, Np10, Np2..Np9, Ns1, Ns10, Ns2..Ns9, plate_1, plate_2, Np1_Section1, Np2_Section1, Np3_Section1, Np4_Section1, Np5_Section1, Np6_Section1, Np7_Section1, Np8_Section1, Np9_Section1, Np10_Section1, Ns1_Section1, Ns2_Section1, Ns3_Section1, Ns4_Section1, Ns5_Section1, Ns6_Section1, Ns7_Section1, Ns8_Section1, Ns9_Section1, Ns10_Section1
  group core_together_1 = Body1, Body1_1, Body1_2
  group core_together = Body1_3, Body1_4, Body1_5
boundaries and excitations:
  Np_1: Coil Terminal Objects=Np1_Section1 Conductor_number=1 Winding=Np Point_out_of_terminal=false
  Np_2: Coil Terminal Objects=Np2_Section1 Conductor_number=1 Winding=Np Point_out_of_terminal=false
  Np_3: Coil Terminal Objects=Np3_Section1 Conductor_number=1 Winding=Np Point_out_of_terminal=false
  Np_4: Coil Terminal Objects=Np4_Section1 Conductor_number=1 Winding=Np Point_out_of_terminal=false
  Np_5: Coil Terminal Objects=Np5_Section1 Conductor_number=1 Winding=Np Point_out_of_terminal=false
  Np_6: Coil Terminal Objects=Ns2_Section1 Conductor_number=1 Winding=Np Point_out_of_terminal=false
  Np_7: Coil Terminal Objects=Ns1_Section1 Conductor_number=1 Winding=Np Point_out_of_terminal=false
  Np_8: Coil Terminal Objects=Ns3_Section1 Conductor_number=1 Winding=Np Point_out_of_terminal=false
  Np_9: Coil Terminal Objects=Ns4_Section1 Conductor_number=1 Winding=Np Point_out_of_terminal=false
  Np_10: Coil Terminal Objects=Ns5_Section1 Conductor_number=1 Winding=Np Point_out_of_terminal=false
  Ns_1: Coil Terminal Objects=Np6_Section1 Conductor_number=1 Winding=Ns Point_out_of_terminal=true
  Ns_2: Coil Terminal Objects=Np7_Section1 Conductor_number=1 Winding=Ns Point_out_of_terminal=true
  Ns_3: Coil Terminal Objects=Np8_Section1 Conductor_number=1 Winding=Ns Point_out_of_terminal=true
  Ns_4: Coil Terminal Objects=Np9_Section1 Conductor_number=1 Winding=Ns Point_out_of_terminal=true
  Ns_5: Coil Terminal Objects=Np10_Section1 Conductor_number=1 Winding=Ns Point_out_of_terminal=true
  Ns_6: Coil Terminal Objects=Ns6_Section1 Conductor_number=1 Winding=Ns Point_out_of_terminal=true
  Ns_7: Coil Terminal Objects=Ns7_Section1 Conductor_number=1 Winding=Ns Point_out_of_terminal=true
  Ns_8: Coil Terminal Objects=Ns8_Section1 Conductor_number=1 Winding=Ns Point_out_of_terminal=true
  Ns_9: Coil Terminal Objects=Ns9_Section1 Conductor_number=1 Winding=Ns Point_out_of_terminal=true
  Ns_10: Coil Terminal Objects=Ns10_Section1 Conductor_number=1 Winding=Ns Point_out_of_terminal=true
  Np: Winding Group Type=Current IsSolid=true Current=16.36A ParallelBranchesNum=1 Phase=0rad
  Ns: Winding Group Type=Current IsSolid=true Current=15.96A ParallelBranchesNum=1 Phase=0.1522rad
  eddy effects on: Np1, Np10, Np2..Np9, Ns1, Ns10, Ns2..Ns9, Body1_1, Body1_2, Body1_4, Body1_5
parameters:
  Matrix1: Matrix Np, Ns:
mesh:
  Length1: LengthBased Objects=[Np1..Np10, Ns1..Ns10, plate_1, plate_2] MaxLength=1.5mm
  Length2: LengthBased Objects=[Body1_4, Body1_5, Body1_3, Body1_1, Body1_2, Body1] MaxLength=4.5mm
  initial mesh: GlobalSurfApproximation{CurvedSurfaceApproxChoice=UseSlider SliderMeshSettings=9} GlobalCurvilinear{Apply} MeshMethod=AnsoftClassic
setups:
  Setup1: EddyCurrent MaximumPasses=20 MinimumPasses=2 MinimumConvergedPasses=1 PercentRefinement=30 PercentError=1 NonLinearResidual=0.0001 Frequency=28.5kHz LossAdaptiveCtrl=0.5

design [Corrected]_10turns_3D_Thermal_FullInterleaved_EDGE (Icepak, SteadyState TemperatureAndFlow, model units mm)
options: Default_Fluid_Material=air Default_Solid_Material=Al-Extruded Default_Surface_Material=Steel-oxidised-surface AmbientTemperature=20cel AmbientPressure=0n_per_meter_sq AmbientRadiationTemperature=20cel Gravity_Vector_CS_ID=Global Gravity_Vector_Axis=Z Positive=false Altitude=0meter OperatingPressure=101325n_per_meter_sq OperatingDensity=1.225kg_per_m3
geometry:
  Region [air] = region(percentage_offset=1000 on all sides)
  Np1 [copper] = imported_body(C:\Users\karlr\Documents\edgewise_corrected.step)
  Np1_Section1 = Np1.section(plane=ZX)
  Np10 [copper] = imported_body(C:\Users\karlr\Documents\edgewise_corrected.step)
  Np10_Section1 [copper] = Np10.section(plane=ZX)
  Np2 [copper] = imported_body(C:\Users\karlr\Documents\edgewise_corrected.step)
  Np2_Section1 [copper] = Np2.section(plane=ZX)
  Np3 [copper] = imported_body(C:\Users\karlr\Documents\edgewise_corrected.step)
  Np3_Section1 [copper] = Np3.section(plane=ZX)
  Np4 [copper] = imported_body(C:\Users\karlr\Documents\edgewise_corrected.step)
  Np4_Section1 [copper] = Np4.section(plane=ZX)
  Np5 [copper] = imported_body(C:\Users\karlr\Documents\edgewise_corrected.step)
  Np5_Section1 [copper] = Np5.section(plane=ZX)
  Np6 [copper] = imported_body(C:\Users\karlr\Documents\edgewise_corrected.step)
  Np6_Section1 [copper] = Np6.section(plane=ZX)
  Np7 [copper] = imported_body(C:\Users\karlr\Documents\edgewise_corrected.step)
  Np7_Section1 [copper] = Np7.section(plane=ZX)
  Np8 [copper] = imported_body(C:\Users\karlr\Documents\edgewise_corrected.step)
  Np8_Section1 [copper] = Np8.section(plane=ZX)
  Np9 [copper] = imported_body(C:\Users\karlr\Documents\edgewise_corrected.step)
  Np9_Section1 [copper] = Np9.section(plane=ZX)
  Ns1 [copper] = imported_body(C:\Users\karlr\Documents\edgewise_corrected.step)
  Ns1_Section1 [copper] = Ns1.section(plane=ZX)
  Ns10 [copper] = imported_body(C:\Users\karlr\Documents\edgewise_corrected.step)
  Ns10_Section1 = Ns10.section(plane=ZX)
  Ns2 [copper] = imported_body(C:\Users\karlr\Documents\edgewise_corrected.step)
  Ns2_Section1 [copper] = Ns2.section(plane=ZX)
  Ns3 [copper] = imported_body(C:\Users\karlr\Documents\edgewise_corrected.step)
  Ns3_Section1 [copper] = Ns3.section(plane=ZX)
  Ns4 [copper] = imported_body(C:\Users\karlr\Documents\edgewise_corrected.step)
  Ns4_Section1 [copper] = Ns4.section(plane=ZX)
  Ns5 [copper] = imported_body(C:\Users\karlr\Documents\edgewise_corrected.step)
  Ns5_Section1 [copper] = Ns5.section(plane=ZX)
  Ns6 [copper] = imported_body(C:\Users\karlr\Documents\edgewise_corrected.step)
  Ns6_Section1 [copper] = Ns6.section(plane=ZX)
  Ns7 [copper] = imported_body(C:\Users\karlr\Documents\edgewise_corrected.step)
  Ns7_Section1 [copper] = Ns7.section(plane=ZX)
  Ns8 [copper] = imported_body(C:\Users\karlr\Documents\edgewise_corrected.step)
  Ns8_Section1 [copper] = Ns8.section(plane=ZX)
  Ns9 [copper] = imported_body(C:\Users\karlr\Documents\edgewise_corrected.step)
  Ns9_Section1 [copper] = Ns9.section(plane=ZX)
  plate1, plate2 [silicon - Copy (2)] = imported_body(C:\Users\karlr\Documents\edgewise_corrected.step)
  Body1 [ferrite - Copy] = imported_body(C:\Users\karlr\Documents\edgewise_corrected.step)
  Body1_1, Body1_2 [aluminum] = imported_body(C:\Users\karlr\Documents\edgewise_corrected.step)
  Body1_3 [ferrite - Copy] = imported_body(C:\Users\karlr\Documents\edgewise_corrected.step)
  Body1_4, Body1_5 [aluminum] = imported_body(C:\Users\karlr\Documents\edgewise_corrected.step)
  Np2_Section1.separate_bodies()
  Np3_Section1.separate_bodies()
  Np4_Section1.separate_bodies()
  Np5_Section1.separate_bodies()
  Np6_Section1.separate_bodies()
  Np7_Section1.separate_bodies()
  Np8_Section1.separate_bodies()
  Np9_Section1.separate_bodies()
  Np10_Section1.separate_bodies()
  Ns1_Section1.separate_bodies()
  Ns2_Section1.separate_bodies()
  Ns3_Section1.separate_bodies()
  Ns4_Section1.separate_bodies()
  Ns5_Section1.separate_bodies()
  Ns6_Section1.separate_bodies()
  Ns7_Section1.separate_bodies()
  Ns8_Section1.separate_bodies()
  Ns9_Section1.separate_bodies()
  Np1_Section1_Separate1 [copper] = Np1_Section1.separate_bodies()
  Np1_Section1.delete()
  Ns10_Section1_Separate1 [copper] = Ns10_Section1.separate_bodies()
  Ns10_Section1.delete()
  group core_assembled_edgewise1 = Np1, Np10, Np2..Np9, Ns1, Ns10, Ns2..Ns9, plate1, plate2, Np2_Section1, Np3_Section1, Np4_Section1, Np5_Section1, Np6_Section1, Np7_Section1, Np8_Section1, Np9_Section1, Np10_Section1, Ns1_Section1, Ns2_Section1, Ns3_Section1, Ns4_Section1, Ns5_Section1, Ns6_Section1, Ns7_Section1, Ns8_Section1, Ns9_Section1, Np1_Section1_Separate1, Ns10_Section1_Separate1
  group core_together_2 = Body1, Body1_1, Body1_2
  group core_together1 = Body1_3, Body1_4, Body1_5
boundaries and excitations:
  Opening1: Opening Faces=Region.face(-y) Temperature=AmbientTemp External_Rad._Temperature=AmbientRadTemp Inlet_Type=Pressure Total_Pressure=AmbientPressure
  Opening2: Opening Faces=Region.face(+y) Temperature=AmbientTemp External_Rad._Temperature=AmbientRadTemp Inlet_Type=Velocity Static_Pressure=AmbientPressure X_Velocity=0m_per_sec Y_Velocity=0m_per_sec Z_Velocity=0m_per_sec
  EMLoss1: EM Loss Objects=[Np1..Np10, Ns1..Ns10] LinkID=263 Project="This Project*" Product="Maxwell 3D" Design=[Corrected]_10turns_3D_FullInterleaved_Edgewise_WindingLoss ForceSourceToSolve PreservePartnerSoln PathRelativeTo=TargetProject Intrinsics(28.5kHz) LossMultiplier=1
  EMLoss2: EM Loss Objects=[Body1_4, Body1_5, Body1_3, Body1_1, Body1_2, Body1] LinkID=266 Project="This Project*" Product="Maxwell 3D" Design=[Corrected]_10turns_3D_FullInterleaved_Edgewise_CoreLoss ForceSourceToSolve PreservePartnerSoln PathRelativeTo=TargetProject Intrinsics(28.5kHz) LossMultiplier=1
mesh:
  Global:  MeshMethod=MesherHD ComputeGap MeshRegionResolution=5 MinGapX=1mm MinGapY=1mm MinGapZ=1mm Objects=Region FacetLevel=5 ProximitySizeFunction CurvatureSizeFunction OptimizePCBMesh
setups:
  Setup1: IcepakSteadyState Flow_Regime=Laminar Include_Temperature=true Include_Flow=true Include_Gravity Solution_Initialization_-_Z_Velocity=0.000980665m_per_sec Convergence_Criteria_-_Flow=0.001 Convergence_Criteria_-_Energy=1e-07 Convergence_Criteria_-_Discrete_Ordinates=1e-06 GPU_Convergence_Criteria_-_Flow=0.001 GPU_Convergence_Criteria_-_Energy=1e-05 GPU_Convergence_Criteria_-_Discrete_Ordinates=1e-05 Radiation_Model="Discrete Ordinates Model" Flow_Iteration_Per_Radiation_Iteration=10 Time_Step_Interval=1 ThetaDivision=2 PhiDivision=2 ThetaPixels=2 PhiPixels=2 Under-relaxation_-_Pressure=0.7 Under-relaxation_-_Momentum=0.3 Under-relaxation_-_Temperature=1 Under-relaxation_-_Body_Force=1 Discretization_Scheme_-_Pressure=Standard Discretization_Scheme_-_Momentum=First Discretization_Scheme_-_Temperature=First Discretization_Scheme_-_Discrete_Ordinates=First Convergence_Criteria_-_Max_Iterations=120
field plots:
  Temperature1: Temperature over Body1, Body1_1..Body1_5, Np1..Np10, Ns1..Ns10 on Setup1 : SteadyState

design [Corrected]_10turns_3D_FullInterleaved_Edgewise_WindingLoss (Maxwell 3D, EddyCurrent, model units mm)
geometry:
  Np1, Np10, Np2..Np9, Ns1, Ns10, Ns2..Ns9 [copper - tempDependent] = imported_body(C:\Users\karlr\Documents\edgewise_corrected.step)
  plate1, plate2 [silicon - Copy (2)] = imported_body(C:\Users\karlr\Documents\edgewise_corrected.step)
  Body1 [ferrite - Copy] = imported_body(C:\Users\karlr\Documents\edgewise_corrected.step)
  Body1_1, Body1_2 [aluminum] = imported_body(C:\Users\karlr\Documents\edgewise_corrected.step)
  Body1_3 [ferrite - Copy] = imported_body(C:\Users\karlr\Documents\edgewise_corrected.step)
  Body1_4, Body1_5 [aluminum] = imported_body(C:\Users\karlr\Documents\edgewise_corrected.step)
  Region [vacuum] = region(percentage_offset=0 on all sides)
  Np1_Section1 = Np1.section(plane=ZX)
  Np2_Section1 [copper - tempDependent] = Np2.section(plane=ZX)
  Np3_Section1 [copper - tempDependent] = Np3.section(plane=ZX)
  Np4_Section1 [copper - tempDependent] = Np4.section(plane=ZX)
  Np5_Section1 [copper - tempDependent] = Np5.section(plane=ZX)
  Np6_Section1 [copper - tempDependent] = Np6.section(plane=ZX)
  Np7_Section1 [copper - tempDependent] = Np7.section(plane=ZX)
  Np8_Section1 [copper - tempDependent] = Np8.section(plane=ZX)
  Np9_Section1 [copper - tempDependent] = Np9.section(plane=ZX)
  Np10_Section1 [copper - tempDependent] = Np10.section(plane=ZX)
  Ns1_Section1 [copper - tempDependent] = Ns1.section(plane=ZX)
  Ns2_Section1 [copper - tempDependent] = Ns2.section(plane=ZX)
  Ns3_Section1 [copper - tempDependent] = Ns3.section(plane=ZX)
  Ns4_Section1 [copper - tempDependent] = Ns4.section(plane=ZX)
  Ns5_Section1 [copper - tempDependent] = Ns5.section(plane=ZX)
  Ns6_Section1 [copper - tempDependent] = Ns6.section(plane=ZX)
  Ns7_Section1 [copper - tempDependent] = Ns7.section(plane=ZX)
  Ns8_Section1 [copper - tempDependent] = Ns8.section(plane=ZX)
  Ns9_Section1 [copper - tempDependent] = Ns9.section(plane=ZX)
  Ns10_Section1 = Ns10.section(plane=ZX)
  Np1_Section1_Separate1 [copper - tempDependent] = Np1_Section1.separate_bodies()
  Np1_Section1.delete()
  Np2_Section1.separate_bodies()
  Np3_Section1.separate_bodies()
  Np4_Section1.separate_bodies()
  Np5_Section1.separate_bodies()
  Np6_Section1.separate_bodies()
  Np7_Section1.separate_bodies()
  Np8_Section1.separate_bodies()
  Np9_Section1.separate_bodies()
  Np10_Section1.separate_bodies()
  Ns1_Section1.separate_bodies()
  Ns2_Section1.separate_bodies()
  Ns3_Section1.separate_bodies()
  Ns4_Section1.separate_bodies()
  Ns5_Section1.separate_bodies()
  Ns6_Section1.separate_bodies()
  Ns7_Section1.separate_bodies()
  Ns8_Section1.separate_bodies()
  Ns9_Section1.separate_bodies()
  Ns10_Section1_Separate1 [copper - tempDependent] = Ns10_Section1.separate_bodies()
  Ns10_Section1.delete()
  group core_assembled_edgewise1 = Np1, Np10, Np2..Np9, Ns1, Ns10, Ns2..Ns9, plate1, plate2, Np2_Section1, Np3_Section1, Np4_Section1, Np5_Section1, Np6_Section1, Np7_Section1, Np8_Section1, Np9_Section1, Np10_Section1, Ns1_Section1, Ns2_Section1, Ns3_Section1, Ns4_Section1, Ns5_Section1, Ns6_Section1, Ns7_Section1, Ns8_Section1, Ns9_Section1, Np1_Section1_Separate1, Ns10_Section1_Separate1
  group core_together_2 = Body1, Body1_1, Body1_2
  group core_together1 = Body1_3, Body1_4, Body1_5
boundaries and excitations:
  Np_1: Coil Terminal Objects=Np1_Section1_Separate1 Conductor_number=1 Winding=Pri Point_out_of_terminal=false
  Np_2: Coil Terminal Objects=Np2_Section1 Conductor_number=1 Winding=Pri Point_out_of_terminal=false
  Np_3: Coil Terminal Objects=Np3_Section1 Conductor_number=1 Winding=Pri Point_out_of_terminal=false
  Np_4: Coil Terminal Objects=Np4_Section1 Conductor_number=1 Winding=Pri Point_out_of_terminal=false
  Np_5: Coil Terminal Objects=Np5_Section1 Conductor_number=1 Winding=Pri Point_out_of_terminal=false
  Np_6: Coil Terminal Objects=Np6_Section1 Conductor_number=1 Winding=Pri Point_out_of_terminal=false
  Np_7: Coil Terminal Objects=Np7_Section1 Conductor_number=1 Winding=Pri Point_out_of_terminal=false
  Np_8: Coil Terminal Objects=Np8_Section1 Conductor_number=1 Winding=Pri Point_out_of_terminal=false
  Np_9: Coil Terminal Objects=Np9_Section1 Conductor_number=1 Winding=Pri Point_out_of_terminal=false
  Np_10: Coil Terminal Objects=Np10_Section1 Conductor_number=1 Winding=Pri Point_out_of_terminal=false
  Ns_1: Coil Terminal Objects=Ns1_Section1 Conductor_number=1 Winding=Sec Point_out_of_terminal=true
  Ns_2: Coil Terminal Objects=Ns2_Section1 Conductor_number=1 Winding=Sec Point_out_of_terminal=true
  Ns_3: Coil Terminal Objects=Ns3_Section1 Conductor_number=1 Winding=Sec Point_out_of_terminal=true
  Ns_4: Coil Terminal Objects=Ns4_Section1 Conductor_number=1 Winding=Sec Point_out_of_terminal=true
  Ns_5: Coil Terminal Objects=Ns5_Section1 Conductor_number=1 Winding=Sec Point_out_of_terminal=true
  Ns_6: Coil Terminal Objects=Ns6_Section1 Conductor_number=1 Winding=Sec Point_out_of_terminal=true
  Ns_7: Coil Terminal Objects=Ns7_Section1 Conductor_number=1 Winding=Sec Point_out_of_terminal=true
  Ns_8: Coil Terminal Objects=Ns8_Section1 Conductor_number=1 Winding=Sec Point_out_of_terminal=true
  Ns_9: Coil Terminal Objects=Ns9_Section1 Conductor_number=1 Winding=Sec Point_out_of_terminal=true
  Ns_10: Coil Terminal Objects=Ns10_Section1_Separate1 Conductor_number=1 Winding=Sec Point_out_of_terminal=true
  Pri: Winding Group Type=Current IsSolid=true Current=16.36A ParallelBranchesNum=1 Phase=0deg
  Sec: Winding Group Type=Current IsSolid=true Current=15.96A ParallelBranchesNum=1 Phase=0.1522rad
  eddy effects on: Np1, Np10, Np2..Np9, Ns1, Ns10, Ns2..Ns9, Body1_1, Body1_2, Body1_4, Body1_5
parameters:
  Matrix1: Matrix Pri, Sec:
mesh:
  Length: LengthBased Objects=[Np1..Np10, Ns1..Ns10, plate1, plate2] MaxLength=1.5mm
  Length1: LengthBased Objects=[Body1_1, Body1_2, Body1, Body1_4, Body1_5, Body1_3] MaxLength=4.5mm
  initial mesh: GlobalSurfApproximation{CurvedSurfaceApproxChoice=UseSlider SliderMeshSettings=9} GlobalCurvilinear{Apply} MeshMethod=AnsoftClassic
setups:
  Setup1: EddyCurrent MaximumPasses=20 MinimumPasses=2 MinimumConvergedPasses=1 PercentRefinement=30 PercentError=1 NonLinearResidual=0.0001 Frequency=28.5kHz LossAdaptiveCtrl=0.5
field plots:
  Mag_B1: B over Body1, Body1_3 on Setup1 : LastAdaptive at Freq=28.5kHz Phase=45deg
  Mag_J1: J over Np1..Np10, Ns1..Ns10 on Setup1 : LastAdaptive at Freq=28.5kHz Phase=45deg
  Mesh1: MeshPlots in Body1_3, Body1, Body1_4, Body1_5, Body1_2 on Setup1 : LastAdaptive at Freq=28.5kHz Phase=0deg

design [Corrected]_10turns_3D_FullInterleaved_Edgewise_CoreLoss (Maxwell 3D, EddyCurrent, model units mm)
geometry:
  Np1, Np10, Np2..Np9, Ns1, Ns10, Ns2..Ns9 [copper - tempDependent] = imported_body(C:\Users\karlr\Documents\edgewise_corrected.step)
  plate1, plate2 [silicon - Copy (2)] = imported_body(C:\Users\karlr\Documents\edgewise_corrected.step)
  Body1 [ferrite - Copy] = imported_body(C:\Users\karlr\Documents\edgewise_corrected.step)
  Body1_1, Body1_2 [aluminum] = imported_body(C:\Users\karlr\Documents\edgewise_corrected.step)
  Body1_3 [ferrite - Copy] = imported_body(C:\Users\karlr\Documents\edgewise_corrected.step)
  Body1_4, Body1_5 [aluminum] = imported_body(C:\Users\karlr\Documents\edgewise_corrected.step)
  Region [vacuum] = region(percentage_offset=0 on all sides)
  Np1_Section1 = Np1.section(plane=ZX)
  Np2_Section1 [copper - tempDependent] = Np2.section(plane=ZX)
  Np3_Section1 [copper - tempDependent] = Np3.section(plane=ZX)
  Np4_Section1 [copper - tempDependent] = Np4.section(plane=ZX)
  Np5_Section1 [copper - tempDependent] = Np5.section(plane=ZX)
  Np6_Section1 [copper - tempDependent] = Np6.section(plane=ZX)
  Np7_Section1 [copper - tempDependent] = Np7.section(plane=ZX)
  Np8_Section1 [copper - tempDependent] = Np8.section(plane=ZX)
  Np9_Section1 [copper - tempDependent] = Np9.section(plane=ZX)
  Np10_Section1 [copper - tempDependent] = Np10.section(plane=ZX)
  Ns1_Section1 [copper - tempDependent] = Ns1.section(plane=ZX)
  Ns2_Section1 [copper - tempDependent] = Ns2.section(plane=ZX)
  Ns3_Section1 [copper - tempDependent] = Ns3.section(plane=ZX)
  Ns4_Section1 [copper - tempDependent] = Ns4.section(plane=ZX)
  Ns5_Section1 [copper - tempDependent] = Ns5.section(plane=ZX)
  Ns6_Section1 [copper - tempDependent] = Ns6.section(plane=ZX)
  Ns7_Section1 [copper - tempDependent] = Ns7.section(plane=ZX)
  Ns8_Section1 [copper - tempDependent] = Ns8.section(plane=ZX)
  Ns9_Section1 [copper - tempDependent] = Ns9.section(plane=ZX)
  Ns10_Section1 = Ns10.section(plane=ZX)
  Np1_Section1_Separate1 [copper - tempDependent] = Np1_Section1.separate_bodies()
  Np1_Section1.delete()
  Np2_Section1.separate_bodies()
  Np3_Section1.separate_bodies()
  Np4_Section1.separate_bodies()
  Np5_Section1.separate_bodies()
  Np6_Section1.separate_bodies()
  Np7_Section1.separate_bodies()
  Np8_Section1.separate_bodies()
  Np9_Section1.separate_bodies()
  Np10_Section1.separate_bodies()
  Ns1_Section1.separate_bodies()
  Ns2_Section1.separate_bodies()
  Ns3_Section1.separate_bodies()
  Ns4_Section1.separate_bodies()
  Ns5_Section1.separate_bodies()
  Ns6_Section1.separate_bodies()
  Ns7_Section1.separate_bodies()
  Ns8_Section1.separate_bodies()
  Ns9_Section1.separate_bodies()
  Ns10_Section1_Separate1 [copper - tempDependent] = Ns10_Section1.separate_bodies()
  Ns10_Section1.delete()
  group core_assembled_edgewise1 = Np1, Np10, Np2..Np9, Ns1, Ns10, Ns2..Ns9, plate1, plate2, Np2_Section1, Np3_Section1, Np4_Section1, Np5_Section1, Np6_Section1, Np7_Section1, Np8_Section1, Np9_Section1, Np10_Section1, Ns1_Section1, Ns2_Section1, Ns3_Section1, Ns4_Section1, Ns5_Section1, Ns6_Section1, Ns7_Section1, Ns8_Section1, Ns9_Section1, Np1_Section1_Separate1, Ns10_Section1_Separate1
  group core_together_2 = Body1, Body1_1, Body1_2
  group core_together1 = Body1_3, Body1_4, Body1_5
boundaries and excitations:
  Np_1: Coil Terminal Objects=Np1_Section1_Separate1 Conductor_number=1 Winding=Pri Point_out_of_terminal=false
  Np_2: Coil Terminal Objects=Np2_Section1 Conductor_number=1 Winding=Pri Point_out_of_terminal=false
  Np_3: Coil Terminal Objects=Np3_Section1 Conductor_number=1 Winding=Pri Point_out_of_terminal=false
  Np_4: Coil Terminal Objects=Np4_Section1 Conductor_number=1 Winding=Pri Point_out_of_terminal=false
  Np_5: Coil Terminal Objects=Np5_Section1 Conductor_number=1 Winding=Pri Point_out_of_terminal=false
  Np_6: Coil Terminal Objects=Np6_Section1 Conductor_number=1 Winding=Pri Point_out_of_terminal=false
  Np_7: Coil Terminal Objects=Np7_Section1 Conductor_number=1 Winding=Pri Point_out_of_terminal=false
  Np_8: Coil Terminal Objects=Np8_Section1 Conductor_number=1 Winding=Pri Point_out_of_terminal=false
  Np_9: Coil Terminal Objects=Np9_Section1 Conductor_number=1 Winding=Pri Point_out_of_terminal=false
  Np_10: Coil Terminal Objects=Np10_Section1 Conductor_number=1 Winding=Pri Point_out_of_terminal=false
  Ns_1: Coil Terminal Objects=Ns1_Section1 Conductor_number=1 Winding=Sec Point_out_of_terminal=true
  Ns_2: Coil Terminal Objects=Ns2_Section1 Conductor_number=1 Winding=Sec Point_out_of_terminal=true
  Ns_3: Coil Terminal Objects=Ns3_Section1 Conductor_number=1 Winding=Sec Point_out_of_terminal=true
  Ns_4: Coil Terminal Objects=Ns4_Section1 Conductor_number=1 Winding=Sec Point_out_of_terminal=true
  Ns_5: Coil Terminal Objects=Ns5_Section1 Conductor_number=1 Winding=Sec Point_out_of_terminal=true
  Ns_6: Coil Terminal Objects=Ns6_Section1 Conductor_number=1 Winding=Sec Point_out_of_terminal=true
  Ns_7: Coil Terminal Objects=Ns7_Section1 Conductor_number=1 Winding=Sec Point_out_of_terminal=true
  Ns_8: Coil Terminal Objects=Ns8_Section1 Conductor_number=1 Winding=Sec Point_out_of_terminal=true
  Ns_9: Coil Terminal Objects=Ns9_Section1 Conductor_number=1 Winding=Sec Point_out_of_terminal=true
  Ns_10: Coil Terminal Objects=Ns10_Section1_Separate1 Conductor_number=1 Winding=Sec Point_out_of_terminal=true
  Pri: Winding Group Type=Voltage IsSolid=true Current=16.36A Resistance=0ohm Inductance=0nH Voltage=141V ParallelBranchesNum=1 Phase=0deg
  Sec: Winding Group Type=Current IsSolid=true Current=0A ParallelBranchesNum=1 Phase=0rad
  eddy effects on: Np1, Np10, Np2..Np9, Ns1, Ns10, Ns2..Ns9, Body1_1, Body1_2, Body1_4, Body1_5
  core loss on: Body1, Body1_3
parameters:
  Matrix1: Matrix Pri, Sec:
mesh:
  Length: LengthBased Objects=[Np1..Np10, Ns1..Ns10, plate1, plate2] MaxLength=1.5mm
  Length1: LengthBased Objects=[Body1_1, Body1_2, Body1, Body1_4, Body1_5, Body1_3] MaxLength=4.5mm
  initial mesh: GlobalSurfApproximation{CurvedSurfaceApproxChoice=UseSlider SliderMeshSettings=9} GlobalCurvilinear{Apply} MeshMethod=AnsoftClassic
setups:
  Setup1: EddyCurrent MaximumPasses=20 MinimumPasses=2 MinimumConvergedPasses=1 PercentRefinement=30 PercentError=1 NonLinearResidual=0.0001 Frequency=28.5kHz LossAdaptiveCtrl=0.5

design [Corrected]_10turns_3D_Thermal_FullInterleaved1 (Icepak, SteadyState TemperatureAndFlow, model units mm)
options: Default_Fluid_Material=air Default_Solid_Material=Al-Extruded Default_Surface_Material=Steel-oxidised-surface AmbientTemperature=20cel AmbientPressure=0n_per_meter_sq AmbientRadiationTemperature=20cel Gravity_Vector_CS_ID=Global Gravity_Vector_Axis=Z Positive=false Altitude=0meter OperatingPressure=101325n_per_meter_sq OperatingDensity=1.225kg_per_m3
geometry:
  Region [air] = region(percentage_offset=1000 on all sides)
  Np1 [copper] = imported_body(C:\Users\karlr\Documents\flatwise_corrected.step)
  Np1_Section1 [copper] = Np1.section(plane=ZX)
  Np10 [copper] = imported_body(C:\Users\karlr\Documents\flatwise_corrected.step)
  Np10_Section1 [copper] = Np10.section(plane=ZX)
  Np2 [copper] = imported_body(C:\Users\karlr\Documents\flatwise_corrected.step)
  Np2_Section1 [copper] = Np2.section(plane=ZX)
  Np3 [copper] = imported_body(C:\Users\karlr\Documents\flatwise_corrected.step)
  Np3_Section1 [copper] = Np3.section(plane=ZX)
  Np4 [copper] = imported_body(C:\Users\karlr\Documents\flatwise_corrected.step)
  Np4_Section1 [copper] = Np4.section(plane=ZX)
  Np5 [copper] = imported_body(C:\Users\karlr\Documents\flatwise_corrected.step)
  Np5_Section1 [copper] = Np5.section(plane=ZX)
  Np6 [copper] = imported_body(C:\Users\karlr\Documents\flatwise_corrected.step)
  Np6_Section1 [copper] = Np6.section(plane=ZX)
  Np7 [copper] = imported_body(C:\Users\karlr\Documents\flatwise_corrected.step)
  Np7_Section1 [copper] = Np7.section(plane=ZX)
  Np8 [copper] = imported_body(C:\Users\karlr\Documents\flatwise_corrected.step)
  Np8_Section1 [copper] = Np8.section(plane=ZX)
  Np9 [copper] = imported_body(C:\Users\karlr\Documents\flatwise_corrected.step)
  Np9_Section1 [copper] = Np9.section(plane=ZX)
  Ns1 [copper] = imported_body(C:\Users\karlr\Documents\flatwise_corrected.step)
  Ns1_Section1 [copper] = Ns1.section(plane=ZX)
  Ns10 [copper] = imported_body(C:\Users\karlr\Documents\flatwise_corrected.step)
  Ns10_Section1 [copper] = Ns10.section(plane=ZX)
  Ns2 [copper] = imported_body(C:\Users\karlr\Documents\flatwise_corrected.step)
  Ns2_Section1 [copper] = Ns2.section(plane=ZX)
  Ns3 [copper] = imported_body(C:\Users\karlr\Documents\flatwise_corrected.step)
  Ns3_Section1 [copper] = Ns3.section(plane=ZX)
  Ns4 [copper] = imported_body(C:\Users\karlr\Documents\flatwise_corrected.step)
  Ns4_Section1 [copper] = Ns4.section(plane=ZX)
  Ns5 [copper] = imported_body(C:\Users\karlr\Documents\flatwise_corrected.step)
  Ns5_Section1 [copper] = Ns5.section(plane=ZX)
  Ns6 [copper] = imported_body(C:\Users\karlr\Documents\flatwise_corrected.step)
  Ns6_Section1 [copper] = Ns6.section(plane=ZX)
  Ns7 [copper] = imported_body(C:\Users\karlr\Documents\flatwise_corrected.step)
  Ns7_Section1 [copper] = Ns7.section(plane=ZX)
  Ns8 [copper] = imported_body(C:\Users\karlr\Documents\flatwise_corrected.step)
  Ns8_Section1 [copper] = Ns8.section(plane=ZX)
  Ns9 [copper] = imported_body(C:\Users\karlr\Documents\flatwise_corrected.step)
  Ns9_Section1 [copper] = Ns9.section(plane=ZX)
  plate_1, plate_2 [silicon - Copy (2)] = imported_body(C:\Users\karlr\Documents\flatwise_corrected.step)
  Body1 [ferrite - Copy] = imported_body(C:\Users\karlr\Documents\flatwise_corrected.step)
  Body1_1, Body1_2 [aluminum] = imported_body(C:\Users\karlr\Documents\flatwise_corrected.step)
  Body1_3 [ferrite - Copy] = imported_body(C:\Users\karlr\Documents\flatwise_corrected.step)
  Body1_4, Body1_5 [aluminum] = imported_body(C:\Users\karlr\Documents\flatwise_corrected.step)
  Np1_Section1.separate_bodies()
  Np2_Section1.separate_bodies()
  Np3_Section1.separate_bodies()
  Np4_Section1.separate_bodies()
  Np5_Section1.separate_bodies()
  Np6_Section1.separate_bodies()
  Np7_Section1.separate_bodies()
  Np8_Section1.separate_bodies()
  Np9_Section1.separate_bodies()
  Np10_Section1.separate_bodies()
  Ns1_Section1.separate_bodies()
  Ns2_Section1.separate_bodies()
  Ns3_Section1.separate_bodies()
  Ns4_Section1.separate_bodies()
  Ns5_Section1.separate_bodies()
  Ns6_Section1.separate_bodies()
  Ns7_Section1.separate_bodies()
  Ns8_Section1.separate_bodies()
  Ns9_Section1.separate_bodies()
  Ns10_Section1.separate_bodies()
  SubRegion [air, non-model] = sub_region(of=Np3, Np1, Np7, Ns7, Np2, Ns2, plate_2, Np4, Np5, Ns10, Np6, Np8, Np9, Np10, Ns1, Ns3..Ns6, Ns8, Ns9, plate_1, percentage_offset=0 on all sides)
  Rectangle1 [Al-Extruded, non-model] = rectangle(corner=(122mm, 18.25mm, 0mm), z_size=39mm, x_size=-122mm)
  group core_assembled_flatwise = Np1, Np10, Np2..Np9, Ns1, Ns10, Ns2..Ns9, plate_1, plate_2, Np1_Section1, Np2_Section1, Np3_Section1, Np4_Section1, Np5_Section1, Np6_Section1, Np7_Section1, Np8_Section1, Np9_Section1, Np10_Section1, Ns1_Section1, Ns2_Section1, Ns3_Section1, Ns4_Section1, Ns5_Section1, Ns6_Section1, Ns7_Section1, Ns8_Section1, Ns9_Section1, Ns10_Section1
  group core_together_1 = Body1, Body1_1, Body1_2
  group core_together = Body1_3, Body1_4, Body1_5
boundaries and excitations:
  Opening1: Opening Faces=Region.face(-y) Temperature=AmbientTemp External_Rad._Temperature=AmbientRadTemp Inlet_Type=Pressure Total_Pressure=AmbientPressure
  Opening2: Opening Faces=Region.face(+y) Temperature=AmbientTemp External_Rad._Temperature=AmbientRadTemp Inlet_Type=Velocity Static_Pressure=AmbientPressure X_Velocity=0m_per_sec Y_Velocity=0m_per_sec Z_Velocity=0m_per_sec
  EMLoss3: EM Loss Objects=[Np1..Np10, Ns1..Ns10] LinkID=222 Project="This Project*" Product="Maxwell 3D" Design=[Corrected]_10turns_3D_WindingLoss_FullInterleaved ForceSourceToSolve PreservePartnerSoln PathRelativeTo=TargetProject Intrinsics(28.5kHz) LossMultiplier=1
  EMLoss4: EM Loss Objects=[Body1, Body1_1..Body1_5] LinkID=227 Project="This Project*" Product="Maxwell 3D" Design=[Corrected]_10turns_3D_CoreLoss_FullInterleaved ForceSourceToSolve PreservePartnerSoln PathRelativeTo=TargetProject Intrinsics(28.5kHz) LossMultiplier=1
mesh:
  Global:  MeshMethod=MesherHD ComputeGap MeshRegionResolution=5 MinGapX=1mm MinGapY=1mm MinGapZ=1mm Objects=Region FacetLevel=5 ProximitySizeFunction CurvatureSizeFunction OptimizePCBMesh
setups:
  Setup1: IcepakSteadyState Flow_Regime=Laminar Include_Temperature=true Include_Flow=true Include_Gravity Solution_Initialization_-_Z_Velocity=0.000980665m_per_sec Convergence_Criteria_-_Flow=0.001 Convergence_Criteria_-_Energy=1e-07 Convergence_Criteria_-_Discrete_Ordinates=1e-06 GPU_Convergence_Criteria_-_Flow=0.001 GPU_Convergence_Criteria_-_Energy=1e-05 GPU_Convergence_Criteria_-_Discrete_Ordinates=1e-05 Radiation_Model="Discrete Ordinates Model" Flow_Iteration_Per_Radiation_Iteration=10 Time_Step_Interval=1 ThetaDivision=2 PhiDivision=2 ThetaPixels=2 PhiPixels=2 Under-relaxation_-_Pressure=0.7 Under-relaxation_-_Momentum=0.3 Under-relaxation_-_Temperature=1 Under-relaxation_-_Body_Force=1 Discretization_Scheme_-_Pressure=Standard Discretization_Scheme_-_Momentum=First Discretization_Scheme_-_Temperature=First Discretization_Scheme_-_Discrete_Ordinates=First Convergence_Criteria_-_Max_Iterations=200
field plots:
  Temperature1: Temperature on Setup1 : SteadyState
  Temperature2: Temperature over a plane on Setup1 : SteadyState
