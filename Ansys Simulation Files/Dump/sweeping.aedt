# Ansys Electronics Desktop project, version 2025.1
materials:
  vacuum: permittivity=1
  copper: permeability=0.999991 conductivity=58000000
  ferrite: permittivity=12 permeability=2000 conductivity=0.01
  aluminum: permeability=1.000021 conductivity=38000000

design Edgewise_0.1 (Maxwell 3D, EddyCurrent, model units mm)
geometry:
  Np1, Np10, Np11, Np12, Np2..Np9, Ns1, Ns10, Ns11, Ns12, Ns2..Ns9 [copper] = imported_body(C:\Users\karlr\Documents\core_assembled_edgewise v2_0.1.step)
  Body1 [ferrite] = imported_body(C:\Users\karlr\Documents\core_assembled_edgewise v2_0.1.step)
  Body1_1, Body1_2 [aluminum] = imported_body(C:\Users\karlr\Documents\core_assembled_edgewise v2_0.1.step)
  Body1_3 [ferrite] = imported_body(C:\Users\karlr\Documents\core_assembled_edgewise v2_0.1.step)
  Body1_4, Body1_5 [aluminum] = imported_body(C:\Users\karlr\Documents\core_assembled_edgewise v2_0.1.step)
  Np1_Section1 [copper] = Np1.section(plane=ZX)
  Np2_Section1 [copper] = Np2.section(plane=ZX)
  Np3_Section1 [copper] = Np3.section(plane=ZX)
  Np4_Section1 [copper] = Np4.section(plane=ZX)
  Np5_Section1 [copper] = Np5.section(plane=ZX)
  Np6_Section1 [copper] = Np6.section(plane=ZX)
  Np7_Section1 [copper] = Np7.section(plane=ZX)
  Np8_Section1 [copper] = Np8.section(plane=ZX)
  Np9_Section1 [copper] = Np9.section(plane=ZX)
  Np10_Section1 [copper] = Np10.section(plane=ZX)
  Np11_Section1 [copper] = Np11.section(plane=ZX)
  Np12_Section1 [copper] = Np12.section(plane=ZX)
  Ns1_Section1 [copper] = Ns1.section(plane=ZX)
  Ns2_Section1 [copper] = Ns2.section(plane=ZX)
  Ns3_Section1 [copper] = Ns3.section(plane=ZX)
  Ns4_Section1 [copper] = Ns4.section(plane=ZX)
  Ns5_Section1 [copper] = Ns5.section(plane=ZX)
  Ns6_Section1 [copper] = Ns6.section(plane=ZX)
  Ns7_Section1 [copper] = Ns7.section(plane=ZX)
  Ns8_Section1 [copper] = Ns8.section(plane=ZX)
  Ns9_Section1 [copper] = Ns9.section(plane=ZX)
  Ns10_Section1 [copper] = Ns10.section(plane=ZX)
  Ns11_Section1 [copper] = Ns11.section(plane=ZX)
  Ns12_Section1 [copper] = Ns12.section(plane=ZX)
  Np1_Section1.separate_bodies()
  Np2_Section1.separate_bodies()
  Np3_Section1.separate_bodies()
  Np4_Section1.separate_bodies()
  Np5_Section1.separate_bodies()
  Np6_Section1.separate_bodies()
  Np7_Section1.separate_bodies()
  Np8_Section1.separate_bodies()
  Np9_Section1.separate_bodies()
  Np10_Section1.separate_bodies()
  Np11_Section1.separate_bodies()
  Np12_Section1.separate_bodies()
  Ns1_Section1.separate_bodies()
  Ns2_Section1.separate_bodies()
  Ns3_Section1.separate_bodies()
  Ns4_Section1.separate_bodies()
  Ns5_Section1.separate_bodies()
  Ns6_Section1.separate_bodies()
  Ns7_Section1.separate_bodies()
  Ns8_Section1.separate_bodies()
  Ns9_Section1.separate_bodies()
  Ns10_Section1.separate_bodies()
  Ns11_Section1.separate_bodies()
  Ns12_Section1.separate_bodies()
  Region [vacuum] = region(percentage_offset=0 on all sides)
  Rectangle1 [non-model] = rectangle(corner=(17.3mm, 6.1890426mm, 0mm), z_size=8.65mm, x_size=-17.3mm)
  group Primary = Np1, Np10, Np11, Np12, Np2..Np9, Np1_Section1, Np2_Section1, Np3_Section1, Np4_Section1, Np5_Section1, Np6_Section1, Np7_Section1, Np8_Section1, Np9_Section1, Np10_Section1, Np11_Section1, Np12_Section1
  group Secondary = Ns1, Ns10, Ns11, Ns12, Ns2..Ns9, Ns1_Section1, Ns2_Section1, Ns3_Section1, Ns4_Section1, Ns5_Section1, Ns6_Section1, Ns7_Section1, Ns8_Section1, Ns9_Section1, Ns10_Section1, Ns11_Section1, Ns12_Section1
  group Aluminum = Body1_1, Body1_2, Body1_4, Body1_5
  group Core = Body1, Body1_3
boundaries and excitations:
  CoilTerminal_1: Coil Terminal Objects=Ns1_Section1 Conductor_number=1 Winding=Secondary Point_out_of_terminal=true
  CoilTerminal_2: Coil Terminal Objects=Ns2_Section1 Conductor_number=1 Winding=Secondary Point_out_of_terminal=true
  CoilTerminal_3: Coil Terminal Objects=Ns3_Section1 Conductor_number=1 Winding=Secondary Point_out_of_terminal=true
  CoilTerminal_4: Coil Terminal Objects=Ns4_Section1 Conductor_number=1 Winding=Secondary Point_out_of_terminal=true
  CoilTerminal_5: Coil Terminal Objects=Ns5_Section1 Conductor_number=1 Winding=Secondary Point_out_of_terminal=true
  CoilTerminal_6: Coil Terminal Objects=Ns6_Section1 Conductor_number=1 Winding=Secondary Point_out_of_terminal=true
  CoilTerminal_7: Coil Terminal Objects=Ns7_Section1 Conductor_number=1 Winding=Secondary Point_out_of_terminal=true
  CoilTerminal_8: Coil Terminal Objects=Ns8_Section1 Conductor_number=1 Winding=Secondary Point_out_of_terminal=true
  CoilTerminal_9: Coil Terminal Objects=Ns9_Section1 Conductor_number=1 Winding=Secondary Point_out_of_terminal=true
  CoilTerminal_10: Coil Terminal Objects=Ns10_Section1 Conductor_number=1 Winding=Secondary Point_out_of_terminal=true
  CoilTerminal_11: Coil Terminal Objects=Ns11_Section1 Conductor_number=1 Winding=Secondary Point_out_of_terminal=true
  CoilTerminal_12: Coil Terminal Objects=Ns12_Section1 Conductor_number=1 Winding=Secondary Point_out_of_terminal=true
  CoilTerminal_13: Coil Terminal Objects=Np1_Section1 Conductor_number=1 Winding=Primary Point_out_of_terminal=false
  CoilTerminal_14: Coil Terminal Objects=Np2_Section1 Conductor_number=1 Winding=Primary Point_out_of_terminal=false
  CoilTerminal_15: Coil Terminal Objects=Np3_Section1 Conductor_number=1 Winding=Primary Point_out_of_terminal=false
  CoilTerminal_16: Coil Terminal Objects=Np4_Section1 Conductor_number=1 Winding=Primary Point_out_of_terminal=false
  CoilTerminal_17: Coil Terminal Objects=Np5_Section1 Conductor_number=1 Winding=Primary Point_out_of_terminal=false
  CoilTerminal_18: Coil Terminal Objects=Np6_Section1 Conductor_number=1 Winding=Primary Point_out_of_terminal=false
  CoilTerminal_19: Coil Terminal Objects=Np7_Section1 Conductor_number=1 Winding=Primary Point_out_of_terminal=false
  CoilTerminal_20: Coil Terminal Objects=Np8_Section1 Conductor_number=1 Winding=Primary Point_out_of_terminal=false
  CoilTerminal_21: Coil Terminal Objects=Np9_Section1 Conductor_number=1 Winding=Primary Point_out_of_terminal=false
  CoilTerminal_22: Coil Terminal Objects=Np10_Section1 Conductor_number=1 Winding=Primary Point_out_of_terminal=false
  CoilTerminal_23: Coil Terminal Objects=Np11_Section1 Conductor_number=1 Winding=Primary Point_out_of_terminal=false
  CoilTerminal_24: Coil Terminal Objects=Np12_Section1 Conductor_number=1 Winding=Primary Point_out_of_terminal=false
  Primary: Winding Group Type=Current IsSolid=true Current=5A ParallelBranchesNum=1 Phase=0deg
  Secondary: Winding Group Type=Current IsSolid=true Current=5A ParallelBranchesNum=1 Phase=0deg
parameters:
  Matrix1: Matrix Primary, Secondary:
mesh:
  Length2: LengthBased disabled Objects=[Body1, Body1_3, Body1_1, Body1_2, Body1_4, Body1_5] MaxLength=3.46mm
  Length4: LengthBased Objects=[Ns1..Ns12, Np1..Np8, Np10, Np9, Np11, Np12] MaxLength=2mm
  initial mesh: GlobalCurvilinear{Apply} MeshMethod=AnsoftClassic
setups:
  Setup1: EddyCurrent MaximumPasses=10 MinimumPasses=2 MinimumConvergedPasses=1 PercentRefinement=30 PercentError=2 SolveMatrixAtLast=false NonLinearResidual=0.0001 Frequency=30000Hz LossAdaptiveCtrl=0.5
field plots:
  Mag_B1, Mag_B2: B over a plane on Setup1 : LastAdaptive at Freq=30000Hz Phase=0deg
  Mag_E1: E over a plane on Setup1 : LastAdaptive at Freq=30000Hz Phase=0deg
  Mag_J1, Mag_J2: J over a plane on Setup1 : LastAdaptive at Freq=30000Hz Phase=0deg

design Flatwise_0.1 (Maxwell 3D, EddyCurrent, model units mm)
geometry:
  Np1, Np10, Np11, Np12, Np2..Np9, Ns1, Ns10, Ns11, Ns12, Ns2..Ns9 [copper] = imported_body(C:\Users\karlr\Documents\core_assembled_flatwise v2_0.1.step)
  Body1 [ferrite] = imported_body(C:\Users\karlr\Documents\core_assembled_flatwise v2_0.1.step)
  Body1_1, Body1_2 [aluminum] = imported_body(C:\Users\karlr\Documents\core_assembled_flatwise v2_0.1.step)
  Body1_3 [ferrite] = imported_body(C:\Users\karlr\Documents\core_assembled_flatwise v2_0.1.step)
  Body1_4, Body1_5 [aluminum] = imported_body(C:\Users\karlr\Documents\core_assembled_flatwise v2_0.1.step)
  Np1_Section1 = Np1.section(plane=ZX)
  Np2_Section1 = Np2.section(plane=ZX)
  Np3_Section1 = Np3.section(plane=ZX)
  Np4_Section1 = Np4.section(plane=ZX)
  Np5_Section1 = Np5.section(plane=ZX)
  Np6_Section1 = Np6.section(plane=ZX)
  Np7_Section1 = Np7.section(plane=ZX)
  Np8_Section1 = Np8.section(plane=ZX)
  Np9_Section1 = Np9.section(plane=ZX)
  Np10_Section1 = Np10.section(plane=ZX)
  Np11_Section1 = Np11.section(plane=ZX)
  Np12_Section1 = Np12.section(plane=ZX)
  Ns1_Section1 = Ns1.section(plane=ZX)
  Ns2_Section1 = Ns2.section(plane=ZX)
  Ns3_Section1 = Ns3.section(plane=ZX)
  Ns4_Section1 = Ns4.section(plane=ZX)
  Ns5_Section1 = Ns5.section(plane=ZX)
  Ns6_Section1 = Ns6.section(plane=ZX)
  Ns7_Section1 = Ns7.section(plane=ZX)
  Ns8_Section1 = Ns8.section(plane=ZX)
  Ns9_Section1 = Ns9.section(plane=ZX)
  Ns10_Section1 = Ns10.section(plane=ZX)
  Ns11_Section1 = Ns11.section(plane=ZX)
  Ns12_Section1 = Ns12.section(plane=ZX)
  Np1_Section1.separate_bodies()
  Np2_Section1.separate_bodies()
  Np3_Section1.separate_bodies()
  Np4_Section1.separate_bodies()
  Np5_Section1.separate_bodies()
  Np6_Section1.separate_bodies()
  Np7_Section1.separate_bodies()
  Np8_Section1.separate_bodies()
  Np9_Section1.separate_bodies()
  Np10_Section1.separate_bodies()
  Np11_Section1.separate_bodies()
  Np12_Section1.separate_bodies()
  Ns1_Section1.separate_bodies()
  Ns2_Section1.separate_bodies()
  Ns3_Section1.separate_bodies()
  Ns4_Section1.separate_bodies()
  Ns5_Section1.separate_bodies()
  Ns6_Section1.separate_bodies()
  Ns7_Section1.separate_bodies()
  Ns8_Section1.separate_bodies()
  Ns9_Section1.separate_bodies()
  Ns10_Section1.separate_bodies()
  Ns11_Section1.separate_bodies()
  Ns12_Section1_Separate1 = Ns12_Section1.separate_bodies()
  Ns12_Section1.delete()
  Region [vacuum] = region(percentage_offset=0 on all sides)
  Rectangle1 [non-model] = rectangle(corner=(17.3mm, 6.1890426mm, 0mm), z_size=8.65mm, x_size=-17.3mm)
  group Aluminum = Body1_1, Body1_2, Body1_4, Body1_5
  group Core = Body1, Body1_3
  group primary = Np1, Np10, Np11, Np12, Np2..Np9, Np1_Section1, Np2_Section1, Np3_Section1, Np4_Section1, Np5_Section1, Np6_Section1, Np7_Section1, Np8_Section1, Np9_Section1, Np10_Section1, Np11_Section1, Np12_Section1
  group secondary = Ns1, Ns10, Ns11, Ns12, Ns2..Ns9, Ns1_Section1, Ns2_Section1, Ns3_Section1, Ns4_Section1, Ns5_Section1, Ns6_Section1, Ns7_Section1, Ns8_Section1, Ns9_Section1, Ns10_Section1, Ns11_Section1, Ns12_Section1_Separate1
boundaries and excitations:
  Np_1: Coil Terminal Objects=Np1_Section1 Conductor_number=1 Winding=Primary Point_out_of_terminal=false
  Np_2: Coil Terminal Objects=Np2_Section1 Conductor_number=1 Winding=Primary Point_out_of_terminal=false
  Np_3: Coil Terminal Objects=Np3_Section1 Conductor_number=1 Winding=Primary Point_out_of_terminal=false
  Np_4: Coil Terminal Objects=Np4_Section1 Conductor_number=1 Winding=Primary Point_out_of_terminal=false
  Np_5: Coil Terminal Objects=Np5_Section1 Conductor_number=1 Winding=Primary Point_out_of_terminal=false
  Np_6: Coil Terminal Objects=Np6_Section1 Conductor_number=1 Winding=Primary Point_out_of_terminal=false
  Np_7: Coil Terminal Objects=Np7_Section1 Conductor_number=1 Winding=Primary Point_out_of_terminal=false
  Np_8: Coil Terminal Objects=Np8_Section1 Conductor_number=1 Winding=Primary Point_out_of_terminal=false
  Np_9: Coil Terminal Objects=Np9_Section1 Conductor_number=1 Winding=Primary Point_out_of_terminal=false
  Np_10: Coil Terminal Objects=Np10_Section1 Conductor_number=1 Winding=Primary Point_out_of_terminal=false
  Np_11: Coil Terminal Objects=Np11_Section1 Conductor_number=1 Winding=Primary Point_out_of_terminal=false
  Np_12: Coil Terminal Objects=Np12_Section1 Conductor_number=1 Winding=Primary Point_out_of_terminal=false
  Ns_1: Coil Terminal Objects=Ns12_Section1_Separate1 Conductor_number=1 Winding=Secondary Point_out_of_terminal=true
  Ns_2: Coil Terminal Objects=Ns1_Section1 Conductor_number=1 Winding=Secondary Point_out_of_terminal=true
  Ns_3: Coil Terminal Objects=Ns2_Section1 Conductor_number=1 Winding=Secondary Point_out_of_terminal=true
  Ns_4: Coil Terminal Objects=Ns3_Section1 Conductor_number=1 Winding=Secondary Point_out_of_terminal=true
  Ns_5: Coil Terminal Objects=Ns4_Section1 Conductor_number=1 Winding=Secondary Point_out_of_terminal=true
  Ns_6: Coil Terminal Objects=Ns5_Section1 Conductor_number=1 Winding=Secondary Point_out_of_terminal=true
  Ns_7: Coil Terminal Objects=Ns6_Section1 Conductor_number=1 Winding=Secondary Point_out_of_terminal=true
  Ns_8: Coil Terminal Objects=Ns7_Section1 Conductor_number=1 Winding=Secondary Point_out_of_terminal=true
  Ns_9: Coil Terminal Objects=Ns8_Section1 Conductor_number=1 Winding=Secondary Point_out_of_terminal=true
  Ns_10: Coil Terminal Objects=Ns9_Section1 Conductor_number=1 Winding=Secondary Point_out_of_terminal=true
  Ns_11: Coil Terminal Objects=Ns10_Section1 Conductor_number=1 Winding=Secondary Point_out_of_terminal=true
  Ns_12: Coil Terminal Objects=Ns11_Section1 Conductor_number=1 Winding=Secondary Point_out_of_terminal=true
  Primary: Winding Group Type=Current IsSolid=true Current=5A ParallelBranchesNum=1 Phase=0deg
  Secondary: Winding Group Type=Current IsSolid=true Current=5A ParallelBranchesNum=1 Phase=0deg
parameters:
  Matrix1: Matrix Primary, Secondary:
mesh:
  Length2: LengthBased Objects=[Body1_3, Body1_1, Body1_2, Body1_4, Body1_5, Body1] MaxLength=3.46mm
  Length4: LengthBased Objects=[Ns1..Ns12, Np1, Np12, Np2, Np3, Np10, Np11, Np9, Np8, Np7, Np6, Np5, Np4] MaxLength=2mm
  initial mesh: GlobalCurvilinear{Apply} MeshMethod=AnsoftClassic
setups:
  Setup1: EddyCurrent MaximumPasses=10 MinimumPasses=2 MinimumConvergedPasses=1 PercentRefinement=30 PercentError=2 SolveMatrixAtLast=false NonLinearResidual=0.0001 Frequency=30000Hz LossAdaptiveCtrl=0.5
field plots:
  Mag_J1: J over a plane on Setup1 : LastAdaptive at Freq=30000Hz Phase=0deg

design Edgewise_5A (Maxwell 2D, EddyCurrent, XY geometry, model units mm)
options: ModelDepth=19.678mm
geometry:
  Np1, Np10, Np11, Np12, Np2..Np9, Ns1, Ns10, Ns11, Ns12, Ns2..Ns9, Body1, Body1_3 = imported_body(C:\Users\karlr\Documents\core_assembled_edgewise v2_0.1.step)
  Np1_Section1 [copper] = Np1.section(plane=ZX)
  Np1.delete()
  Np10_Section1 [copper] = Np10.section(plane=ZX)
  Np10.delete()
  Np11_Section1 [copper] = Np11.section(plane=ZX)
  Np11.delete()
  Np12_Section1 [copper] = Np12.section(plane=ZX)
  Np12.delete()
  Np2_Section1 [copper] = Np2.section(plane=ZX)
  Np2.delete()
  Np3_Section1 [copper] = Np3.section(plane=ZX)
  Np3.delete()
  Np4_Section1 [copper] = Np4.section(plane=ZX)
  Np4.delete()
  Np5_Section1 [copper] = Np5.section(plane=ZX)
  Np5.delete()
  Np6_Section1 [copper] = Np6.section(plane=ZX)
  Np6.delete()
  Np7_Section1 [copper] = Np7.section(plane=ZX)
  Np7.delete()
  Np8_Section1 [copper] = Np8.section(plane=ZX)
  Np8.delete()
  Np9_Section1 [copper] = Np9.section(plane=ZX)
  Np9.delete()
  Ns1_Section1 [copper] = Ns1.section(plane=ZX)
  Ns1.delete()
  Ns10_Section1 [copper] = Ns10.section(plane=ZX)
  Ns10.delete()
  Ns11_Section1 [copper] = Ns11.section(plane=ZX)
  Ns11.delete()
  Ns12_Section1 [copper] = Ns12.section(plane=ZX)
  Ns12.delete()
  Ns2_Section1 [copper] = Ns2.section(plane=ZX)
  Ns2.delete()
  Ns3_Section1 [copper] = Ns3.section(plane=ZX)
  Ns3.delete()
  Ns4_Section1 [copper] = Ns4.section(plane=ZX)
  Ns4.delete()
  Ns5_Section1 [copper] = Ns5.section(plane=ZX)
  Ns5.delete()
  Ns6_Section1 [copper] = Ns6.section(plane=ZX)
  Ns6.delete()
  Ns7_Section1 [copper] = Ns7.section(plane=ZX)
  Ns7.delete()
  Ns8_Section1 [copper] = Ns8.section(plane=ZX)
  Ns8.delete()
  Ns9_Section1 [copper] = Ns9.section(plane=ZX)
  Ns9.delete()
  Body1_Section1 [ferrite] = Body1.section(plane=ZX)
  Body1.delete()
  Body1_3_Section1 [ferrite] = Body1_3.section(plane=ZX)
  Body1_3.delete()
  Np1_Section1_Separate1 [copper] = Np1_Section1.separate_bodies()
  Np2_Section1_Separate1 [copper] = Np2_Section1.separate_bodies()
  Np3_Section1_Separate1 [copper] = Np3_Section1.separate_bodies()
  Np4_Section1_Separate1 [copper] = Np4_Section1.separate_bodies()
  Np5_Section1_Separate1 [copper] = Np5_Section1.separate_bodies()
  Np6_Section1_Separate1 [copper] = Np6_Section1.separate_bodies()
  Np7_Section1_Separate1 [copper] = Np7_Section1.separate_bodies()
  Np8_Section1_Separate1 [copper] = Np8_Section1.separate_bodies()
  Np9_Section1_Separate1 [copper] = Np9_Section1.separate_bodies()
  Np10_Section1_Separate1 [copper] = Np10_Section1.separate_bodies()
  Np11_Section1_Separate1 [copper] = Np11_Section1.separate_bodies()
  Np12_Section1_Separate1 [copper] = Np12_Section1.separate_bodies()
  Ns1_Section1_Separate1 [copper] = Ns1_Section1.separate_bodies()
  Ns2_Section1_Separate1 [copper] = Ns2_Section1.separate_bodies()
  Ns3_Section1_Separate1 [copper] = Ns3_Section1.separate_bodies()
  Ns4_Section1_Separate1 [copper] = Ns4_Section1.separate_bodies()
  Ns5_Section1_Separate1 [copper] = Ns5_Section1.separate_bodies()
  Ns6_Section1_Separate1 [copper] = Ns6_Section1.separate_bodies()
  Ns7_Section1_Separate1 [copper] = Ns7_Section1.separate_bodies()
  Ns8_Section1_Separate1 [copper] = Ns8_Section1.separate_bodies()
  Ns9_Section1_Separate1 [copper] = Ns9_Section1.separate_bodies()
  Ns10_Section1_Separate1 [copper] = Ns10_Section1.separate_bodies()
  Ns11_Section1_Separate1 [copper] = Ns11_Section1.separate_bodies()
  Ns12_Section1_Separate1 [copper] = Ns12_Section1.separate_bodies()
  [Np1_Section1, Np10_Section1, Np11_Section1, Np12_Section1, Np2_Section1, Np3_Section1, Np4_Section1, Np5_Section1, Np6_Section1, Np7_Section1, Np8_Section1, Np9_Section1, Ns1_Section1, Ns10_Section1, Ns11_Section1, Ns12_Section1, Ns2_Section1, Ns3_Section1, Ns4_Section1, Ns5_Section1, Ns6_Section1, Ns7_Section1, Ns8_Section1, Ns9_Section1, Body1_Section1, Body1_3_Section1, Np1_Section1_Separate1, Np2_Section1_Separate1, Np3_Section1_Separate1, Np4_Section1_Separate1, Np5_Section1_Separate1, Np6_Section1_Separate1, Np7_Section1_Separate1, Np8_Section1_Separate1, Np9_Section1_Separate1, Np10_Section1_Separate1, Np11_Section1_Separate1, Np12_Section1_Separate1, Ns1_Section1_Separate1, Ns2_Section1_Separate1, Ns3_Section1_Separate1, Ns4_Section1_Separate1, Ns5_Section1_Separate1, Ns6_Section1_Separate1, Ns7_Section1_Separate1, Ns8_Section1_Separate1, Ns9_Section1_Separate1, Ns10_Section1_Separate1, Ns11_Section1_Separate1, Ns12_Section1_Separate1].move(-8.65mm, 0mm, 0mm)
  [Np1_Section1, Np10_Section1, Np11_Section1, Np12_Section1, Np2_Section1, Np3_Section1, Np4_Section1, Np5_Section1, Np6_Section1, Np7_Section1, Np8_Section1, Np9_Section1, Ns1_Section1, Ns10_Section1, Ns11_Section1, Ns12_Section1, Ns2_Section1, Ns3_Section1, Ns4_Section1, Ns5_Section1, Ns6_Section1, Ns7_Section1, Ns8_Section1, Ns9_Section1, Body1_Section1, Body1_3_Section1, Np1_Section1_Separate1, Np2_Section1_Separate1, Np3_Section1_Separate1, Np4_Section1_Separate1, Np5_Section1_Separate1, Np6_Section1_Separate1, Np7_Section1_Separate1, Np8_Section1_Separate1, Np9_Section1_Separate1, Np10_Section1_Separate1, Np11_Section1_Separate1, Np12_Section1_Separate1, Ns1_Section1_Separate1, Ns2_Section1_Separate1, Ns3_Section1_Separate1, Ns4_Section1_Separate1, Ns5_Section1_Separate1, Ns6_Section1_Separate1, Ns7_Section1_Separate1, Ns8_Section1_Separate1, Ns9_Section1_Separate1, Ns10_Section1_Separate1, Ns11_Section1_Separate1, Ns12_Section1_Separate1].rotate(axis=Z, angle=90deg)
  [Np1_Section1, Np10_Section1, Np11_Section1, Np12_Section1, Np2_Section1, Np3_Section1, Np4_Section1, Np5_Section1, Np6_Section1, Np7_Section1, Np8_Section1, Np9_Section1, Ns1_Section1, Ns10_Section1, Ns11_Section1, Ns12_Section1, Ns2_Section1, Ns3_Section1, Ns4_Section1, Ns5_Section1, Ns6_Section1, Ns7_Section1, Ns8_Section1, Ns9_Section1, Body1_Section1, Body1_3_Section1, Np1_Section1_Separate1, Np2_Section1_Separate1, Np3_Section1_Separate1, Np4_Section1_Separate1, Np5_Section1_Separate1, Np6_Section1_Separate1, Np7_Section1_Separate1, Np8_Section1_Separate1, Np9_Section1_Separate1, Np10_Section1_Separate1, Np11_Section1_Separate1, Np12_Section1_Separate1, Ns1_Section1_Separate1, Ns2_Section1_Separate1, Ns3_Section1_Separate1, Ns4_Section1_Separate1, Ns5_Section1_Separate1, Ns6_Section1_Separate1, Ns7_Section1_Separate1, Ns8_Section1_Separate1, Ns9_Section1_Separate1, Ns10_Section1_Separate1, Ns11_Section1_Separate1, Ns12_Section1_Separate1].rotate(axis=Y, angle=90deg)
  [Np1_Section1, Np10_Section1, Np11_Section1, Np12_Section1, Np2_Section1, Np3_Section1, Np4_Section1, Np5_Section1, Np6_Section1, Np7_Section1, Np8_Section1, Np9_Section1, Ns1_Section1, Ns10_Section1, Ns11_Section1, Ns12_Section1, Ns2_Section1, Ns3_Section1, Ns4_Section1, Ns5_Section1, Ns6_Section1, Ns7_Section1, Ns8_Section1, Ns9_Section1, Body1_Section1, Body1_3_Section1, Np1_Section1_Separate1, Np2_Section1_Separate1, Np3_Section1_Separate1, Np4_Section1_Separate1, Np5_Section1_Separate1, Np6_Section1_Separate1, Np7_Section1_Separate1, Np8_Section1_Separate1, Np9_Section1_Separate1, Np10_Section1_Separate1, Np11_Section1_Separate1, Np12_Section1_Separate1, Ns1_Section1_Separate1, Ns2_Section1_Separate1, Ns3_Section1_Separate1, Ns4_Section1_Separate1, Ns5_Section1_Separate1, Ns6_Section1_Separate1, Ns7_Section1_Separate1, Ns8_Section1_Separate1, Ns9_Section1_Separate1, Ns10_Section1_Separate1, Ns11_Section1_Separate1, Ns12_Section1_Separate1].move(-4.275mm, 0mm, 0mm)
  Region [vacuum] = region(percentage_offset=0 on all sides)
  group core_assembled_edgewise = Np1_Section1, Np10_Section1, Np11_Section1, Np12_Section1, Np2_Section1, Np3_Section1, Np4_Section1, Np5_Section1, Np6_Section1, Np7_Section1, Np8_Section1, Np9_Section1, Ns1_Section1, Ns10_Section1, Ns11_Section1, Ns12_Section1, Ns2_Section1, Ns3_Section1, Ns4_Section1, Ns5_Section1, Ns6_Section1, Ns7_Section1, Ns8_Section1, Ns9_Section1, Np1_Section1_Separate1, Np2_Section1_Separate1, Np3_Section1_Separate1, Np4_Section1_Separate1, Np5_Section1_Separate1, Np6_Section1_Separate1, Np7_Section1_Separate1, Np8_Section1_Separate1, Np9_Section1_Separate1, Np10_Section1_Separate1, Np11_Section1_Separate1, Np12_Section1_Separate1, Ns1_Section1_Separate1, Ns2_Section1_Separate1, Ns3_Section1_Separate1, Ns4_Section1_Separate1, Ns5_Section1_Separate1, Ns6_Section1_Separate1, Ns7_Section1_Separate1, Ns8_Section1_Separate1, Ns9_Section1_Separate1, Ns10_Section1_Separate1, Ns11_Section1_Separate1, Ns12_Section1_Separate1
  group core_together_1 = Body1_Section1
  group core_together = Body1_3_Section1
boundaries and excitations:
  Balloon1: Balloon Edges=Region.edge(all 4)
  Np1_Section1: Coil Objects=Np1_Section1 Conductor_number=1 Winding=Primary PolarityType=Positive
  Np2_Section1: Coil Objects=Np2_Section1 Conductor_number=1 Winding=Primary PolarityType=Positive
  Np3_Section1: Coil Objects=Np3_Section1 Conductor_number=1 Winding=Primary PolarityType=Positive
  Np4_Section1: Coil Objects=Np4_Section1 Conductor_number=1 Winding=Primary PolarityType=Positive
  Np5_Section1: Coil Objects=Np5_Section1 Conductor_number=1 Winding=Primary PolarityType=Positive
  Np6_Section1: Coil Objects=Np6_Section1 Conductor_number=1 Winding=Primary PolarityType=Positive
  Np7_Section1: Coil Objects=Np7_Section1 Conductor_number=1 Winding=Primary PolarityType=Positive
  Np8_Section1: Coil Objects=Np8_Section1 Conductor_number=1 Winding=Primary PolarityType=Positive
  Np9_Section1: Coil Objects=Np9_Section1 Conductor_number=1 Winding=Primary PolarityType=Positive
  Np10_Section1: Coil Objects=Np10_Section1 Conductor_number=1 Winding=Primary PolarityType=Positive
  Np11_Section1: Coil Objects=Np11_Section1 Conductor_number=1 Winding=Primary PolarityType=Positive
  Np12_Section1: Coil Objects=Np12_Section1 Conductor_number=1 Winding=Primary PolarityType=Positive
  Np1_Section1_Separate1: Coil Objects=Np1_Section1_Separate1 Conductor_number=1 Winding=Primary PolarityType=Negative
  Np2_Section1_Separate1: Coil Objects=Np2_Section1_Separate1 Conductor_number=1 Winding=Primary PolarityType=Negative
  Np3_Section1_Separate1: Coil Objects=Np3_Section1_Separate1 Conductor_number=1 Winding=Primary PolarityType=Negative
  Np4_Section1_Separate1: Coil Objects=Np4_Section1_Separate1 Conductor_number=1 Winding=Primary PolarityType=Negative
  Np5_Section1_Separate1: Coil Objects=Np5_Section1_Separate1 Conductor_number=1 Winding=Primary PolarityType=Negative
  Np6_Section1_Separate1: Coil Objects=Np6_Section1_Separate1 Conductor_number=1 Winding=Primary PolarityType=Negative
  Np7_Section1_Separate1: Coil Objects=Np7_Section1_Separate1 Conductor_number=1 Winding=Primary PolarityType=Negative
  Np8_Section1_Separate1: Coil Objects=Np8_Section1_Separate1 Conductor_number=1 Winding=Primary PolarityType=Negative
  Np9_Section1_Separate1: Coil Objects=Np9_Section1_Separate1 Conductor_number=1 Winding=Primary PolarityType=Negative
  Np10_Section1_Separate1: Coil Objects=Np10_Section1_Separate1 Conductor_number=1 Winding=Primary PolarityType=Negative
  Np11_Section1_Separate1: Coil Objects=Np11_Section1_Separate1 Conductor_number=1 Winding=Primary PolarityType=Negative
  Np12_Section1_Separate1: Coil Objects=Np12_Section1_Separate1 Conductor_number=1 Winding=Primary PolarityType=Negative
  Ns2_Section1: Coil Objects=Ns2_Section1 Conductor_number=1 Winding=Secondary PolarityType=Negative
  Ns1_Section1: Coil Objects=Ns1_Section1 Conductor_number=1 Winding=Secondary PolarityType=Negative
  Ns3_Section1: Coil Objects=Ns3_Section1 Conductor_number=1 Winding=Secondary PolarityType=Negative
  Ns4_Section1: Coil Objects=Ns4_Section1 Conductor_number=1 Winding=Secondary PolarityType=Negative
  Ns5_Section1: Coil Objects=Ns5_Section1 Conductor_number=1 Winding=Secondary PolarityType=Negative
  Ns6_Section1: Coil Objects=Ns6_Section1 Conductor_number=1 Winding=Secondary PolarityType=Negative
  Ns7_Section1: Coil Objects=Ns7_Section1 Conductor_number=1 Winding=Secondary PolarityType=Negative
  Ns8_Section1: Coil Objects=Ns8_Section1 Conductor_number=1 Winding=Secondary PolarityType=Negative
  Ns9_Section1: Coil Objects=Ns9_Section1 Conductor_number=1 Winding=Secondary PolarityType=Negative
  Ns10_Section1: Coil Objects=Ns10_Section1 Conductor_number=1 Winding=Secondary PolarityType=Negative
  Ns11_Section1: Coil Objects=Ns11_Section1 Conductor_number=1 Winding=Secondary PolarityType=Negative
  Ns12_Section1: Coil Objects=Ns12_Section1 Conductor_number=1 Winding=Secondary PolarityType=Negative
  Ns11_Section1_Separate1: Coil Objects=Ns11_Section1_Separate1 Conductor_number=1 Winding=Secondary PolarityType=Positive
  Ns12_Section1_Separate1: Coil Objects=Ns12_Section1_Separate1 Conductor_number=1 Winding=Secondary PolarityType=Positive
  Ns10_Section1_Separate1: Coil Objects=Ns10_Section1_Separate1 Conductor_number=1 Winding=Secondary PolarityType=Positive
  Ns9_Section1_Separate1: Coil Objects=Ns9_Section1_Separate1 Conductor_number=1 Winding=Secondary PolarityType=Positive
  Ns8_Section1_Separate1: Coil Objects=Ns8_Section1_Separate1 Conductor_number=1 Winding=Secondary PolarityType=Positive
  Ns7_Section1_Separate1: Coil Objects=Ns7_Section1_Separate1 Conductor_number=1 Winding=Secondary PolarityType=Positive
  Ns6_Section1_Separate1: Coil Objects=Ns6_Section1_Separate1 Conductor_number=1 Winding=Secondary PolarityType=Positive
  Ns5_Section1_Separate1: Coil Objects=Ns5_Section1_Separate1 Conductor_number=1 Winding=Secondary PolarityType=Positive
  Ns4_Section1_Separate1: Coil Objects=Ns4_Section1_Separate1 Conductor_number=1 Winding=Secondary PolarityType=Positive
  Ns3_Section1_Separate1: Coil Objects=Ns3_Section1_Separate1 Conductor_number=1 Winding=Secondary PolarityType=Positive
  Ns2_Section1_Separate1: Coil Objects=Ns2_Section1_Separate1 Conductor_number=1 Winding=Secondary PolarityType=Positive
  Ns1_Section1_Separate1: Coil Objects=Ns1_Section1_Separate1 Conductor_number=1 Winding=Secondary PolarityType=Positive
  Primary: Winding Group Type=Current IsSolid=true Current=5A ParallelBranchesNum=1 Phase=0deg
  Secondary: Winding Group Type=Current IsSolid=true Current=5A ParallelBranchesNum=1 Phase=0deg
parameters:
  Matrix1: Matrix Primary, Secondary:
mesh:
  Length1: LengthBased RefineInside Objects=[Body1_Section1, Body1_3_Section1] MaxLength=3.46mm
  Length2: LengthBased RefineInside Objects=Np10_Section1_Separate1 MaxLength=0.2mm
setups:
  Setup1: EddyCurrent MaximumPasses=10 MinimumPasses=2 MinimumConvergedPasses=1 PercentRefinement=30 PercentError=1 NonLinearResidual=0.0001 Frequency=30000Hz SweepRanges{10Hz to 50000Hz step 1000Hz} SaveAllFields
field plots:
  JAtPhase1: J over Ns12_Section1_Separate1, Np1_Section1, Np1_Section1_Separate1, Np2_Section1, Np2_Section1_Separate1, Np3_Section1, Np3_Section1_Separate1, Np4_Section1, Np4_Section1_Separate1, Np5_Section1, Np5_Section1_Separate1, Np6_Section1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 on Setup1 : LastAdaptive at Freq=30000Hz Phase=0deg
  JAtPhase2: J over Np1_Section1, Np1_Section1_Separate1, Np2_Section1, Np2_Section1_Separate1, Np3_Section1, Np3_Section1_Separate1, Np4_Section1, Np4_Section1_Separate1, Np5_Section1, Np5_Section1_Separate1, Np6_Section1, Np6_Section1_Separate1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 on Setup1 : LastAdaptive at Freq=30000Hz Phase=0deg
reports:
  Loss Plot1: CoreLoss vs Freq on Setup1 : LastAdaptive
  Loss Plot2: SolidLoss vs Freq on Setup1 : LastAdaptive

design Flatwise_5A (Maxwell 2D, EddyCurrent, XY geometry, model units mm)
options: ModelDepth=19.678mm
geometry:
  Np1#3477, Np10#3529, Np11#3581, Np12#3633, Np2#3685, Np3#3737, Np4#3789, Np5#3841, Np6#3893, Np7#3945, Np8#3997, Np9#4049, Ns1#4101, Ns10#4153, Ns11#4205, Ns12#4257, Ns2#4309, Ns3#4361, Ns4#4413, Ns5#4465, Ns6#4517, Ns7#4569, Ns8#4621, Ns9#4673, Body1#5977, Body1_3#6157 = imported_body(C:\Users\karlr\Documents\core_assembled_flatwise v2_0.1.step)
  Region [vacuum] = region(percentage_offset=0 on all sides)
  Np1 [copper] = Np1#3477.section(plane=ZX)
  Np1#3477.delete()
  Np1.rotate(axis=X, angle=-90deg)
  Np10 [copper] = Np10#3529.section(plane=ZX)
  Np10#3529.delete()
  Np10.rotate(axis=X, angle=-90deg)
  Np11 [copper] = Np11#3581.section(plane=ZX)
  Np11#3581.delete()
  Np11.rotate(axis=X, angle=-90deg)
  Np12 [copper] = Np12#3633.section(plane=ZX)
  Np12#3633.delete()
  Np12.rotate(axis=X, angle=-90deg)
  Np2 [copper] = Np2#3685.section(plane=ZX)
  Np2#3685.delete()
  Np2.rotate(axis=X, angle=-90deg)
  Np3 [copper] = Np3#3737.section(plane=ZX)
  Np3#3737.delete()
  Np3.rotate(axis=X, angle=-90deg)
  Np4 [copper] = Np4#3789.section(plane=ZX)
  Np4#3789.delete()
  Np4.rotate(axis=X, angle=-90deg)
  Np5 [copper] = Np5#3841.section(plane=ZX)
  Np5#3841.delete()
  Np5.rotate(axis=X, angle=-90deg)
  Np6 [copper] = Np6#3893.section(plane=ZX)
  Np6#3893.delete()
  Np6.rotate(axis=X, angle=-90deg)
  Np7 [copper] = Np7#3945.section(plane=ZX)
  Np7#3945.delete()
  Np7.rotate(axis=X, angle=-90deg)
  Np8 [copper] = Np8#3997.section(plane=ZX)
  Np8#3997.delete()
  Np8.rotate(axis=X, angle=-90deg)
  Np9 [copper] = Np9#4049.section(plane=ZX)
  Np9#4049.delete()
  Np9.rotate(axis=X, angle=-90deg)
  Ns1 [copper] = Ns1#4101.section(plane=ZX)
  Ns1#4101.delete()
  Ns1.rotate(axis=X, angle=-90deg)
  Ns10 [copper] = Ns10#4153.section(plane=ZX)
  Ns10#4153.delete()
  Ns10.rotate(axis=X, angle=-90deg)
  Ns11 [copper] = Ns11#4205.section(plane=ZX)
  Ns11#4205.delete()
  Ns11.rotate(axis=X, angle=-90deg)
  Ns12 [copper] = Ns12#4257.section(plane=ZX)
  Ns12#4257.delete()
  Ns12.rotate(axis=X, angle=-90deg)
  Ns2 [copper] = Ns2#4309.section(plane=ZX)
  Ns2#4309.delete()
  Ns2.rotate(axis=X, angle=-90deg)
  Ns3 [copper] = Ns3#4361.section(plane=ZX)
  Ns3#4361.delete()
  Ns3.rotate(axis=X, angle=-90deg)
  Ns4 [copper] = Ns4#4413.section(plane=ZX)
  Ns4#4413.delete()
  Ns4.rotate(axis=X, angle=-90deg)
  Ns5 [copper] = Ns5#4465.section(plane=ZX)
  Ns5#4465.delete()
  Ns5.rotate(axis=X, angle=-90deg)
  Ns6 [copper] = Ns6#4517.section(plane=ZX)
  Ns6#4517.delete()
  Ns6.rotate(axis=X, angle=-90deg)
  Ns7 [copper] = Ns7#4569.section(plane=ZX)
  Ns7#4569.delete()
  Ns7.rotate(axis=X, angle=-90deg)
  Ns8 [copper] = Ns8#4621.section(plane=ZX)
  Ns8#4621.delete()
  Ns8.rotate(axis=X, angle=-90deg)
  Ns9 [copper] = Ns9#4673.section(plane=ZX)
  Ns9#4673.delete()
  Ns9.rotate(axis=X, angle=-90deg)
  Body1 [ferrite] = Body1#5977.section(plane=ZX)
  Body1#5977.delete()
  Body1.rotate(axis=X, angle=-90deg)
  Body1_3 [ferrite] = Body1_3#6157.section(plane=ZX)
  Body1_3#6157.delete()
  Body1_3.rotate(axis=X, angle=-90deg)
  [Np1, Np10, Np11, Np12, Np2..Np9, Ns1, Ns10, Ns11, Ns12, Ns2..Ns9, Body1, Body1_3].move(-8.65mm, -4.275mm, 0mm)
  Np1_Separate1 [copper] = Np1.separate_bodies()
  Np2_Separate1 [copper] = Np2.separate_bodies()
  Np3_Separate1 [copper] = Np3.separate_bodies()
  Np4_Separate1 [copper] = Np4.separate_bodies()
  Np5_Separate1 [copper] = Np5.separate_bodies()
  Np6_Separate1 [copper] = Np6.separate_bodies()
  Np7_Separate1 [copper] = Np7.separate_bodies()
  Np8_Separate1 [copper] = Np8.separate_bodies()
  Np9_Separate1 [copper] = Np9.separate_bodies()
  Np10_Separate1 [copper] = Np10.separate_bodies()
  Np11_Separate1 [copper] = Np11.separate_bodies()
  Np12_Separate1 [copper] = Np12.separate_bodies()
  Ns1_Separate1 [copper] = Ns1.separate_bodies()
  Ns2_Separate1 [copper] = Ns2.separate_bodies()
  Ns3_Separate1 [copper] = Ns3.separate_bodies()
  Ns4_Separate1 [copper] = Ns4.separate_bodies()
  Ns5_Separate1 [copper] = Ns5.separate_bodies()
  Ns6_Separate1 [copper] = Ns6.separate_bodies()
  Ns7_Separate1 [copper] = Ns7.separate_bodies()
  Ns8_Separate1 [copper] = Ns8.separate_bodies()
  Ns9_Separate1 [copper] = Ns9.separate_bodies()
  Ns10_Separate1 [copper] = Ns10.separate_bodies()
  Ns11_Separate1 [copper] = Ns11.separate_bodies()
  Ns12_Separate1 [copper] = Ns12.separate_bodies()
  group Core = Body1, Body1_3
  group primary = Np1, Np10, Np11, Np12, Np2..Np9, Np1_Separate1, Np2_Separate1, Np3_Separate1, Np4_Separate1, Np5_Separate1, Np6_Separate1, Np7_Separate1, Np8_Separate1, Np9_Separate1, Np10_Separate1, Np11_Separate1, Np12_Separate1
  group secondary = Ns1, Ns10, Ns11, Ns12, Ns2..Ns9, Ns1_Separate1, Ns2_Separate1, Ns3_Separate1, Ns4_Separate1, Ns5_Separate1, Ns6_Separate1, Ns7_Separate1, Ns8_Separate1, Ns9_Separate1, Ns10_Separate1, Ns11_Separate1, Ns12_Separate1
boundaries and excitations:
  Balloon1: Balloon Edges=Region.edge(all 4)
  Current_1: Current Objects=Np1 Phase=0deg Current=5A IsSolid=true IsPositive=true
  Current_2: Current Objects=Np2 Phase=0deg Current=5A IsSolid=true IsPositive=true
  Current_3: Current Objects=Np3 Phase=0deg Current=5A IsSolid=true IsPositive=true
  Current_4: Current Objects=Np4 Phase=0deg Current=5A IsSolid=true IsPositive=true
  Current_5: Current Objects=Np5 Phase=0deg Current=5A IsSolid=true IsPositive=true
  Current_6: Current Objects=Np6 Phase=0deg Current=5A IsSolid=true IsPositive=true
  Current_7: Current Objects=Np7 Phase=0deg Current=5A IsSolid=true IsPositive=true
  Current_8: Current Objects=Np8 Phase=0deg Current=5A IsSolid=true IsPositive=true
  Current_9: Current Objects=Np9 Phase=0deg Current=5A IsSolid=true IsPositive=true
  Current_10: Current Objects=Np10 Phase=0deg Current=5A IsSolid=true IsPositive=true
  Current_11: Current Objects=Np11 Phase=0deg Current=5A IsSolid=true IsPositive=true
  Current_12: Current Objects=Np12 Phase=0deg Current=5A IsSolid=true IsPositive=true
  Current_13: Current Objects=Np1_Separate1 Phase=0deg Current=5A IsSolid=true IsPositive=false
  Current_14: Current Objects=Np2_Separate1 Phase=0deg Current=5A IsSolid=true IsPositive=false
  Current_15: Current Objects=Np3_Separate1 Phase=0deg Current=5A IsSolid=true IsPositive=false
  Current_16: Current Objects=Np4_Separate1 Phase=0deg Current=5A IsSolid=true IsPositive=false
  Current_17: Current Objects=Np5_Separate1 Phase=0deg Current=5A IsSolid=true IsPositive=false
  Current_18: Current Objects=Np6_Separate1 Phase=0deg Current=5A IsSolid=true IsPositive=false
  Current_19: Current Objects=Np7_Separate1 Phase=0deg Current=5A IsSolid=true IsPositive=false
  Current_20: Current Objects=Np8_Separate1 Phase=0deg Current=5A IsSolid=true IsPositive=false
  Current_21: Current Objects=Np9_Separate1 Phase=0deg Current=5A IsSolid=true IsPositive=false
  Current_22: Current Objects=Np10_Separate1 Phase=0deg Current=5A IsSolid=true IsPositive=false
  Current_23: Current Objects=Np11_Separate1 Phase=0deg Current=5A IsSolid=true IsPositive=false
  Current_24: Current Objects=Np12_Separate1 Phase=0deg Current=5A IsSolid=true IsPositive=false
  Current_25: Current Objects=Ns1 Phase=0deg Current=5A IsSolid=true IsPositive=false
  Current_26: Current Objects=Ns2 Phase=0deg Current=5A IsSolid=true IsPositive=false
  Current_27: Current Objects=Ns3 Phase=0deg Current=5A IsSolid=true IsPositive=false
  Current_28: Current Objects=Ns4 Phase=0deg Current=5A IsSolid=true IsPositive=false
  Current_29: Current Objects=Ns5 Phase=0deg Current=5A IsSolid=true IsPositive=false
  Current_30: Current Objects=Ns6 Phase=0deg Current=5A IsSolid=true IsPositive=false
  Current_31: Current Objects=Ns7 Phase=0deg Current=5A IsSolid=true IsPositive=false
  Current_32: Current Objects=Ns8 Phase=0deg Current=5A IsSolid=true IsPositive=false
  Current_33: Current Objects=Ns9 Phase=0deg Current=5A IsSolid=true IsPositive=false
  Current_34: Current Objects=Ns10 Phase=0deg Current=5A IsSolid=true IsPositive=false
  Current_35: Current Objects=Ns11 Phase=0deg Current=5A IsSolid=true IsPositive=false
  Current_36: Current Objects=Ns12_Separate1 Phase=0deg Current=5A IsSolid=true IsPositive=false
  Current_37: Current Objects=Ns1_Separate1 Phase=0deg Current=5A IsSolid=true IsPositive=true
  Current_38: Current Objects=Ns2_Separate1 Phase=0deg Current=5A IsSolid=true IsPositive=true
  Current_39: Current Objects=Ns3_Separate1 Phase=0deg Current=5A IsSolid=true IsPositive=true
  Current_40: Current Objects=Ns4_Separate1 Phase=0deg Current=5A IsSolid=true IsPositive=true
  Current_41: Current Objects=Ns5_Separate1 Phase=0deg Current=5A IsSolid=true IsPositive=true
  Current_42: Current Objects=Ns6_Separate1 Phase=0deg Current=5A IsSolid=true IsPositive=true
  Current_43: Current Objects=Ns7_Separate1 Phase=0deg Current=5A IsSolid=true IsPositive=true
  Current_44: Current Objects=Ns8_Separate1 Phase=0deg Current=5A IsSolid=true IsPositive=true
  Current_45: Current Objects=Ns9_Separate1 Phase=0deg Current=5A IsSolid=true IsPositive=true
  Current_46: Current Objects=Ns10_Separate1 Phase=0deg Current=5A IsSolid=true IsPositive=true
  Current_47: Current Objects=Ns11_Separate1 Phase=0deg Current=5A IsSolid=true IsPositive=true
  Current_48: Current Objects=Ns12 Phase=0deg Current=5A IsSolid=true IsPositive=true
  eddy effects on: Np1, Np10, Np11, Np12, Np2..Np9, Ns1, Ns10, Ns11, Ns12, Ns2..Ns9, Np1_Separate1, Np2_Separate1, Np3_Separate1, Np4_Separate1, Np5_Separate1, Np6_Separate1, Np7_Separate1, Np8_Separate1, Np9_Separate1, Np10_Separate1, Np11_Separate1, Np12_Separate1, Ns1_Separate1, Ns2_Separate1, Ns3_Separate1, Ns4_Separate1, Ns5_Separate1, Ns6_Separate1, Ns7_Separate1, Ns8_Separate1, Ns9_Separate1, Ns10_Separate1, Ns11_Separate1, Ns12_Separate1
parameters:
  Matrix1: Matrix Reduce_Matrices{ReduceMatrix1{Primary{Type="Join in Series" Matrix=1 Sources=Current_1..Current_24} Secondary{Type="Join in Series" Matrix=1 Sources=Current_25..Current_48}}}; Current_1..Current_48:
mesh:
  Length1: LengthBased RefineInside Objects=[Body1, Body1_3] MaxLength=2mm
  Length2: LengthBased RefineInside Objects=[Np1, Np1_Separate1, Np2, Np2_Separate1, Np3, Np3_Separate1, Np4, Np4_Separate1, Np5, Np5_Separate1, Np6, Np6_Separate1, Np7, Np7_Separate1, Np8, Np8_Separate1, Np9, Np9_Separate1, Np10, Np10_Separate1, Np11, Np11_Separate1, Np12, Np12_Separate1, Ns1, Ns1_Separate1, Ns2, Ns2_Separate1, Ns3, Ns3_Separate1, Ns4, Ns4_Separate1, Ns5, Ns5_Separate1, Ns6, Ns6_Separate1, Ns7, Ns7_Separate1, Ns8, Ns8_Separate1, Ns9, Ns9_Separate1, Ns10, Ns10_Separate1, Ns11, Ns11_Separate1, Ns12, Ns12_Separate1] MaxLength=0.05mm
  initial mesh: GlobalSurfApproximation{CurvedSurfaceApproxChoice=UseSlider SliderMeshSettings=9}
setups:
  Setup1: EddyCurrent MaximumPasses=20 MinimumPasses=2 MinimumConvergedPasses=1 PercentRefinement=30 PercentError=1 NonLinearResidual=0.0001 Frequency=30000Hz SweepRanges{10Hz to 50000Hz step 1000Hz} SaveAllFields
field plots:
  JAtPhase1: J over Np1, Np1_Separate1, Np2, Np2_Separate1, Np3, Np3_Separate1, Np4, Np4_Separate1, Np5, Np5_Separate1, Np6, Np6_Separate1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 on Setup1 : LastAdaptive at Freq=30000Hz Phase=0deg
reports:
  Loss Plot1: SolidLoss vs Freq on Setup1 : LastAdaptive

design Symmetry_Flatwise (Maxwell 2D, EddyCurrent, XY geometry, model units mm)
options: ModelDepth=19.678mm
geometry:
  Np1#3477, Np10#3529, Np11#3581, Np12#3633, Np2#3685, Np3#3737, Np4#3789, Np5#3841, Np6#3893, Np7#3945, Np8#3997, Np9#4049, Ns1#4101, Ns10#4153, Ns11#4205, Ns12#4257, Ns2#4309, Ns3#4361, Ns4#4413, Ns5#4465, Ns6#4517, Ns7#4569, Ns8#4621, Ns9#4673, Body1#5977, Body1_3#6157 = imported_body(C:\Users\karlr\Documents\core_assembled_flatwise v2_0.1.step)
  Region [vacuum] = region(percentage_offset=0 on all sides)
  Np1 [copper] = Np1#3477.section(plane=ZX)
  Np1#3477.delete()
  Np1.rotate(axis=X, angle=-90deg)
  Np10 [copper] = Np10#3529.section(plane=ZX)
  Np10#3529.delete()
  Np10.rotate(axis=X, angle=-90deg)
  Np11 [copper] = Np11#3581.section(plane=ZX)
  Np11#3581.delete()
  Np11.rotate(axis=X, angle=-90deg)
  Np12 [copper] = Np12#3633.section(plane=ZX)
  Np12#3633.delete()
  Np12.rotate(axis=X, angle=-90deg)
  Np2 [copper] = Np2#3685.section(plane=ZX)
  Np2#3685.delete()
  Np2.rotate(axis=X, angle=-90deg)
  Np3 [copper] = Np3#3737.section(plane=ZX)
  Np3#3737.delete()
  Np3.rotate(axis=X, angle=-90deg)
  Np4 [copper] = Np4#3789.section(plane=ZX)
  Np4#3789.delete()
  Np4.rotate(axis=X, angle=-90deg)
  Np5 [copper] = Np5#3841.section(plane=ZX)
  Np5#3841.delete()
  Np5.rotate(axis=X, angle=-90deg)
  Np6 [copper] = Np6#3893.section(plane=ZX)
  Np6#3893.delete()
  Np6.rotate(axis=X, angle=-90deg)
  Np7 [copper] = Np7#3945.section(plane=ZX)
  Np7#3945.delete()
  Np7.rotate(axis=X, angle=-90deg)
  Np8 [copper] = Np8#3997.section(plane=ZX)
  Np8#3997.delete()
  Np8.rotate(axis=X, angle=-90deg)
  Np9 [copper] = Np9#4049.section(plane=ZX)
  Np9#4049.delete()
  Np9.rotate(axis=X, angle=-90deg)
  Ns1 [copper] = Ns1#4101.section(plane=ZX)
  Ns1#4101.delete()
  Ns1.rotate(axis=X, angle=-90deg)
  Ns10 [copper] = Ns10#4153.section(plane=ZX)
  Ns10#4153.delete()
  Ns10.rotate(axis=X, angle=-90deg)
  Ns11 [copper] = Ns11#4205.section(plane=ZX)
  Ns11#4205.delete()
  Ns11.rotate(axis=X, angle=-90deg)
  Ns12#7263 = Ns12#4257.section(plane=ZX)
  Ns12#4257.delete()
  Ns12#7263.rotate(axis=X, angle=-90deg)
  Ns2 [copper] = Ns2#4309.section(plane=ZX)
  Ns2#4309.delete()
  Ns2.rotate(axis=X, angle=-90deg)
  Ns3 [copper] = Ns3#4361.section(plane=ZX)
  Ns3#4361.delete()
  Ns3.rotate(axis=X, angle=-90deg)
  Ns4 [copper] = Ns4#4413.section(plane=ZX)
  Ns4#4413.delete()
  Ns4.rotate(axis=X, angle=-90deg)
  Ns5 [copper] = Ns5#4465.section(plane=ZX)
  Ns5#4465.delete()
  Ns5.rotate(axis=X, angle=-90deg)
  Ns6 [copper] = Ns6#4517.section(plane=ZX)
  Ns6#4517.delete()
  Ns6.rotate(axis=X, angle=-90deg)
  Ns7 [copper] = Ns7#4569.section(plane=ZX)
  Ns7#4569.delete()
  Ns7.rotate(axis=X, angle=-90deg)
  Ns8 [copper] = Ns8#4621.section(plane=ZX)
  Ns8#4621.delete()
  Ns8.rotate(axis=X, angle=-90deg)
  Ns9 [copper] = Ns9#4673.section(plane=ZX)
  Ns9#4673.delete()
  Ns9.rotate(axis=X, angle=-90deg)
  Body1 [ferrite] = Body1#5977.section(plane=ZX)
  Body1#5977.delete()
  Body1.rotate(axis=X, angle=-90deg)
  Body1_3 [ferrite] = Body1_3#6157.section(plane=ZX)
  Body1_3#6157.delete()
  Body1_3.rotate(axis=X, angle=-90deg)
  [Np1, Np10, Np11, Np12, Np2..Np9, Ns1, Ns10, Ns11, Ns12#7263, Ns2..Ns9, Body1, Body1_3].move(-8.65mm, -4.275mm, 0mm)
  Np1.separate_bodies()
  Np2.separate_bodies()
  Np3.separate_bodies()
  Np4.separate_bodies()
  Np5.separate_bodies()
  Np6.separate_bodies()
  Np7.separate_bodies()
  Np8.separate_bodies()
  Np9.separate_bodies()
  Np10.separate_bodies()
  Np11.separate_bodies()
  Np12.separate_bodies()
  Ns1.separate_bodies()
  Ns2.separate_bodies()
  Ns3.separate_bodies()
  Ns4.separate_bodies()
  Ns5.separate_bodies()
  Ns6.separate_bodies()
  Ns7.separate_bodies()
  Ns8.separate_bodies()
  Ns9.separate_bodies()
  Ns10.separate_bodies()
  Ns11.separate_bodies()
  Ns12_Separate1 [copper] = Ns12#7263.separate_bodies()
  [Np1, Np10, Np11, Np12, Np2..Np9, Ns1, Ns10, Ns11, Ns12#7263].split(plane=YZ, keep=PositiveOnly)
  Ns12#7263.delete()
  [Ns2..Ns9, Body1, Body1_3, Ns12_Separate1].split(plane=YZ, keep=PositiveOnly)
  group Core = Body1, Body1_3
  group primary = Np1, Np10, Np11, Np12, Np2..Np9
  group secondary = Ns1, Ns10, Ns11, Ns2..Ns9, Ns12_Separate1
boundaries and excitations:
  Balloon1: Balloon Edges=Region.edge(all 4)
  Symmetry1: Symmetry Edges=Region.edge(at (0, 0.05, 0)) IsOdd=true
  Np1: Coil Objects=Np1 Conductor_number=1 Winding=Primary PolarityType=Positive
  Np2: Coil Objects=Np2 Conductor_number=1 Winding=Primary PolarityType=Positive
  Np3: Coil Objects=Np3 Conductor_number=1 Winding=Primary PolarityType=Positive
  Np4: Coil Objects=Np4 Conductor_number=1 Winding=Primary PolarityType=Positive
  Np5: Coil Objects=Np5 Conductor_number=1 Winding=Primary PolarityType=Positive
  Np6: Coil Objects=Np6 Conductor_number=1 Winding=Primary PolarityType=Positive
  Np7: Coil Objects=Np7 Conductor_number=1 Winding=Primary PolarityType=Positive
  Np8: Coil Objects=Np8 Conductor_number=1 Winding=Primary PolarityType=Positive
  Np9: Coil Objects=Np9 Conductor_number=1 Winding=Primary PolarityType=Positive
  Np10: Coil Objects=Np10 Conductor_number=1 Winding=Primary PolarityType=Positive
  Np11: Coil Objects=Np11 Conductor_number=1 Winding=Primary PolarityType=Positive
  Np12: Coil Objects=Np12 Conductor_number=1 Winding=Primary PolarityType=Positive
  Ns1: Coil Objects=Ns1 Conductor_number=1 Winding=Secondary PolarityType=Negative
  Ns2: Coil Objects=Ns2 Conductor_number=1 Winding=Secondary PolarityType=Negative
  Ns3: Coil Objects=Ns3 Conductor_number=1 Winding=Secondary PolarityType=Negative
  Ns4: Coil Objects=Ns4 Conductor_number=1 Winding=Secondary PolarityType=Negative
  Ns5: Coil Objects=Ns5 Conductor_number=1 Winding=Secondary PolarityType=Negative
  Ns6: Coil Objects=Ns6 Conductor_number=1 Winding=Secondary PolarityType=Negative
  Ns7: Coil Objects=Ns7 Conductor_number=1 Winding=Secondary PolarityType=Negative
  Ns8: Coil Objects=Ns8 Conductor_number=1 Winding=Secondary PolarityType=Negative
  Ns9: Coil Objects=Ns9 Conductor_number=1 Winding=Secondary PolarityType=Negative
  Ns10: Coil Objects=Ns10 Conductor_number=1 Winding=Secondary PolarityType=Negative
  Ns11: Coil Objects=Ns11 Conductor_number=1 Winding=Secondary PolarityType=Negative
  Ns12_Separate1: Coil Objects=Ns12_Separate1 Conductor_number=1 Winding=Secondary PolarityType=Negative
  Primary: Winding Group Type=Current IsSolid=true Current=5A ParallelBranchesNum=1 Phase=0deg
  Secondary: Winding Group Type=Current IsSolid=true Current=5A ParallelBranchesNum=1 Phase=0deg
  eddy effects on: Np1, Np10, Np11, Np12, Np2..Np9, Ns1, Ns10, Ns11, Ns2..Ns9, Ns12_Separate1
parameters:
  Matrix1: Matrix Primary, Secondary:
mesh:
  Length1: LengthBased RefineInside Objects=[Body1, Body1_3] MaxLength=2mm
  Length2: LengthBased RefineInside Objects=[Np1..Np12, Ns1..Ns11, Ns12_Separate1] MaxLength=0.05mm
  initial mesh: GlobalSurfApproximation{CurvedSurfaceApproxChoice=UseSlider SliderMeshSettings=9}
setups:
  Setup1: EddyCurrent MaximumPasses=20 MinimumPasses=2 MinimumConvergedPasses=1 PercentRefinement=30 PercentError=1 NonLinearResidual=0.0001 Frequency=10kHz SweepRanges{10Hz to 50000Hz step 1000Hz} SaveAllFields
field plots:
  JAtPhase1: J over Np1..Np12, Ns1..Ns11, Ns12_Separate1 on Setup1 : LastAdaptive at Freq=10kHz Phase=0deg
reports:
  Loss Plot1: SolidLoss vs Freq on Setup1 : LastAdaptive

design Maxwell2DDesign3 (Maxwell 2D, EddyCurrent, XY geometry, model units mm)
options: ModelDepth=19.678mm
geometry:
  Np1#6, Np10#58, Np11#110, Np12#162, Np2#214, Np3#266, Np4#318, Np5#370, Np6#422, Np7#474, Np8#526, Np9#578, Ns1#630, Ns10#682, Ns11#734, Ns12#786, Ns2#838, Ns3#890, Ns4#942, Ns5#994, Ns6#1046, Ns7#1098, Ns8#1150, Ns9#1202, Body1#2506, Body1_3#2686 = imported_body(C:\Users\karlr\Documents\core_assembled_edgewise v2_0.1.step)
  Region [vacuum] = region(percentage_offset=0 on all sides)
  Np1 [copper] = Np1#6.section(plane=ZX)
  Np1#6.delete()
  Np1.rotate(axis=X, angle=-90deg)
  Np10 [copper] = Np10#58.section(plane=ZX)
  Np10#58.delete()
  Np10.rotate(axis=X, angle=-90deg)
  Np11 [copper] = Np11#110.section(plane=ZX)
  Np11#110.delete()
  Np11.rotate(axis=X, angle=-90deg)
  Np12 [copper] = Np12#162.section(plane=ZX)
  Np12#162.delete()
  Np12.rotate(axis=X, angle=-90deg)
  Np2 [copper] = Np2#214.section(plane=ZX)
  Np2#214.delete()
  Np2.rotate(axis=X, angle=-90deg)
  Np3 [copper] = Np3#266.section(plane=ZX)
  Np3#266.delete()
  Np3.rotate(axis=X, angle=-90deg)
  Np4 [copper] = Np4#318.section(plane=ZX)
  Np4#318.delete()
  Np4.rotate(axis=X, angle=-90deg)
  Np5 [copper] = Np5#370.section(plane=ZX)
  Np5#370.delete()
  Np5.rotate(axis=X, angle=-90deg)
  Np6 [copper] = Np6#422.section(plane=ZX)
  Np6#422.delete()
  Np6.rotate(axis=X, angle=-90deg)
  Np7 [copper] = Np7#474.section(plane=ZX)
  Np7#474.delete()
  Np7.rotate(axis=X, angle=-90deg)
  Np8 [copper] = Np8#526.section(plane=ZX)
  Np8#526.delete()
  Np8.rotate(axis=X, angle=-90deg)
  Np9 [copper] = Np9#578.section(plane=ZX)
  Np9#578.delete()
  Np9.rotate(axis=X, angle=-90deg)
  Ns1 [copper] = Ns1#630.section(plane=ZX)
  Ns1#630.delete()
  Ns1.rotate(axis=X, angle=-90deg)
  Ns10 [copper] = Ns10#682.section(plane=ZX)
  Ns10#682.delete()
  Ns10.rotate(axis=X, angle=-90deg)
  Ns11 [copper] = Ns11#734.section(plane=ZX)
  Ns11#734.delete()
  Ns11.rotate(axis=X, angle=-90deg)
  Ns12 [copper] = Ns12#786.section(plane=ZX)
  Ns12#786.delete()
  Ns12.rotate(axis=X, angle=-90deg)
  Ns2 [copper] = Ns2#838.section(plane=ZX)
  Ns2#838.delete()
  Ns2.rotate(axis=X, angle=-90deg)
  Ns3 [copper] = Ns3#890.section(plane=ZX)
  Ns3#890.delete()
  Ns3.rotate(axis=X, angle=-90deg)
  Ns4 [copper] = Ns4#942.section(plane=ZX)
  Ns4#942.delete()
  Ns4.rotate(axis=X, angle=-90deg)
  Ns5 [copper] = Ns5#994.section(plane=ZX)
  Ns5#994.delete()
  Ns5.rotate(axis=X, angle=-90deg)
  Ns6 [copper] = Ns6#1046.section(plane=ZX)
  Ns6#1046.delete()
  Ns6.rotate(axis=X, angle=-90deg)
  Ns7 [copper] = Ns7#1098.section(plane=ZX)
  Ns7#1098.delete()
  Ns7.rotate(axis=X, angle=-90deg)
  Ns8 [copper] = Ns8#1150.section(plane=ZX)
  Ns8#1150.delete()
  Ns8.rotate(axis=X, angle=-90deg)
  Ns9 [copper] = Ns9#1202.section(plane=ZX)
  Ns9#1202.delete()
  Ns9.rotate(axis=X, angle=-90deg)
  Body1 [ferrite] = Body1#2506.section(plane=ZX)
  Body1#2506.delete()
  Body1.rotate(axis=X, angle=-90deg)
  Body1_3 [ferrite] = Body1_3#2686.section(plane=ZX)
  Body1_3#2686.delete()
  Body1_3.rotate(axis=X, angle=-90deg)
  [Np1, Np10, Np11, Np12, Np2..Np9, Ns1, Ns10, Ns11, Ns12, Ns2..Ns9, Body1, Body1_3].move(-8.65mm, -4.275mm, 0mm)
  [Np1, Np10, Np11, Np12, Np2..Np9, Ns1, Ns10, Ns11, Ns12, Ns2..Ns9, Body1, Body1_3].split(plane=YZ, keep=PositiveOnly)
  group Primary = Np1, Np10, Np11, Np12, Np2..Np9
  group Secondary = Ns1, Ns10, Ns11, Ns12, Ns2..Ns9
  group Core = Body1, Body1_3
boundaries and excitations:
  Balloon1: Balloon Edges=Region.edge(all 4)
  Ns12: Coil Objects=Ns12 Conductor_number=1 Winding=Secondary PolarityType=Negative
  Ns1: Coil Objects=Ns1 Conductor_number=1 Winding=Secondary PolarityType=Negative
  Ns2: Coil Objects=Ns2 Conductor_number=1 Winding=Secondary PolarityType=Negative
  Ns3: Coil Objects=Ns3 Conductor_number=1 Winding=Secondary PolarityType=Negative
  Ns4: Coil Objects=Ns4 Conductor_number=1 Winding=Secondary PolarityType=Negative
  Ns5: Coil Objects=Ns5 Conductor_number=1 Winding=Secondary PolarityType=Negative
  Ns6: Coil Objects=Ns6 Conductor_number=1 Winding=Secondary PolarityType=Negative
  Ns7: Coil Objects=Ns7 Conductor_number=1 Winding=Secondary PolarityType=Negative
  Ns8: Coil Objects=Ns8 Conductor_number=1 Winding=Secondary PolarityType=Negative
  Ns9: Coil Objects=Ns9 Conductor_number=1 Winding=Secondary PolarityType=Negative
  Ns10: Coil Objects=Ns10 Conductor_number=1 Winding=Secondary PolarityType=Negative
  Ns11: Coil Objects=Ns11 Conductor_number=1 Winding=Secondary PolarityType=Negative
  Np12: Coil Objects=Np12 Conductor_number=1 Winding=Primary PolarityType=Positive
  Np1: Coil Objects=Np1 Conductor_number=1 Winding=Primary PolarityType=Positive
  Np2: Coil Objects=Np2 Conductor_number=1 Winding=Primary PolarityType=Positive
  Np3: Coil Objects=Np3 Conductor_number=1 Winding=Primary PolarityType=Positive
  Np4: Coil Objects=Np4 Conductor_number=1 Winding=Primary PolarityType=Positive
  Np5: Coil Objects=Np5 Conductor_number=1 Winding=Primary PolarityType=Positive
  Np6: Coil Objects=Np6 Conductor_number=1 Winding=Primary PolarityType=Positive
  Np7: Coil Objects=Np7 Conductor_number=1 Winding=Primary PolarityType=Positive
  Np8: Coil Objects=Np8 Conductor_number=1 Winding=Primary PolarityType=Positive
  Np9: Coil Objects=Np9 Conductor_number=1 Winding=Primary PolarityType=Positive
  Np10: Coil Objects=Np10 Conductor_number=1 Winding=Primary PolarityType=Positive
  Np11: Coil Objects=Np11 Conductor_number=1 Winding=Primary PolarityType=Positive
  Primary: Winding Group Type=Current IsSolid=true Current=5A ParallelBranchesNum=1 Phase=0deg
  Secondary: Winding Group Type=Current IsSolid=true Current=5A ParallelBranchesNum=1 Phase=0deg
parameters:
  Matrix1: Matrix Primary, Secondary:
mesh:
  Length1: LengthBased RefineInside Objects=[Ns12, Ns1..Ns11, Np12, Np11, Np10, Np9, Np8, Np7, Np6, Np5, Np4, Np3, Np2, Np1] MaxLength=0.05mm
  Length2: LengthBased RefineInside Objects=[Body1, Body1_3] MaxLength=1mm
  Length3: LengthBased RefineInside Objects=Region MaxLength=1.73mm
setups:
  Setup1: EddyCurrent MaximumPasses=10 MinimumPasses=2 MinimumConvergedPasses=1 PercentRefinement=30 PercentError=1 NonLinearResidual=0.0001 Frequency=10000Hz SweepRanges{10Hz to 500000Hz step 1000Hz} SaveAllFields

design Symmetry_Flatwise1 (Maxwell 2D, EddyCurrent, XY geometry, model units mm)
options: ModelDepth=19.678mm
geometry:
  Np1#3477, Np10#3529, Np11#3581, Np12#3633, Np2#3685, Np3#3737, Np4#3789, Np5#3841, Np6#3893, Np7#3945, Np8#3997, Np9#4049, Ns1#4101, Ns10#4153, Ns11#4205, Ns12#4257, Ns2#4309, Ns3#4361, Ns4#4413, Ns5#4465, Ns6#4517, Ns7#4569, Ns8#4621, Ns9#4673, Body1#5977, Body1_3#6157 = imported_body(C:\Users\karlr\Documents\core_assembled_flatwise v2_0.1.step)
  Region [vacuum] = region(percentage_offset=0 on all sides)
  Np1 [copper] = Np1#3477.section(plane=ZX)
  Np1#3477.delete()
  Np1.rotate(axis=X, angle=-90deg)
  Np10 [copper] = Np10#3529.section(plane=ZX)
  Np10#3529.delete()
  Np10.rotate(axis=X, angle=-90deg)
  Np11 [copper] = Np11#3581.section(plane=ZX)
  Np11#3581.delete()
  Np11.rotate(axis=X, angle=-90deg)
  Np12 [copper] = Np12#3633.section(plane=ZX)
  Np12#3633.delete()
  Np12.rotate(axis=X, angle=-90deg)
  Np2 [copper] = Np2#3685.section(plane=ZX)
  Np2#3685.delete()
  Np2.rotate(axis=X, angle=-90deg)
  Np3 [copper] = Np3#3737.section(plane=ZX)
  Np3#3737.delete()
  Np3.rotate(axis=X, angle=-90deg)
  Np4 [copper] = Np4#3789.section(plane=ZX)
  Np4#3789.delete()
  Np4.rotate(axis=X, angle=-90deg)
  Np5 [copper] = Np5#3841.section(plane=ZX)
  Np5#3841.delete()
  Np5.rotate(axis=X, angle=-90deg)
  Np6 [copper] = Np6#3893.section(plane=ZX)
  Np6#3893.delete()
  Np6.rotate(axis=X, angle=-90deg)
  Np7 [copper] = Np7#3945.section(plane=ZX)
  Np7#3945.delete()
  Np7.rotate(axis=X, angle=-90deg)
  Np8 [copper] = Np8#3997.section(plane=ZX)
  Np8#3997.delete()
  Np8.rotate(axis=X, angle=-90deg)
  Np9 [copper] = Np9#4049.section(plane=ZX)
  Np9#4049.delete()
  Np9.rotate(axis=X, angle=-90deg)
  Ns1 [copper] = Ns1#4101.section(plane=ZX)
  Ns1#4101.delete()
  Ns1.rotate(axis=X, angle=-90deg)
  Ns10 [copper] = Ns10#4153.section(plane=ZX)
  Ns10#4153.delete()
  Ns10.rotate(axis=X, angle=-90deg)
  Ns11 [copper] = Ns11#4205.section(plane=ZX)
  Ns11#4205.delete()
  Ns11.rotate(axis=X, angle=-90deg)
  Ns12#7263 = Ns12#4257.section(plane=ZX)
  Ns12#4257.delete()
  Ns12#7263.rotate(axis=X, angle=-90deg)
  Ns2 [copper] = Ns2#4309.section(plane=ZX)
  Ns2#4309.delete()
  Ns2.rotate(axis=X, angle=-90deg)
  Ns3 [copper] = Ns3#4361.section(plane=ZX)
  Ns3#4361.delete()
  Ns3.rotate(axis=X, angle=-90deg)
  Ns4 [copper] = Ns4#4413.section(plane=ZX)
  Ns4#4413.delete()
  Ns4.rotate(axis=X, angle=-90deg)
  Ns5 [copper] = Ns5#4465.section(plane=ZX)
  Ns5#4465.delete()
  Ns5.rotate(axis=X, angle=-90deg)
  Ns6 [copper] = Ns6#4517.section(plane=ZX)
  Ns6#4517.delete()
  Ns6.rotate(axis=X, angle=-90deg)
  Ns7 [copper] = Ns7#4569.section(plane=ZX)
  Ns7#4569.delete()
  Ns7.rotate(axis=X, angle=-90deg)
  Ns8 [copper] = Ns8#4621.section(plane=ZX)
  Ns8#4621.delete()
  Ns8.rotate(axis=X, angle=-90deg)
  Ns9 [copper] = Ns9#4673.section(plane=ZX)
  Ns9#4673.delete()
  Ns9.rotate(axis=X, angle=-90deg)
  Body1 [ferrite] = Body1#5977.section(plane=ZX)
  Body1#5977.delete()
  Body1.rotate(axis=X, angle=-90deg)
  Body1_3 [ferrite] = Body1_3#6157.section(plane=ZX)
  Body1_3#6157.delete()
  Body1_3.rotate(axis=X, angle=-90deg)
  [Np1, Np10, Np11, Np12, Np2..Np9, Ns1, Ns10, Ns11, Ns12#7263, Ns2..Ns9, Body1, Body1_3].move(-8.65mm, -4.275mm, 0mm)
  Np1.separate_bodies()
  Np2.separate_bodies()
  Np3.separate_bodies()
  Np4.separate_bodies()
  Np5.separate_bodies()
  Np6.separate_bodies()
  Np7.separate_bodies()
  Np8.separate_bodies()
  Np9.separate_bodies()
  Np10.separate_bodies()
  Np11.separate_bodies()
  Np12.separate_bodies()
  Ns1.separate_bodies()
  Ns2.separate_bodies()
  Ns3.separate_bodies()
  Ns4.separate_bodies()
  Ns5.separate_bodies()
  Ns6.separate_bodies()
  Ns7.separate_bodies()
  Ns8.separate_bodies()
  Ns9.separate_bodies()
  Ns10.separate_bodies()
  Ns11.separate_bodies()
  Ns12_Separate1 [copper] = Ns12#7263.separate_bodies()
  [Np1, Np10, Np11, Np12, Np2..Np9, Ns1, Ns10, Ns11, Ns12#7263].split(plane=YZ, keep=PositiveOnly)
  Ns12#7263.delete()
  [Ns2..Ns9, Body1, Body1_3, Ns12_Separate1].split(plane=YZ, keep=PositiveOnly)
  [Ns1..Ns11, Ns12_Separate1, Np12, Np11, Np9, Np10, Np7, Np8, Np6, Np5, Np4, Np3, Np2, Np1].rotate(axis=Z, angle=90deg)
  [Ns1..Ns11, Ns12_Separate1, Np12, Np11, Np9, Np10, Np7, Np8, Np6, Np5, Np4, Np3, Np2, Np1].move(0mm, -4.275mm, 0mm)
  [Ns1..Ns11, Ns12_Separate1, Np12, Np11, Np9, Np10, Np7, Np8, Np6, Np5, Np4, Np3, Np2, Np1].move(4.375mm, 0.075mm, 0mm)
  Ns1.move(0mm, -0.05mm, 0mm)
  Ns2.move(0mm, -0.05mm, 0mm)
  Ns3.move(0mm, -0.05mm, 0mm)
  Ns4.move(0mm, -0.05mm, 0mm)
  Ns5.move(0mm, -0.05mm, 0mm)
  Ns6.move(0mm, -0.05mm, 0mm)
  Ns7.move(0mm, -0.05mm, 0mm)
  Ns8.move(0mm, -0.05mm, 0mm)
  Ns9.move(0mm, -0.05mm, 0mm)
  Ns10.move(0mm, -0.05mm, 0mm)
  Ns11.move(0mm, -0.05mm, 0mm)
  Ns12_Separate1.move(0mm, -0.05mm, 0mm)
  Np12.move(0mm, -0.05mm, 0mm)
  Np11.move(0mm, -0.05mm, 0mm)
  Np9.move(0mm, -0.05mm, 0mm)
  Np10.move(0mm, -0.05mm, 0mm)
  Np7.move(0mm, -0.05mm, 0mm)
  Np8.move(0mm, -0.05mm, 0mm)
  Np6.move(0mm, -0.05mm, 0mm)
  Np5.move(0mm, -0.05mm, 0mm)
  Np4.move(0mm, -0.05mm, 0mm)
  Np3.move(0mm, -0.05mm, 0mm)
  Np2.move(0mm, -0.05mm, 0mm)
  Np1.move(0mm, -0.05mm, 0mm)
  [Ns1..Ns11, Ns12_Separate1, Np12, Np11, Np9, Np10, Np7, Np8, Np6, Np5, Np4, Np3, Np2, Np1].move(0mm, -0.05mm, 0mm)
  group Core = Body1, Body1_3
  group primary = Np1, Np10, Np11, Np12, Np2..Np9
  group secondary = Ns1, Ns10, Ns11, Ns2..Ns9, Ns12_Separate1
boundaries and excitations:
  Balloon1: Balloon Edges=Region.edge(all 4)
  Symmetry1: Symmetry Edges=Region.edge(at (0, 0.05, 0)) IsOdd=true
  Np1: Coil Objects=Np1 Conductor_number=1 Winding=Primary PolarityType=Positive
  Np2: Coil Objects=Np2 Conductor_number=1 Winding=Primary PolarityType=Positive
  Np3: Coil Objects=Np3 Conductor_number=1 Winding=Primary PolarityType=Positive
  Np4: Coil Objects=Np4 Conductor_number=1 Winding=Primary PolarityType=Positive
  Np5: Coil Objects=Np5 Conductor_number=1 Winding=Primary PolarityType=Positive
  Np6: Coil Objects=Np6 Conductor_number=1 Winding=Primary PolarityType=Positive
  Np7: Coil Objects=Np7 Conductor_number=1 Winding=Primary PolarityType=Positive
  Np8: Coil Objects=Np8 Conductor_number=1 Winding=Primary PolarityType=Positive
  Np9: Coil Objects=Np9 Conductor_number=1 Winding=Primary PolarityType=Positive
  Np10: Coil Objects=Np10 Conductor_number=1 Winding=Primary PolarityType=Positive
  Np11: Coil Objects=Np11 Conductor_number=1 Winding=Primary PolarityType=Positive
  Np12: Coil Objects=Np12 Conductor_number=1 Winding=Primary PolarityType=Positive
  Ns1: Coil Objects=Ns1 Conductor_number=1 Winding=Secondary PolarityType=Negative
  Ns2: Coil Objects=Ns2 Conductor_number=1 Winding=Secondary PolarityType=Negative
  Ns3: Coil Objects=Ns3 Conductor_number=1 Winding=Secondary PolarityType=Negative
  Ns4: Coil Objects=Ns4 Conductor_number=1 Winding=Secondary PolarityType=Negative
  Ns5: Coil Objects=Ns5 Conductor_number=1 Winding=Secondary PolarityType=Negative
  Ns6: Coil Objects=Ns6 Conductor_number=1 Winding=Secondary PolarityType=Negative
  Ns7: Coil Objects=Ns7 Conductor_number=1 Winding=Secondary PolarityType=Negative
  Ns8: Coil Objects=Ns8 Conductor_number=1 Winding=Secondary PolarityType=Negative
  Ns9: Coil Objects=Ns9 Conductor_number=1 Winding=Secondary PolarityType=Negative
  Ns10: Coil Objects=Ns10 Conductor_number=1 Winding=Secondary PolarityType=Negative
  Ns11: Coil Objects=Ns11 Conductor_number=1 Winding=Secondary PolarityType=Negative
  Ns12_Separate1: Coil Objects=Ns12_Separate1 Conductor_number=1 Winding=Secondary PolarityType=Negative
  Primary: Winding Group Type=Current IsSolid=true Current=5A ParallelBranchesNum=1 Phase=0deg
  Secondary: Winding Group Type=Current IsSolid=true Current=0mA ParallelBranchesNum=1 Phase=0deg
  eddy effects on: Np1, Np10, Np11, Np12, Np2..Np9, Ns1, Ns10, Ns11, Ns2..Ns9, Ns12_Separate1
parameters:
  Matrix1: Matrix Primary, Secondary:
mesh:
  Length1: LengthBased RefineInside Objects=[Body1, Body1_3] MaxLength=2mm
  Length2: LengthBased RefineInside Objects=[Np1..Np12, Ns1..Ns11, Ns12_Separate1] MaxLength=0.05mm
  initial mesh: GlobalSurfApproximation{CurvedSurfaceApproxChoice=UseSlider SliderMeshSettings=9}
setups:
  Setup1: EddyCurrent MaximumPasses=20 MinimumPasses=2 MinimumConvergedPasses=1 PercentRefinement=30 PercentError=1 NonLinearResidual=0.0001 Frequency=10kHz SweepRanges{10Hz to 500000Hz step 1000Hz} SaveAllFields
field plots:
  JAtPhase1: J over Ns1..Ns11, Ns12_Separate1 on Setup1 : LastAdaptive at Freq=10kHz Phase=0deg
  JAtPhase2: J over Np1..Np12 on Setup1 : LastAdaptive at Freq=10kHz Phase=0deg

design Symmetry_Flatwise2 (Maxwell 2D, EddyCurrent, XY geometry, model units mm)
options: ModelDepth=19.678mm
geometry:
  Np1#3477, Np10#3529, Np11#3581, Np12#3633, Np2#3685, Np3#3737, Np4#3789, Np5#3841, Np6#3893, Np7#3945, Np8#3997, Np9#4049, Ns1#4101, Ns10#4153, Ns11#4205, Ns12#4257, Ns2#4309, Ns3#4361, Ns4#4413, Ns5#4465, Ns6#4517, Ns7#4569, Ns8#4621, Ns9#4673, Body1#5977, Body1_3#6157 = imported_body(C:\Users\karlr\Documents\core_assembled_flatwise v2_0.1.step)
  Region [vacuum] = region(percentage_offset=0 on all sides)
  Np1 [copper] = Np1#3477.section(plane=ZX)
  Np1#3477.delete()
  Np1.rotate(axis=X, angle=-90deg)
  Np10 [copper] = Np10#3529.section(plane=ZX)
  Np10#3529.delete()
  Np10.rotate(axis=X, angle=-90deg)
  Np11 [copper] = Np11#3581.section(plane=ZX)
  Np11#3581.delete()
  Np11.rotate(axis=X, angle=-90deg)
  Np12 [copper] = Np12#3633.section(plane=ZX)
  Np12#3633.delete()
  Np12.rotate(axis=X, angle=-90deg)
  Np2 [copper] = Np2#3685.section(plane=ZX)
  Np2#3685.delete()
  Np2.rotate(axis=X, angle=-90deg)
  Np3 [copper] = Np3#3737.section(plane=ZX)
  Np3#3737.delete()
  Np3.rotate(axis=X, angle=-90deg)
  Np4 [copper] = Np4#3789.section(plane=ZX)
  Np4#3789.delete()
  Np4.rotate(axis=X, angle=-90deg)
  Np5 [copper] = Np5#3841.section(plane=ZX)
  Np5#3841.delete()
  Np5.rotate(axis=X, angle=-90deg)
  Np6 [copper] = Np6#3893.section(plane=ZX)
  Np6#3893.delete()
  Np6.rotate(axis=X, angle=-90deg)
  Np7 [copper] = Np7#3945.section(plane=ZX)
  Np7#3945.delete()
  Np7.rotate(axis=X, angle=-90deg)
  Np8 [copper] = Np8#3997.section(plane=ZX)
  Np8#3997.delete()
  Np8.rotate(axis=X, angle=-90deg)
  Np9 [copper] = Np9#4049.section(plane=ZX)
  Np9#4049.delete()
  Np9.rotate(axis=X, angle=-90deg)
  Ns1 [copper] = Ns1#4101.section(plane=ZX)
  Ns1#4101.delete()
  Ns1.rotate(axis=X, angle=-90deg)
  Ns10 [copper] = Ns10#4153.section(plane=ZX)
  Ns10#4153.delete()
  Ns10.rotate(axis=X, angle=-90deg)
  Ns11 [copper] = Ns11#4205.section(plane=ZX)
  Ns11#4205.delete()
  Ns11.rotate(axis=X, angle=-90deg)
  Ns12#7263 = Ns12#4257.section(plane=ZX)
  Ns12#4257.delete()
  Ns12#7263.rotate(axis=X, angle=-90deg)
  Ns2 [copper] = Ns2#4309.section(plane=ZX)
  Ns2#4309.delete()
  Ns2.rotate(axis=X, angle=-90deg)
  Ns3 [copper] = Ns3#4361.section(plane=ZX)
  Ns3#4361.delete()
  Ns3.rotate(axis=X, angle=-90deg)
  Ns4 [copper] = Ns4#4413.section(plane=ZX)
  Ns4#4413.delete()
  Ns4.rotate(axis=X, angle=-90deg)
  Ns5 [copper] = Ns5#4465.section(plane=ZX)
  Ns5#4465.delete()
  Ns5.rotate(axis=X, angle=-90deg)
  Ns6 [copper] = Ns6#4517.section(plane=ZX)
  Ns6#4517.delete()
  Ns6.rotate(axis=X, angle=-90deg)
  Ns7 [copper] = Ns7#4569.section(plane=ZX)
  Ns7#4569.delete()
  Ns7.rotate(axis=X, angle=-90deg)
  Ns8 [copper] = Ns8#4621.section(plane=ZX)
  Ns8#4621.delete()
  Ns8.rotate(axis=X, angle=-90deg)
  Ns9 [copper] = Ns9#4673.section(plane=ZX)
  Ns9#4673.delete()
  Ns9.rotate(axis=X, angle=-90deg)
  Body1 [ferrite] = Body1#5977.section(plane=ZX)
  Body1#5977.delete()
  Body1.rotate(axis=X, angle=-90deg)
  Body1_3 [ferrite] = Body1_3#6157.section(plane=ZX)
  Body1_3#6157.delete()
  Body1_3.rotate(axis=X, angle=-90deg)
  [Np1, Np10, Np11, Np12, Np2..Np9, Ns1, Ns10, Ns11, Ns12#7263, Ns2..Ns9, Body1, Body1_3].move(-8.65mm, -4.275mm, 0mm)
  Np1.separate_bodies()
  Np2.separate_bodies()
  Np3.separate_bodies()
  Np4.separate_bodies()
  Np5.separate_bodies()
  Np6.separate_bodies()
  Np7.separate_bodies()
  Np8.separate_bodies()
  Np9.separate_bodies()
  Np10.separate_bodies()
  Np11.separate_bodies()
  Np12.separate_bodies()
  Ns1.separate_bodies()
  Ns2.separate_bodies()
  Ns3.separate_bodies()
  Ns4.separate_bodies()
  Ns5.separate_bodies()
  Ns6.separate_bodies()
  Ns7.separate_bodies()
  Ns8.separate_bodies()
  Ns9.separate_bodies()
  Ns10.separate_bodies()
  Ns11.separate_bodies()
  Ns12_Separate1 [copper] = Ns12#7263.separate_bodies()
  [Np1, Np10, Np11, Np12, Np2..Np9, Ns1, Ns10, Ns11, Ns12#7263].split(plane=YZ, keep=PositiveOnly)
  Ns12#7263.delete()
  [Ns2..Ns9, Body1, Body1_3, Ns12_Separate1].split(plane=YZ, keep=PositiveOnly)
  [Ns1..Ns11, Ns12_Separate1, Np12, Np11, Np9, Np10, Np7, Np8, Np6, Np5, Np4, Np3, Np2, Np1].rotate(axis=Z, angle=90deg)
  [Ns1..Ns11, Ns12_Separate1, Np12, Np11, Np9, Np10, Np7, Np8, Np6, Np5, Np4, Np3, Np2, Np1].move(0mm, -4.275mm, 0mm)
  [Ns1..Ns11, Ns12_Separate1, Np12, Np11, Np9, Np10, Np7, Np8, Np6, Np5, Np4, Np3, Np2, Np1].move(4.375mm, 0.075mm, 0mm)
  Ns1.move(0mm, -0.05mm, 0mm)
  Ns2.move(0mm, -0.05mm, 0mm)
  Ns3.move(0mm, -0.05mm, 0mm)
  Ns4.move(0mm, -0.05mm, 0mm)
  Ns5.move(0mm, -0.05mm, 0mm)
  Ns6.move(0mm, -0.05mm, 0mm)
  Ns7.move(0mm, -0.05mm, 0mm)
  Ns8.move(0mm, -0.05mm, 0mm)
  Ns9.move(0mm, -0.05mm, 0mm)
  Ns10.move(0mm, -0.05mm, 0mm)
  Ns11.move(0mm, -0.05mm, 0mm)
  Ns12_Separate1.move(0mm, -0.05mm, 0mm)
  Np12.move(0mm, -0.05mm, 0mm)
  Np11.move(0mm, -0.05mm, 0mm)
  Np9.move(0mm, -0.05mm, 0mm)
  Np10.move(0mm, -0.05mm, 0mm)
  Np7.move(0mm, -0.05mm, 0mm)
  Np8.move(0mm, -0.05mm, 0mm)
  Np6.move(0mm, -0.05mm, 0mm)
  Np5.move(0mm, -0.05mm, 0mm)
  Np4.move(0mm, -0.05mm, 0mm)
  Np3.move(0mm, -0.05mm, 0mm)
  Np2.move(0mm, -0.05mm, 0mm)
  Np1.move(0mm, -0.05mm, 0mm)
  [Ns1..Ns11, Ns12_Separate1, Np12, Np11, Np9, Np10, Np7, Np8, Np6, Np5, Np4, Np3, Np2, Np1].move(0mm, -0.05mm, 0mm)
  group Core = Body1, Body1_3
  group primary = Np1, Np10, Np11, Np12, Np2..Np9
  group secondary = Ns1, Ns10, Ns11, Ns2..Ns9, Ns12_Separate1
boundaries and excitations:
  Balloon1: Balloon Edges=Region.edge(all 4)
  Symmetry1: Symmetry Edges=Region.edge(at (0, 0.05, 0)) IsOdd=true
  Np1: Coil Objects=Np1 Conductor_number=1 Winding=Primary PolarityType=Positive
  Np2: Coil Objects=Np2 Conductor_number=1 Winding=Primary PolarityType=Positive
  Np3: Coil Objects=Np3 Conductor_number=1 Winding=Primary PolarityType=Positive
  Np4: Coil Objects=Np4 Conductor_number=1 Winding=Primary PolarityType=Positive
  Np5: Coil Objects=Np5 Conductor_number=1 Winding=Primary PolarityType=Positive
  Np6: Coil Objects=Np6 Conductor_number=1 Winding=Primary PolarityType=Positive
  Np7: Coil Objects=Np7 Conductor_number=1 Winding=Primary PolarityType=Positive
  Np8: Coil Objects=Np8 Conductor_number=1 Winding=Primary PolarityType=Positive
  Np9: Coil Objects=Np9 Conductor_number=1 Winding=Primary PolarityType=Positive
  Np10: Coil Objects=Np10 Conductor_number=1 Winding=Primary PolarityType=Positive
  Np11: Coil Objects=Np11 Conductor_number=1 Winding=Primary PolarityType=Positive
  Np12: Coil Objects=Np12 Conductor_number=1 Winding=Primary PolarityType=Positive
  Ns1: Coil Objects=Ns1 Conductor_number=1 Winding=Secondary PolarityType=Negative
  Ns2: Coil Objects=Ns2 Conductor_number=1 Winding=Secondary PolarityType=Negative
  Ns3: Coil Objects=Ns3 Conductor_number=1 Winding=Secondary PolarityType=Negative
  Ns4: Coil Objects=Ns4 Conductor_number=1 Winding=Secondary PolarityType=Negative
  Ns5: Coil Objects=Ns5 Conductor_number=1 Winding=Secondary PolarityType=Negative
  Ns6: Coil Objects=Ns6 Conductor_number=1 Winding=Secondary PolarityType=Negative
  Ns7: Coil Objects=Ns7 Conductor_number=1 Winding=Secondary PolarityType=Negative
  Ns8: Coil Objects=Ns8 Conductor_number=1 Winding=Secondary PolarityType=Negative
  Ns9: Coil Objects=Ns9 Conductor_number=1 Winding=Secondary PolarityType=Negative
  Ns10: Coil Objects=Ns10 Conductor_number=1 Winding=Secondary PolarityType=Negative
  Ns11: Coil Objects=Ns11 Conductor_number=1 Winding=Secondary PolarityType=Negative
  Ns12_Separate1: Coil Objects=Ns12_Separate1 Conductor_number=1 Winding=Secondary PolarityType=Negative
  Primary: Winding Group Type=Current IsSolid=true Current=5A ParallelBranchesNum=1 Phase=0deg
  Secondary: Winding Group Type=Current IsSolid=true Current=5A ParallelBranchesNum=1 Phase=0deg
  eddy effects on: Np1, Np10, Np11, Np12, Np2..Np9, Ns1, Ns10, Ns11, Ns2..Ns9, Ns12_Separate1
parameters:
  Matrix1: Matrix Primary, Secondary:
mesh:
  Length1: LengthBased RefineInside Objects=[Body1, Body1_3] MaxLength=2mm
  Length2: LengthBased RefineInside Objects=[Np1..Np12, Ns1..Ns11, Ns12_Separate1] MaxLength=0.05mm
  initial mesh: GlobalSurfApproximation{CurvedSurfaceApproxChoice=UseSlider SliderMeshSettings=9}
setups:
  Setup1: EddyCurrent MaximumPasses=20 MinimumPasses=2 MinimumConvergedPasses=1 PercentRefinement=30 PercentError=1 NonLinearResidual=0.0001 Frequency=10kHz SweepRanges{10Hz to 500000Hz step 1000Hz} SaveAllFields
field plots:
  JAtPhase1: J over Ns12_Separate1, Np12, Ns11, Np11, Ns10, Np10, Ns9, Np9, Ns8, Ns7, Np8, Np7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 on Setup1 : LastAdaptive at Freq=10kHz Phase=0deg
  JAtPhase2: J over Ns1..Ns11, Ns12_Separate1, Np1..Np12 on Setup1 : LastAdaptive at Freq=10kHz Phase=0deg

design Symmetry_Edgewise (Maxwell 2D, EddyCurrent, XY geometry, model units mm)
options: ModelDepth=19.678mm
geometry:
  Np1, Np10, Np11, Np12, Np2..Np9, Ns1, Ns10, Ns11, Ns12, Ns2..Ns9, Body1, Body1_3 = imported_body(C:\Users\karlr\Documents\core_assembled_edgewise v2_0.1.step)
  Np1_Section1 [copper] = Np1.section(plane=ZX)
  Np1.delete()
  Np10_Section1 [copper] = Np10.section(plane=ZX)
  Np10.delete()
  Np11_Section1 [copper] = Np11.section(plane=ZX)
  Np11.delete()
  Np12_Section1 [copper] = Np12.section(plane=ZX)
  Np12.delete()
  Np2_Section1 [copper] = Np2.section(plane=ZX)
  Np2.delete()
  Np3_Section1 [copper] = Np3.section(plane=ZX)
  Np3.delete()
  Np4_Section1 [copper] = Np4.section(plane=ZX)
  Np4.delete()
  Np5_Section1 [copper] = Np5.section(plane=ZX)
  Np5.delete()
  Np6_Section1 [copper] = Np6.section(plane=ZX)
  Np6.delete()
  Np7_Section1 [copper] = Np7.section(plane=ZX)
  Np7.delete()
  Np8_Section1 [copper] = Np8.section(plane=ZX)
  Np8.delete()
  Np9_Section1 [copper] = Np9.section(plane=ZX)
  Np9.delete()
  Ns1_Section1 [copper] = Ns1.section(plane=ZX)
  Ns1.delete()
  Ns10_Section1 [copper] = Ns10.section(plane=ZX)
  Ns10.delete()
  Ns11_Section1 [copper] = Ns11.section(plane=ZX)
  Ns11.delete()
  Ns12_Section1 [copper] = Ns12.section(plane=ZX)
  Ns12.delete()
  Ns2_Section1 [copper] = Ns2.section(plane=ZX)
  Ns2.delete()
  Ns3_Section1 [copper] = Ns3.section(plane=ZX)
  Ns3.delete()
  Ns4_Section1 [copper] = Ns4.section(plane=ZX)
  Ns4.delete()
  Ns5_Section1 [copper] = Ns5.section(plane=ZX)
  Ns5.delete()
  Ns6_Section1 [copper] = Ns6.section(plane=ZX)
  Ns6.delete()
  Ns7_Section1 [copper] = Ns7.section(plane=ZX)
  Ns7.delete()
  Ns8_Section1 [copper] = Ns8.section(plane=ZX)
  Ns8.delete()
  Ns9_Section1 [copper] = Ns9.section(plane=ZX)
  Ns9.delete()
  Body1_Section1 [ferrite] = Body1.section(plane=ZX)
  Body1.delete()
  Body1_3_Section1 [ferrite] = Body1_3.section(plane=ZX)
  Body1_3.delete()
  Np1_Section1.separate_bodies()
  Np2_Section1.separate_bodies()
  Np3_Section1.separate_bodies()
  Np4_Section1.separate_bodies()
  Np5_Section1.separate_bodies()
  Np6_Section1.separate_bodies()
  Np7_Section1.separate_bodies()
  Np8_Section1.separate_bodies()
  Np9_Section1.separate_bodies()
  Np10_Section1.separate_bodies()
  Np11_Section1.separate_bodies()
  Np12_Section1.separate_bodies()
  Ns1_Section1.separate_bodies()
  Ns2_Section1.separate_bodies()
  Ns3_Section1.separate_bodies()
  Ns4_Section1.separate_bodies()
  Ns5_Section1.separate_bodies()
  Ns6_Section1.separate_bodies()
  Ns7_Section1.separate_bodies()
  Ns8_Section1.separate_bodies()
  Ns9_Section1.separate_bodies()
  Ns10_Section1.separate_bodies()
  Ns11_Section1.separate_bodies()
  Ns12_Section1.separate_bodies()
  [Np1_Section1, Np10_Section1, Np11_Section1, Np12_Section1, Np2_Section1, Np3_Section1, Np4_Section1, Np5_Section1, Np6_Section1, Np7_Section1, Np8_Section1, Np9_Section1, Ns1_Section1, Ns10_Section1, Ns11_Section1, Ns12_Section1, Ns2_Section1, Ns3_Section1, Ns4_Section1, Ns5_Section1, Ns6_Section1, Ns7_Section1, Ns8_Section1, Ns9_Section1, Body1_Section1, Body1_3_Section1].move(-8.65mm, 0mm, 0mm)
  [Np1_Section1, Np10_Section1, Np11_Section1, Np12_Section1, Np2_Section1, Np3_Section1, Np4_Section1, Np5_Section1, Np6_Section1, Np7_Section1, Np8_Section1, Np9_Section1, Ns1_Section1, Ns10_Section1, Ns11_Section1, Ns12_Section1, Ns2_Section1, Ns3_Section1, Ns4_Section1, Ns5_Section1, Ns6_Section1, Ns7_Section1, Ns8_Section1, Ns9_Section1, Body1_Section1, Body1_3_Section1].rotate(axis=Z, angle=90deg)
  [Np1_Section1, Np10_Section1, Np11_Section1, Np12_Section1, Np2_Section1, Np3_Section1, Np4_Section1, Np5_Section1, Np6_Section1, Np7_Section1, Np8_Section1, Np9_Section1, Ns1_Section1, Ns10_Section1, Ns11_Section1, Ns12_Section1, Ns2_Section1, Ns3_Section1, Ns4_Section1, Ns5_Section1, Ns6_Section1, Ns7_Section1, Ns8_Section1, Ns9_Section1, Body1_Section1, Body1_3_Section1].rotate(axis=Y, angle=90deg)
  [Np1_Section1, Np10_Section1, Np11_Section1, Np12_Section1, Np2_Section1, Np3_Section1, Np4_Section1, Np5_Section1, Np6_Section1, Np7_Section1, Np8_Section1, Np9_Section1, Ns1_Section1, Ns10_Section1, Ns11_Section1, Ns12_Section1, Ns2_Section1, Ns3_Section1, Ns4_Section1, Ns5_Section1, Ns6_Section1, Ns7_Section1, Ns8_Section1, Ns9_Section1, Body1_Section1, Body1_3_Section1].move(-4.275mm, 0mm, 0mm)
  Region [vacuum] = region(percentage_offset=0 on all sides)
  [Np1_Section1, Np10_Section1, Np11_Section1, Np12_Section1, Np2_Section1, Np3_Section1, Np4_Section1, Np5_Section1, Np6_Section1, Np7_Section1, Np8_Section1, Np9_Section1, Ns1_Section1, Ns10_Section1, Ns11_Section1, Ns12_Section1, Ns2_Section1, Ns3_Section1, Ns4_Section1, Ns5_Section1, Ns6_Section1, Ns7_Section1, Ns8_Section1, Ns9_Section1, Body1_Section1, Body1_3_Section1].split(plane=ZX, keep=PositiveOnly)
  group core_assembled_edgewise = Np1_Section1, Np10_Section1, Np11_Section1, Np12_Section1, Np2_Section1, Np3_Section1, Np4_Section1, Np5_Section1, Np6_Section1, Np7_Section1, Np8_Section1, Np9_Section1, Ns1_Section1, Ns10_Section1, Ns11_Section1, Ns12_Section1, Ns2_Section1, Ns3_Section1, Ns4_Section1, Ns5_Section1, Ns6_Section1, Ns7_Section1, Ns8_Section1, Ns9_Section1
  group core_together_1 = Body1_Section1
  group core_together = Body1_3_Section1
boundaries and excitations:
  Balloon1: Balloon Edges=Region.edge(all 4)
  Np1_Section1: Coil Objects=Np1_Section1 Conductor_number=1 Winding=Primary PolarityType=Positive
  Np2_Section1: Coil Objects=Np2_Section1 Conductor_number=1 Winding=Primary PolarityType=Positive
  Np3_Section1: Coil Objects=Np3_Section1 Conductor_number=1 Winding=Primary PolarityType=Positive
  Np4_Section1: Coil Objects=Np4_Section1 Conductor_number=1 Winding=Primary PolarityType=Positive
  Np5_Section1: Coil Objects=Np5_Section1 Conductor_number=1 Winding=Primary PolarityType=Positive
  Np6_Section1: Coil Objects=Np6_Section1 Conductor_number=1 Winding=Primary PolarityType=Positive
  Np7_Section1: Coil Objects=Np7_Section1 Conductor_number=1 Winding=Primary PolarityType=Positive
  Np8_Section1: Coil Objects=Np8_Section1 Conductor_number=1 Winding=Primary PolarityType=Positive
  Np9_Section1: Coil Objects=Np9_Section1 Conductor_number=1 Winding=Primary PolarityType=Positive
  Np10_Section1: Coil Objects=Np10_Section1 Conductor_number=1 Winding=Primary PolarityType=Positive
  Np11_Section1: Coil Objects=Np11_Section1 Conductor_number=1 Winding=Primary PolarityType=Positive
  Np12_Section1: Coil Objects=Np12_Section1 Conductor_number=1 Winding=Primary PolarityType=Positive
  Ns2_Section1: Coil Objects=Ns2_Section1 Conductor_number=1 Winding=Secondary PolarityType=Negative
  Ns1_Section1: Coil Objects=Ns1_Section1 Conductor_number=1 Winding=Secondary PolarityType=Negative
  Ns3_Section1: Coil Objects=Ns3_Section1 Conductor_number=1 Winding=Secondary PolarityType=Negative
  Ns4_Section1: Coil Objects=Ns4_Section1 Conductor_number=1 Winding=Secondary PolarityType=Negative
  Ns5_Section1: Coil Objects=Ns5_Section1 Conductor_number=1 Winding=Secondary PolarityType=Negative
  Ns6_Section1: Coil Objects=Ns6_Section1 Conductor_number=1 Winding=Secondary PolarityType=Negative
  Ns7_Section1: Coil Objects=Ns7_Section1 Conductor_number=1 Winding=Secondary PolarityType=Negative
  Ns8_Section1: Coil Objects=Ns8_Section1 Conductor_number=1 Winding=Secondary PolarityType=Negative
  Ns9_Section1: Coil Objects=Ns9_Section1 Conductor_number=1 Winding=Secondary PolarityType=Negative
  Ns10_Section1: Coil Objects=Ns10_Section1 Conductor_number=1 Winding=Secondary PolarityType=Negative
  Ns11_Section1: Coil Objects=Ns11_Section1 Conductor_number=1 Winding=Secondary PolarityType=Negative
  Ns12_Section1: Coil Objects=Ns12_Section1 Conductor_number=1 Winding=Secondary PolarityType=Negative
  Primary: Winding Group Type=Current IsSolid=true Current=5A ParallelBranchesNum=1 Phase=0deg
  Secondary: Winding Group Type=Current IsSolid=true Current=5A ParallelBranchesNum=1 Phase=0deg
parameters:
  Matrix1: Matrix Primary, Secondary:
mesh:
  Length1: LengthBased RefineInside Objects=[Body1_Section1, Body1_3_Section1] MaxLength=3.46mm
setups:
  Setup1: EddyCurrent MaximumPasses=10 MinimumPasses=2 MinimumConvergedPasses=1 PercentRefinement=30 PercentError=1 NonLinearResidual=0.0001 Frequency=30000Hz SweepRanges{10Hz to 50000Hz step 1000Hz} SaveAllFields
field plots:
  JAtPhase1, JAtPhase2: J over Np1_Section1, Np2_Section1, Np3_Section1, Np4_Section1, Np5_Section1, Np6_Section1, Np7_Section1, Np8_Section1, Np9_Section1, Np10_Section1, Np11_Section1, Np12_Section1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 on Setup1 : LastAdaptive at Freq=30000Hz Phase=0deg
reports:
  Loss Plot1: SolidLoss vs Freq on Setup1 : LastAdaptive
