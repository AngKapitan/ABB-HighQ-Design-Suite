# Ansys Electronics Desktop project, version 2025.1
materials:
  vacuum: permittivity=1
  aluminum: permeability=1.000021 conductivity=38000000
  ferrite: permittivity=12 permeability=2000 conductivity=0.01
  copper: permeability=0.999991 conductivity=58000000

design Flatwise_100kW (Maxwell 3D, EddyCurrent, model units mm)
geometry:
  Np1..Np4, Ns1..Ns4 [copper] = imported_body(C:\Users\karlr\Documents\core_assembled_flatwise 100kW.step)
  Body1 [ferrite] = imported_body(C:\Users\karlr\Documents\core_assembled_flatwise 100kW.step)
  Body1_1, Body1_2 [aluminum] = imported_body(C:\Users\karlr\Documents\core_assembled_flatwise 100kW.step)
  Body1_3 [ferrite] = imported_body(C:\Users\karlr\Documents\core_assembled_flatwise 100kW.step)
  Body1_4, Body1_5 [aluminum] = imported_body(C:\Users\karlr\Documents\core_assembled_flatwise 100kW.step)
  Region [vacuum] = region(percentage_offset=0 on all sides)
  Np1_Section1 = Np1.section(plane=ZX)
  Np2_Section1 [copper] = Np2.section(plane=ZX)
  Np3_Section1 [copper] = Np3.section(plane=ZX)
  Np4_Section1 [copper] = Np4.section(plane=ZX)
  Ns1_Section1 [copper] = Ns1.section(plane=ZX)
  Ns2_Section1 [copper] = Ns2.section(plane=ZX)
  Ns4_Section1 = Ns4.section(plane=ZX)
  Ns3_Section1 [copper] = Ns3.section(plane=ZX)
  Np1_Section1_Separate1 [copper] = Np1_Section1.separate_bodies()
  Np1_Section1.delete()
  Np2_Section1.separate_bodies()
  Np3_Section1.separate_bodies()
  Np4_Section1.separate_bodies()
  Ns1_Section1.separate_bodies()
  Ns2_Section1.separate_bodies()
  Ns3_Section1.separate_bodies()
  Ns4_Section1_Separate1 [copper] = Ns4_Section1.separate_bodies()
  Ns4_Section1.delete()
  Rectangle1 [non-model] = rectangle(corner=(0mm, 68.27851315mm, 56.9mm), z_size=-56.9mm, x_size=113.8mm)
  group Primary = Np1..Np4, Np2_Section1, Np3_Section1, Np4_Section1, Np1_Section1_Separate1
  group outside = Body1_1, Body1_2, Body1_4, Body1_5
  group Secondaryt = Ns1..Ns4, Ns1_Section1, Ns2_Section1, Ns3_Section1, Ns4_Section1_Separate1
  group Core = Body1, Body1_3
boundaries and excitations:
  CoilTerminal_1: Coil Terminal Objects=Ns4_Section1_Separate1 Conductor_number=1 Winding=Secondary Point_out_of_terminal=false
  CoilTerminal_2: Coil Terminal Objects=Ns3_Section1 Conductor_number=1 Winding=Secondary Point_out_of_terminal=false
  CoilTerminal_3: Coil Terminal Objects=Ns2_Section1 Conductor_number=1 Winding=Secondary Point_out_of_terminal=false
  CoilTerminal_4: Coil Terminal Objects=Ns1_Section1 Conductor_number=1 Winding=Secondary Point_out_of_terminal=false
  CoilTerminal_5: Coil Terminal Objects=Np1_Section1_Separate1 Conductor_number=1 Winding=Primary Point_out_of_terminal=true
  CoilTerminal_6: Coil Terminal Objects=Np2_Section1 Conductor_number=1 Winding=Primary Point_out_of_terminal=true
  CoilTerminal_7: Coil Terminal Objects=Np3_Section1 Conductor_number=1 Winding=Primary Point_out_of_terminal=true
  CoilTerminal_8: Coil Terminal Objects=Np4_Section1 Conductor_number=1 Winding=Primary Point_out_of_terminal=true
  Primary: Winding Group Type=Current IsSolid=true Current=200A ParallelBranchesNum=1 Phase=0deg
  Secondary: Winding Group Type=Current IsSolid=true Current=200A ParallelBranchesNum=1 Phase=0deg
parameters:
  Matrix1: Matrix Primary, Secondary:
mesh:
  Length1: LengthBased Objects=[Ns1..Ns4, Np3, Np4, Np2, Np1] MaxLength=20mm
  Length2: LengthBased Objects=[Body1, Body1_3, Body1_1, Body1_2, Body1_4, Body1_5] MaxLength=20mm
  initial mesh: GlobalCurvilinear{Apply} MeshMethod=AnsoftClassic
setups:
  Setup3: EddyCurrent MaximumPasses=15 MinimumPasses=2 MinimumConvergedPasses=1 PercentRefinement=30 PercentError=3 SolveMatrixAtLast=false NonLinearResidual=0.0001 Frequency=27500Hz LossAdaptiveCtrl=0.5
field plots:
  Mag_J1: J over a plane on Setup3 : LastAdaptive at Freq=27500Hz Phase=0deg

design Edgewise_100kW (Maxwell 3D, EddyCurrent, model units mm)
geometry:
  Np1..Np4, Ns1..Ns4 [copper] = imported_body(C:\Users\karlr\Documents\core_assembled_edgewise 100kW.step)
  Body1 [ferrite] = imported_body(C:\Users\karlr\Documents\core_assembled_edgewise 100kW.step)
  Body1_1, Body1_2 [aluminum] = imported_body(C:\Users\karlr\Documents\core_assembled_edgewise 100kW.step)
  Body1_3 [ferrite] = imported_body(C:\Users\karlr\Documents\core_assembled_edgewise 100kW.step)
  Body1_4, Body1_5 [aluminum] = imported_body(C:\Users\karlr\Documents\core_assembled_edgewise 100kW.step)
  Ns1_Section1 [copper] = Ns1.section(plane=ZX)
  Ns2_Section1 [copper] = Ns2.section(plane=ZX)
  Ns3_Section1 [copper] = Ns3.section(plane=ZX)
  Ns4_Section1 = Ns4.section(plane=ZX)
  Np4_Section1 [copper] = Np4.section(plane=ZX)
  Np3_Section1 [copper] = Np3.section(plane=ZX)
  Np2_Section1 [copper] = Np2.section(plane=ZX)
  Np1_Section1 [copper] = Np1.section(plane=ZX)
  Ns1_Section1.separate_bodies()
  Ns2_Section1.separate_bodies()
  Ns3_Section1.separate_bodies()
  Ns4_Section1_Separate1 [copper] = Ns4_Section1.separate_bodies()
  Ns4_Section1.delete()
  Np4_Section1.separate_bodies()
  Np3_Section1.separate_bodies()
  Np2_Section1.separate_bodies()
  Np1_Section1.separate_bodies()
  Region [vacuum] = region(percentage_offset=0 on all sides)
  Rectangle1 [non-model] = rectangle(corner=(113.8mm, 68.27851315mm, 0mm), z_size=56.9mm, x_size=-113.8mm)
  group Core_1 = Body1, Body1_3
  group Outside_1 = Body1_1, Body1_2, Body1_4, Body1_5
  group Primary_1 = Np1..Np4, Np4_Section1, Np3_Section1, Np2_Section1, Np1_Section1
  group Secondary = Ns1..Ns4, Ns1_Section1, Ns2_Section1, Ns3_Section1, Ns4_Section1_Separate1
boundaries and excitations:
  CoilTerminal_1: Coil Terminal Objects=Ns1_Section1 Conductor_number=1 Winding=Secondary Point_out_of_terminal=true
  CoilTerminal_2: Coil Terminal Objects=Ns2_Section1 Conductor_number=1 Winding=Secondary Point_out_of_terminal=true
  CoilTerminal_3: Coil Terminal Objects=Ns3_Section1 Conductor_number=1 Winding=Secondary Point_out_of_terminal=true
  CoilTerminal_4: Coil Terminal Objects=Ns4_Section1_Separate1 Conductor_number=1 Winding=Secondary Point_out_of_terminal=true
  CoilTerminal_5: Coil Terminal Objects=Np1_Section1 Conductor_number=1 Winding=Primary Point_out_of_terminal=false
  CoilTerminal_6: Coil Terminal Objects=Np2_Section1 Conductor_number=1 Winding=Primary Point_out_of_terminal=false
  CoilTerminal_7: Coil Terminal Objects=Np3_Section1 Conductor_number=1 Winding=Primary Point_out_of_terminal=false
  CoilTerminal_8: Coil Terminal Objects=Np4_Section1 Conductor_number=1 Winding=Primary Point_out_of_terminal=false
  Primary: Winding Group Type=Current IsSolid=true Current=200A ParallelBranchesNum=1 Phase=0deg
  Secondary: Winding Group Type=Current IsSolid=true Current=200A ParallelBranchesNum=1 Phase=0deg
parameters:
  Matrix1: Matrix Primary, Secondary:
mesh:
  Length1: LengthBased Objects=[Np1..Np4, Ns1, Ns3, Ns2, Ns4] MaxLength=20mm
  Length2: LengthBased Objects=[Body1, Body1_3, Body1_1, Body1_2, Body1_4, Body1_5] MaxLength=20mm
  initial mesh: GlobalCurvilinear{Apply} MeshMethod=AnsoftClassic
setups:
  Setup3: EddyCurrent MaximumPasses=15 MinimumPasses=2 MinimumConvergedPasses=1 PercentRefinement=30 PercentError=3 SolveMatrixAtLast=false NonLinearResidual=0.0001 Frequency=27500Hz LossAdaptiveCtrl=0.5
field plots:
  Mag_J1, Mag_J2, Mag_J3: J over a plane on Setup3 : LastAdaptive at Freq=27500Hz Phase=0deg

design Flatwise_100kW_quarter (Maxwell 3D, EddyCurrent, model units mm)
geometry:
  Np1..Np4, Ns1..Ns4 [copper] = imported_body(C:\Users\karlr\Documents\core_assembled_flatwise 100kW.step)
  Body1 [ferrite] = imported_body(C:\Users\karlr\Documents\core_assembled_flatwise 100kW.step)
  Body1_2 [aluminum] = imported_body(C:\Users\karlr\Documents\core_assembled_flatwise 100kW.step)
  Body1_3 [ferrite] = imported_body(C:\Users\karlr\Documents\core_assembled_flatwise 100kW.step)
  Body1_5 [aluminum] = imported_body(C:\Users\karlr\Documents\core_assembled_flatwise 100kW.step)
  Region [vacuum] = region(percentage_offset=0 on all sides)
  [Np1..Np4, Ns1..Ns4, Body1, Body1_2, Body1_3, Body1_5].move(0mm, -68.27851315mm, 0mm)
  [Np1..Np4, Ns1..Ns4, Body1, Body1_2, Body1_3, Body1_5].move(-56.9mm, 0mm, 0mm)
  [Np1..Np4, Ns1..Ns4, Body1, Body1_2, Body1_3, Body1_5].split(plane=YZ, keep=PositiveOnly)
  [Np1..Np4, Ns1..Ns4, Body1, Body1_2, Body1_3, Body1_5].split(plane=ZX, keep=PositiveOnly)
  group Primary = Np1..Np4
  group outside = Body1_2, Body1_5
  group Secondaryt = Ns1..Ns4
  group Core = Body1, Body1_3
boundaries and excitations:
  Symmetry1: Symmetry Faces=Region.face(-y) IsOdd=true
  Symmetry2: Symmetry Faces=Region.face(-x) IsOdd=true
  CoilTerminal_1: Coil Terminal Faces=Np1.face(at (21.1, 0, 28.35)) Conductor_number=1 Winding=Primary Point_out_of_terminal=false
  CoilTerminal_2: Coil Terminal Faces=Np2.face(at (25.3, 0, 28.35)) Conductor_number=1 Winding=Primary Point_out_of_terminal=false
  CoilTerminal_3: Coil Terminal Faces=Np3.face(at (29.5, 0, 28.35)) Conductor_number=1 Winding=Primary Point_out_of_terminal=false
  CoilTerminal_4: Coil Terminal Faces=Np4.face(at (33.7, 0, 28.35)) Conductor_number=1 Winding=Primary Point_out_of_terminal=false
  CoilTerminal_5: Coil Terminal Faces=Np1.face(at (0, 69.4785, 28.35)) Conductor_number=1 Winding=Primary Point_out_of_terminal=true
  CoilTerminal_6: Coil Terminal Faces=Np2.face(at (0, 73.6785, 28.35)) Conductor_number=1 Winding=Primary Point_out_of_terminal=true
  CoilTerminal_7: Coil Terminal Faces=Np3.face(at (0, 77.8785, 28.35)) Conductor_number=1 Winding=Primary Point_out_of_terminal=true
  CoilTerminal_8: Coil Terminal Faces=Np4.face(at (0, 82.0785, 28.35)) Conductor_number=1 Winding=Primary Point_out_of_terminal=true
  CoilTerminal_9: Coil Terminal Faces=Ns1.face(at (23.2, 0, 28.35)) Conductor_number=1 Winding=Secondary Point_out_of_terminal=true
  CoilTerminal_10: Coil Terminal Faces=Ns2.face(at (27.4, 0, 28.35)) Conductor_number=1 Winding=Secondary Point_out_of_terminal=true
  CoilTerminal_11: Coil Terminal Faces=Ns3.face(at (31.6, 0, 28.35)) Conductor_number=1 Winding=Secondary Point_out_of_terminal=true
  CoilTerminal_12: Coil Terminal Faces=Ns4.face(at (35.8, 0, 28.35)) Conductor_number=1 Winding=Secondary Point_out_of_terminal=true
  CoilTerminal_13: Coil Terminal Faces=Ns4.face(at (0, 84.1785, 28.35)) Conductor_number=1 Winding=Secondary Point_out_of_terminal=false
  CoilTerminal_14: Coil Terminal Faces=Ns3.face(at (0, 79.9785, 28.35)) Conductor_number=1 Winding=Secondary Point_out_of_terminal=false
  CoilTerminal_15: Coil Terminal Faces=Ns2.face(at (0, 75.7785, 28.35)) Conductor_number=1 Winding=Secondary Point_out_of_terminal=false
  CoilTerminal_16: Coil Terminal Faces=Ns1.face(at (0, 71.5785, 28.35)) Conductor_number=1 Winding=Secondary Point_out_of_terminal=false
  Primary: Winding Group Type=Current IsSolid=true Current=200A ParallelBranchesNum=1 Phase=0deg
  Secondary: Winding Group Type=Current IsSolid=true Current=200A ParallelBranchesNum=1 Phase=0deg
parameters:
  Matrix1: Matrix Primary, Secondary:
mesh:
  Length1: LengthBased Objects=[Ns1..Ns4, Np3, Np4, Np2, Np1] MaxLength=20mm
  Length2: LengthBased Objects=[Body1, Body1_3, Body1_2, Body1_5] MaxLength=20mm
  initial mesh: GlobalCurvilinear{Apply} MeshMethod=AnsoftClassic
setups:
  Setup3: EddyCurrent MaximumPasses=15 MinimumPasses=2 MinimumConvergedPasses=1 PercentRefinement=30 PercentError=3 SolveMatrixAtLast=false NonLinearResidual=0.0001 Frequency=27500Hz LossAdaptiveCtrl=0.5

design Edgewise_100kW_quarter (Maxwell 3D, EddyCurrent, model units mm)
geometry:
  Np1..Np4, Ns1..Ns4 [copper] = imported_body(C:\Users\karlr\Documents\core_assembled_edgewise 100kW.step)
  Body1 [ferrite] = imported_body(C:\Users\karlr\Documents\core_assembled_edgewise 100kW.step)
  Body1_2 [aluminum] = imported_body(C:\Users\karlr\Documents\core_assembled_edgewise 100kW.step)
  Body1_3 [ferrite] = imported_body(C:\Users\karlr\Documents\core_assembled_edgewise 100kW.step)
  Body1_5 [aluminum] = imported_body(C:\Users\karlr\Documents\core_assembled_edgewise 100kW.step)
  Region [vacuum] = region(percentage_offset=0 on all sides)
  [Np1..Np4, Ns1..Ns4, Body1, Body1_2, Body1_3, Body1_5].move(0mm, -68.27851315mm, -28.45mm)
  [Np1..Np4, Ns1..Ns4, Body1, Body1_2, Body1_3, Body1_5].move(-56.9mm, 0mm, 1.0658141e-14mm)
  [Np1..Np4, Ns1..Ns4, Body1, Body1_2, Body1_3, Body1_5].split(plane=ZX, keep=PositiveOnly)
  [Np1..Np4, Ns1..Ns4, Body1, Body1_2, Body1_3, Body1_5].split(plane=YZ, keep=PositiveOnly)
  group Core_1 = Body1, Body1_3
  group Outside_1 = Body1_2, Body1_5
  group Primary_1 = Np1..Np4
  group Secondary = Ns1..Ns4
boundaries and excitations:
  Symmetry1: Symmetry Faces=Region.face(-y) IsOdd=true
  Symmetry2: Symmetry Faces=Region.face(-x) IsOdd=true
  CoilTerminal_1: Coil Terminal Faces=Np1.face(at (28.45, 0, 7.35)) Conductor_number=1 Winding=Primary Point_out_of_terminal=false
  CoilTerminal_2: Coil Terminal Faces=Np2.face(at (28.45, 0, 3.15)) Conductor_number=1 Winding=Primary Point_out_of_terminal=false
  CoilTerminal_3: Coil Terminal Faces=Np3.face(at (28.45, 0, -1.05)) Conductor_number=1 Winding=Primary Point_out_of_terminal=false
  CoilTerminal_4: Coil Terminal Faces=Np4.face(at (28.45, 0, -5.25)) Conductor_number=1 Winding=Primary Point_out_of_terminal=false
  CoilTerminal_5: Coil Terminal Faces=Ns1.face(at (28.45, 0, 5.25)) Conductor_number=1 Winding=Secondary Point_out_of_terminal=true
  CoilTerminal_6: Coil Terminal Faces=Ns2.face(at (28.45, 0, 1.05)) Conductor_number=1 Winding=Secondary Point_out_of_terminal=true
  CoilTerminal_7: Coil Terminal Faces=Ns3.face(at (28.45, 0, -3.15)) Conductor_number=1 Winding=Secondary Point_out_of_terminal=true
  CoilTerminal_8: Coil Terminal Faces=Ns4.face(at (28.45, 0, -7.35)) Conductor_number=1 Winding=Secondary Point_out_of_terminal=true
  CoilTerminal_9: Coil Terminal Faces=Np1.face(at (0, 76.7285, 7.35)) Conductor_number=1 Winding=Primary Point_out_of_terminal=true
  CoilTerminal_10: Coil Terminal Faces=Np2.face(at (0, 76.7285, 3.15)) Conductor_number=1 Winding=Primary Point_out_of_terminal=true
  CoilTerminal_11: Coil Terminal Faces=Np3.face(at (0, 76.7285, -1.05)) Conductor_number=1 Winding=Primary Point_out_of_terminal=true
  CoilTerminal_12: Coil Terminal Faces=Np4.face(at (0, 76.7285, -5.25)) Conductor_number=1 Winding=Primary Point_out_of_terminal=true
  CoilTerminal_13: Coil Terminal Faces=Ns1.face(at (0, 76.7285, 5.25)) Conductor_number=1 Winding=Secondary Point_out_of_terminal=false
  CoilTerminal_14: Coil Terminal Faces=Ns2.face(at (0, 76.7285, 1.05)) Conductor_number=1 Winding=Secondary Point_out_of_terminal=false
  CoilTerminal_15: Coil Terminal Faces=Ns3.face(at (0, 76.7285, -3.15)) Conductor_number=1 Winding=Secondary Point_out_of_terminal=false
  CoilTerminal_16: Coil Terminal Faces=Ns4.face(at (0, 76.7285, -7.35)) Conductor_number=1 Winding=Secondary Point_out_of_terminal=false
  Primary: Winding Group Type=Current IsSolid=true Current=200A ParallelBranchesNum=1 Phase=0deg
  Secondary: Winding Group Type=Current IsSolid=true Current=200A ParallelBranchesNum=1 Phase=0deg
parameters:
  Matrix1: Matrix Primary, Secondary:
mesh:
  Length1: LengthBased Objects=[Np1..Np4, Ns1, Ns3, Ns2, Ns4] MaxLength=20mm
  Length2: LengthBased Objects=[Body1, Body1_3, Body1_2, Body1_5] MaxLength=20mm
  initial mesh: GlobalCurvilinear{Apply} MeshMethod=AnsoftClassic
setups:
  Setup3: EddyCurrent MaximumPasses=20 MinimumPasses=2 MinimumConvergedPasses=1 PercentRefinement=30 PercentError=1 SolveMatrixAtLast=false NonLinearResidual=0.0001 Frequency=27500Hz LossAdaptiveCtrl=0.5

design Flatwise_2D 100 kW (Maxwell 2D, EddyCurrent, XY geometry, model units mm)
options: ModelDepth=136.5570263mm
geometry:
  Np1#6, Np2#58, Np3#110, Np4#162, Ns1#214, Ns2#266, Ns3#318, Ns4#370, Body1#874, Body1_3#1054 = imported_body(C:\Users\karlr\Documents\core_assembled_flatwise 100kW.step)
  Region [vacuum] = region(percentage_offset=0 on all sides)
  Np1 [copper] = Np1#6.section(plane=ZX)
  Np1#6.delete()
  Np1.rotate(axis=X, angle=-90deg)
  Np2 [copper] = Np2#58.section(plane=ZX)
  Np2#58.delete()
  Np2.rotate(axis=X, angle=-90deg)
  Np3 [copper] = Np3#110.section(plane=ZX)
  Np3#110.delete()
  Np3.rotate(axis=X, angle=-90deg)
  Np4 [copper] = Np4#162.section(plane=ZX)
  Np4#162.delete()
  Np4.rotate(axis=X, angle=-90deg)
  Ns1 [copper] = Ns1#214.section(plane=ZX)
  Ns1#214.delete()
  Ns1.rotate(axis=X, angle=-90deg)
  Ns2 [copper] = Ns2#266.section(plane=ZX)
  Ns2#266.delete()
  Ns2.rotate(axis=X, angle=-90deg)
  Ns3 [copper] = Ns3#318.section(plane=ZX)
  Ns3#318.delete()
  Ns3.rotate(axis=X, angle=-90deg)
  Ns4 [copper] = Ns4#370.section(plane=ZX)
  Ns4#370.delete()
  Ns4.rotate(axis=X, angle=-90deg)
  Body1 [ferrite] = Body1#874.section(plane=ZX)
  Body1#874.delete()
  Body1.rotate(axis=X, angle=-90deg)
  Body1_3 [ferrite] = Body1_3#1054.section(plane=ZX)
  Body1_3#1054.delete()
  Body1_3.rotate(axis=X, angle=-90deg)
  Np1_Separate1 [copper] = Np1.separate_bodies()
  Np2_Separate1 [copper] = Np2.separate_bodies()
  Np3_Separate1 [copper] = Np3.separate_bodies()
  Np4_Separate1 [copper] = Np4.separate_bodies()
  Ns1_Separate1 [copper] = Ns1.separate_bodies()
  Ns2_Separate1 [copper] = Ns2.separate_bodies()
  Ns3_Separate1 [copper] = Ns3.separate_bodies()
  Ns4_Separate1 [copper] = Ns4.separate_bodies()
  group Primary = Np1..Np4, Np1_Separate1, Np2_Separate1, Np3_Separate1, Np4_Separate1
  group Secondaryt = Ns1..Ns4, Ns1_Separate1, Ns2_Separate1, Ns3_Separate1, Ns4_Separate1
  group Core = Body1, Body1_3
boundaries and excitations:
  Balloon1: Balloon Edges=Region.edge(all 4)
  Np2: Coil Objects=Np2 Conductor_number=1 Winding=Primary PolarityType=Positive
  Np3: Coil Objects=Np3 Conductor_number=1 Winding=Primary PolarityType=Positive
  Np4: Coil Objects=Np4 Conductor_number=1 Winding=Primary PolarityType=Positive
  Np1_Separate1: Coil Objects=Np1_Separate1 Conductor_number=1 Winding=Primary PolarityType=Positive
  Np2_Separate1: Coil Objects=Np2_Separate1 Conductor_number=1 Winding=Primary PolarityType=Negative
  Np3_Separate1: Coil Objects=Np3_Separate1 Conductor_number=1 Winding=Primary PolarityType=Negative
  Np4_Separate1: Coil Objects=Np4_Separate1 Conductor_number=1 Winding=Primary PolarityType=Negative
  Np1: Coil Objects=Np1 Conductor_number=1 Winding=Primary PolarityType=Negative
  Ns1_Separate1: Coil Objects=Ns1_Separate1 Conductor_number=1 Winding=Secondary PolarityType=Positive
  Ns2_Separate1: Coil Objects=Ns2_Separate1 Conductor_number=1 Winding=Secondary PolarityType=Positive
  Ns3_Separate1: Coil Objects=Ns3_Separate1 Conductor_number=1 Winding=Secondary PolarityType=Positive
  Ns4: Coil Objects=Ns4 Conductor_number=1 Winding=Secondary PolarityType=Positive
  Ns1: Coil Objects=Ns1 Conductor_number=1 Winding=Secondary PolarityType=Negative
  Ns2: Coil Objects=Ns2 Conductor_number=1 Winding=Secondary PolarityType=Negative
  Ns3: Coil Objects=Ns3 Conductor_number=1 Winding=Secondary PolarityType=Negative
  Ns4_Separate1: Coil Objects=Ns4_Separate1 Conductor_number=1 Winding=Secondary PolarityType=Negative
  Primary: Winding Group Type=Current IsSolid=true Current=200A ParallelBranchesNum=1 Phase=0deg
  Secondary: Winding Group Type=Current IsSolid=true Current=200A ParallelBranchesNum=1 Phase=0deg
parameters:
  Matrix1: Matrix Primary, Secondary:
mesh:
  Length1: LengthBased RefineInside Objects=[Body1, Body1_3] MaxLength=2mm
  Length2: LengthBased RefineInside Objects=[Np1, Np1_Separate1, Np2, Np2_Separate1, Np3, Np3_Separate1, Np4, Np4_Separate1, Ns1, Ns1_Separate1, Ns2, Ns2_Separate1, Ns3, Ns3_Separate1, Ns4, Ns4_Separate1] MaxLength=0.05mm
setups:
  Setup1: EddyCurrent MaximumPasses=20 MinimumPasses=2 MinimumConvergedPasses=1 PercentRefinement=30 PercentError=0.5 NonLinearResidual=0.0001 Frequency=27500Hz
field plots:
  JAtPhase1: J over Ns1, Ns1_Separate1, Ns2, Ns2_Separate1, Ns3, Ns3_Separate1, Ns4, Ns4_Separate1, Np1, Np1_Separate1, Np2, Np2_Separate1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 on Setup1 : LastAdaptive at Freq=27500Hz Phase=0deg
  Mesh1: MeshPlots over Region, Np1..Np4, Ns1..Ns4, Body1, Body1_3, Np1_Separate1, Np2_Separate1, Np3_Separate1, Np4_Separate1, Ns1_Separate1, Ns2_Separate1, Ns3_Separate1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 on Setup1 : LastAdaptive at Freq=27500Hz Phase=0deg

design Edgewise_2D 100 kW (Maxwell 2D, EddyCurrent, XY geometry, model units mm)
options: ModelDepth=136.5570263mm
geometry:
  Np1#1475, Np2#1527, Np3#1579, Np4#1631, Ns1#1683, Ns2#1735, Ns3#1787, Ns4#1839, Body1#2343, Body1_3#2523 = imported_body(C:\Users\karlr\Documents\core_assembled_edgewise 100kW.step)
  Region [vacuum] = region(percentage_offset=0 on all sides)
  Np1 [copper] = Np1#1475.section(plane=ZX)
  Np1#1475.delete()
  Np1.rotate(axis=X, angle=-90deg)
  Np2 [copper] = Np2#1527.section(plane=ZX)
  Np2#1527.delete()
  Np2.rotate(axis=X, angle=-90deg)
  Np3 [copper] = Np3#1579.section(plane=ZX)
  Np3#1579.delete()
  Np3.rotate(axis=X, angle=-90deg)
  Np4 [copper] = Np4#1631.section(plane=ZX)
  Np4#1631.delete()
  Np4.rotate(axis=X, angle=-90deg)
  Ns1 [copper] = Ns1#1683.section(plane=ZX)
  Ns1#1683.delete()
  Ns1.rotate(axis=X, angle=-90deg)
  Ns2 [copper] = Ns2#1735.section(plane=ZX)
  Ns2#1735.delete()
  Ns2.rotate(axis=X, angle=-90deg)
  Ns3 [copper] = Ns3#1787.section(plane=ZX)
  Ns3#1787.delete()
  Ns3.rotate(axis=X, angle=-90deg)
  Ns4 [copper] = Ns4#1839.section(plane=ZX)
  Ns4#1839.delete()
  Ns4.rotate(axis=X, angle=-90deg)
  Body1 [ferrite] = Body1#2343.section(plane=ZX)
  Body1#2343.delete()
  Body1.rotate(axis=X, angle=-90deg)
  Body1_3 [ferrite] = Body1_3#2523.section(plane=ZX)
  Body1_3#2523.delete()
  Body1_3.rotate(axis=X, angle=-90deg)
  Ns1_Separate1 [copper] = Ns1.separate_bodies()
  Ns2_Separate1 [copper] = Ns2.separate_bodies()
  Ns3_Separate1 [copper] = Ns3.separate_bodies()
  Ns4_Separate1 [copper] = Ns4.separate_bodies()
  Np1_Separate1 [copper] = Np1.separate_bodies()
  Np2_Separate1 [copper] = Np2.separate_bodies()
  Np3_Separate1 [copper] = Np3.separate_bodies()
  Np4_Separate1 [copper] = Np4.separate_bodies()
  group Core_1 = Body1, Body1_3
  group Primary_1 = Np1..Np4, Np1_Separate1, Np2_Separate1, Np3_Separate1, Np4_Separate1
  group Secondary = Ns1..Ns4, Ns1_Separate1, Ns2_Separate1, Ns3_Separate1, Ns4_Separate1
boundaries and excitations:
  Balloon1: Balloon Edges=Region.edge(all 4)
  Ns1: Coil Objects=Ns1 Conductor_number=1 Winding=Secondary PolarityType=Positive
  Ns2: Coil Objects=Ns2 Conductor_number=1 Winding=Secondary PolarityType=Positive
  Ns3: Coil Objects=Ns3 Conductor_number=1 Winding=Secondary PolarityType=Positive
  Ns4_Separate1: Coil Objects=Ns4_Separate1 Conductor_number=1 Winding=Secondary PolarityType=Positive
  Ns1_Separate1: Coil Objects=Ns1_Separate1 Conductor_number=1 Winding=Secondary PolarityType=Negative
  Ns2_Separate1: Coil Objects=Ns2_Separate1 Conductor_number=1 Winding=Secondary PolarityType=Negative
  Ns3_Separate1: Coil Objects=Ns3_Separate1 Conductor_number=1 Winding=Secondary PolarityType=Negative
  Ns4: Coil Objects=Ns4 Conductor_number=1 Winding=Secondary PolarityType=Negative
  Np1: Coil Objects=Np1 Conductor_number=1 Winding=Primary PolarityType=Negative
  Np2: Coil Objects=Np2 Conductor_number=1 Winding=Primary PolarityType=Negative
  Np3: Coil Objects=Np3 Conductor_number=1 Winding=Primary PolarityType=Negative
  Np4: Coil Objects=Np4 Conductor_number=1 Winding=Primary PolarityType=Negative
  Np1_Separate1: Coil Objects=Np1_Separate1 Conductor_number=1 Winding=Primary PolarityType=Positive
  Np2_Separate1: Coil Objects=Np2_Separate1 Conductor_number=1 Winding=Primary PolarityType=Positive
  Np3_Separate1: Coil Objects=Np3_Separate1 Conductor_number=1 Winding=Primary PolarityType=Positive
  Np4_Separate1: Coil Objects=Np4_Separate1 Conductor_number=1 Winding=Primary PolarityType=Positive
  Secondary: Winding Group Type=Current IsSolid=true Current=200A ParallelBranchesNum=1 Phase=0deg
  Primary: Winding Group Type=Current IsSolid=true Current=200A ParallelBranchesNum=1 Phase=0deg
parameters:
  Matrix1: Matrix Primary, Secondary:
mesh:
  Length1: LengthBased RefineInside Objects=[Np1, Np1_Separate1, Np2, Np2_Separate1, Np3, Np3_Separate1, Np4, Np4_Separate1, Ns1, Ns1_Separate1, Ns2, Ns2_Separate1, Ns3, Ns3_Separate1, Ns4, Ns4_Separate1] MaxLength=0.2mm
  Length2: LengthBased RefineInside Objects=[Body1, Body1_3] MaxLength=2mm
setups:
  Setup1: EddyCurrent MaximumPasses=20 MinimumPasses=2 MinimumConvergedPasses=1 PercentRefinement=30 PercentError=0.5 ConstantDelta=0s NonLinearResidual=0.0001 Frequency=27500Hz SweepRanges{10Hz to 50000Hz step 1000Hz} SaveAllFields
field plots:
  JAtPhase1: J over Ns1, Ns1_Separate1, Ns2, Ns2_Separate1, Ns3, Ns3_Separate1, Ns4, Ns4_Separate1, Np1, Np1_Separate1, Np2, Np2_Separate1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 on Setup1 : LastAdaptive at Freq=27500Hz Phase=0deg
  Mesh1: MeshPlots over Region, Np1..Np4, Ns1..Ns4, Body1, Body1_3, Ns1_Separate1, Ns2_Separate1, Ns3_Separate1, Ns4_Separate1, Np1_Separate1, Np2_Separate1, Np3_Separate1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 on Setup1 : LastAdaptive at Freq=27500Hz Phase=0deg
  JAtPhase2: J over Np1, Np1_Separate1, Np2, Np2_Separate1, Np3, Np3_Separate1, Np4, Np4_Separate1, Ns1, Ns1_Separate1, Ns2, Ns2_Separate1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 on Setup1 : LastAdaptive at Freq=27500Hz Phase=0deg
reports:
  Loss Plot1: SolidLoss vs Freq on Setup1 : LastAdaptive

design Flatwise_100kW_corrected (Maxwell 3D, EddyCurrent, model units mm)
geometry:
  Np1..Np4, Ns1..Ns4 [copper] = imported_body(C:\Users\karlr\Documents\core_assembled_flatwise_100kW_revised.step)
  Body1 [ferrite] = imported_body(C:\Users\karlr\Documents\core_assembled_flatwise_100kW_revised.step)
  Body1_1, Body1_2 [aluminum] = imported_body(C:\Users\karlr\Documents\core_assembled_flatwise_100kW_revised.step)
  Body1_3 [ferrite] = imported_body(C:\Users\karlr\Documents\core_assembled_flatwise_100kW_revised.step)
  Body1_4, Body1_5 [aluminum] = imported_body(C:\Users\karlr\Documents\core_assembled_flatwise_100kW_revised.step)
  Region [vacuum] = region(percentage_offset=0 on all sides)
  Np1_Section1 [copper] = Np1.section(plane=ZX)
  Np2_Section1 [copper] = Np2.section(plane=ZX)
  Np3_Section1 [copper] = Np3.section(plane=ZX)
  Np4_Section1 [copper] = Np4.section(plane=ZX)
  Ns1_Section1 [copper] = Ns1.section(plane=ZX)
  Ns2_Section1 [copper] = Ns2.section(plane=ZX)
  Ns3_Section1 [copper] = Ns3.section(plane=ZX)
  Ns4_Section1 = Ns4.section(plane=ZX)
  Ns4_Section1_Separate1 [copper] = Ns4_Section1.separate_bodies()
  Ns4_Section1.delete()
  Ns3_Section1.separate_bodies()
  Ns2_Section1.separate_bodies()
  Ns1_Section1.separate_bodies()
  Np4_Section1.separate_bodies()
  Np3_Section1.separate_bodies()
  Np2_Section1.separate_bodies()
  Np1_Section1.separate_bodies()
  Rectangle1 [non-model] = rectangle(corner=(113.8mm, 68.27851315mm, 0mm), z_size=56.9mm, x_size=-113.8mm)
  group core_assembled_flatwise = Np1..Np4, Ns1..Ns4, Np1_Section1, Np2_Section1, Np3_Section1, Np4_Section1, Ns1_Section1, Ns2_Section1, Ns3_Section1, Ns4_Section1_Separate1
  group core_together_1 = Body1_1, Body1_2
  group core_together = Body1_4, Body1_5
  group core = Body1, Body1_3
boundaries and excitations:
  primary_1: Coil Terminal Objects=Np1_Section1 Conductor_number=1 Winding=primary Point_out_of_terminal=false
  primary_2: Coil Terminal Objects=Np2_Section1 Conductor_number=1 Winding=primary Point_out_of_terminal=false
  primary_3: Coil Terminal Objects=Np3_Section1 Conductor_number=1 Winding=primary Point_out_of_terminal=false
  primary_4: Coil Terminal Objects=Np4_Section1 Conductor_number=1 Winding=primary Point_out_of_terminal=false
  secondary_1: Coil Terminal Objects=Ns1_Section1 Conductor_number=1 Winding=secondary Point_out_of_terminal=true
  secondary_2: Coil Terminal Objects=Ns2_Section1 Conductor_number=1 Winding=secondary Point_out_of_terminal=true
  secondary_3: Coil Terminal Objects=Ns3_Section1 Conductor_number=1 Winding=secondary Point_out_of_terminal=true
  secondary_4: Coil Terminal Objects=Ns4_Section1_Separate1 Conductor_number=1 Winding=secondary Point_out_of_terminal=true
  primary: Winding Group Type=Current IsSolid=true Current=200A ParallelBranchesNum=1 Phase=0deg
  secondary: Winding Group Type=Current IsSolid=true Current=200A ParallelBranchesNum=1 Phase=0deg
parameters:
  Matrix1: Matrix primary, secondary:
mesh:
  Length1: LengthBased Objects=[Np1..Np4, Ns1..Ns4] MaxLength=20mm
  Length2: LengthBased Objects=[Body1_1, Body1_2, Body1_5, Body1_4, Body1_3, Body1] MaxLength=20mm
  initial mesh: GlobalCurvilinear{Apply}
setups:
  Setup1: EddyCurrent MaximumPasses=20 MinimumPasses=2 MinimumConvergedPasses=1 PercentRefinement=30 PercentError=3 ConstantDelta=0s NonLinearResidual=0.0001 Frequency=27500Hz LossAdaptiveCtrl=0.5
field plots:
  Mag_J1: J over a plane on Setup1 : LastAdaptive at Freq=27500Hz Phase=0deg

design Flatwise_100kW_q_revised (Maxwell 3D, EddyCurrent, model units mm)
geometry:
  Np1..Np4, Ns1..Ns4 [copper] = imported_body(C:\Users\karlr\Documents\core_assembled_flatwise_100kW_revised.step)
  Body1 [ferrite] = imported_body(C:\Users\karlr\Documents\core_assembled_flatwise_100kW_revised.step)
  Body1_1 [aluminum] = imported_body(C:\Users\karlr\Documents\core_assembled_flatwise_100kW_revised.step)
  Body1_3 [ferrite] = imported_body(C:\Users\karlr\Documents\core_assembled_flatwise_100kW_revised.step)
  Body1_5 [aluminum] = imported_body(C:\Users\karlr\Documents\core_assembled_flatwise_100kW_revised.step)
  Region [vacuum] = region(percentage_offset=0 on all sides)
  [Np1..Np4, Ns1..Ns4, Body1, Body1_1, Body1_3, Body1_5].move(0mm, -68.27851315mm, -1.6666796e-08mm)
  [Np1..Np4, Ns1..Ns4, Body1, Body1_1, Body1_3, Body1_5].move(-56.9mm, 0mm, 0mm)
  [Np1..Np4, Ns1..Ns4, Body1, Body1_1, Body1_3, Body1_5].split(plane=ZX, keep=PositiveOnly)
  [Np1..Np4, Ns1..Ns4, Body1, Body1_1, Body1_3, Body1_5].split(plane=YZ, keep=PositiveOnly)
  group core_assembled_flatwise = Np1..Np4, Ns1..Ns4
  group core_together_1 = Body1_1
  group core_together = Body1_5
  group core = Body1, Body1_3
boundaries and excitations:
  Symmetry1: Symmetry Faces=Region.face(-y) IsOdd=true
  Symmetry2: Symmetry Faces=Region.face(-x) IsOdd=true
  p_1: Coil Terminal Faces=Np1.face(at (21.1, 0, 28.45)) Conductor_number=1 Winding=primary Point_out_of_terminal=false
  p_2: Coil Terminal Faces=Np2.face(at (25.3, 0, 28.45)) Conductor_number=1 Winding=primary Point_out_of_terminal=false
  p_3: Coil Terminal Faces=Np3.face(at (29.5, 0, 28.45)) Conductor_number=1 Winding=primary Point_out_of_terminal=false
  p_4: Coil Terminal Faces=Np4.face(at (33.7, 0, 28.45)) Conductor_number=1 Winding=primary Point_out_of_terminal=false
  p_5: Coil Terminal Faces=Np1.face(at (0, 69.3785, 28.45)) Conductor_number=1 Winding=primary Point_out_of_terminal=true
  p_6: Coil Terminal Faces=Np2.face(at (0, 73.5785, 28.45)) Conductor_number=1 Winding=primary Point_out_of_terminal=true
  p_7: Coil Terminal Faces=Np3.face(at (0, 77.7785, 28.45)) Conductor_number=1 Winding=primary Point_out_of_terminal=true
  p_8: Coil Terminal Faces=Np4.face(at (0, 81.9785, 28.45)) Conductor_number=1 Winding=primary Point_out_of_terminal=true
  s_1: Coil Terminal Faces=Ns1.face(at (23.2, 0, 28.45)) Conductor_number=1 Winding=secondary Point_out_of_terminal=true
  s_2: Coil Terminal Faces=Ns2.face(at (27.4, 0, 28.45)) Conductor_number=1 Winding=secondary Point_out_of_terminal=true
  s_3: Coil Terminal Faces=Ns3.face(at (31.6, 0, 28.45)) Conductor_number=1 Winding=secondary Point_out_of_terminal=true
  s_4: Coil Terminal Faces=Ns4.face(at (35.8, 0, 28.45)) Conductor_number=1 Winding=secondary Point_out_of_terminal=true
  s_5: Coil Terminal Faces=Ns4.face(at (0, 84.0785, 28.45)) Conductor_number=1 Winding=secondary Point_out_of_terminal=false
  s_6: Coil Terminal Faces=Ns3.face(at (0, 79.8785, 28.45)) Conductor_number=1 Winding=secondary Point_out_of_terminal=false
  s_7: Coil Terminal Faces=Ns2.face(at (0, 75.6785, 28.45)) Conductor_number=1 Winding=secondary Point_out_of_terminal=false
  s_8: Coil Terminal Faces=Ns1.face(at (0, 71.4785, 28.45)) Conductor_number=1 Winding=secondary Point_out_of_terminal=false
  primary: Winding Group Type=Current IsSolid=true Current=200A ParallelBranchesNum=1 Phase=0deg
  secondary: Winding Group Type=Current IsSolid=true Current=200A ParallelBranchesNum=1 Phase=0deg
parameters:
  Matrix1: Matrix primary, secondary:
mesh:
  Length1: LengthBased Objects=[Body1, Body1_3, Body1_5, Body1_1] MaxLength=20mm
  Length2: LengthBased Objects=[Np1..Np4, Ns1..Ns4] MaxLength=20mm
  initial mesh: GlobalCurvilinear{Apply} MeshMethod=AnsoftClassic
setups:
  Setup1: EddyCurrent MaximumPasses=20 MinimumPasses=2 MinimumConvergedPasses=1 PercentRefinement=30 PercentError=1 ConstantDelta=0s NonLinearResidual=0.0001 Frequency=27500Hz LossAdaptiveCtrl=0.5

design Flatwise_2D_100kW_corrected (Maxwell 2D, EddyCurrent, XY geometry, model units mm)
options: ModelDepth=136.5570263mm
geometry:
  Np1#6, Np2#58, Np3#110, Np4#162, Ns1#214, Ns2#266, Ns3#318, Ns4#370, Body1#874, Body1_3#1054 = imported_body(C:\Users\karlr\Documents\core_assembled_flatwise_100kW_revised.step)
  Region [vacuum] = region(percentage_offset=0 on all sides)
  Np1 [copper] = Np1#6.section(plane=ZX)
  Np1#6.delete()
  Np1.rotate(axis=X, angle=-90deg)
  Np2 [copper] = Np2#58.section(plane=ZX)
  Np2#58.delete()
  Np2.rotate(axis=X, angle=-90deg)
  Np3 [copper] = Np3#110.section(plane=ZX)
  Np3#110.delete()
  Np3.rotate(axis=X, angle=-90deg)
  Np4 [copper] = Np4#162.section(plane=ZX)
  Np4#162.delete()
  Np4.rotate(axis=X, angle=-90deg)
  Ns1 [copper] = Ns1#214.section(plane=ZX)
  Ns1#214.delete()
  Ns1.rotate(axis=X, angle=-90deg)
  Ns2 [copper] = Ns2#266.section(plane=ZX)
  Ns2#266.delete()
  Ns2.rotate(axis=X, angle=-90deg)
  Ns3 [copper] = Ns3#318.section(plane=ZX)
  Ns3#318.delete()
  Ns3.rotate(axis=X, angle=-90deg)
  Ns4 [copper] = Ns4#370.section(plane=ZX)
  Ns4#370.delete()
  Ns4.rotate(axis=X, angle=-90deg)
  Body1 [ferrite] = Body1#874.section(plane=ZX)
  Body1#874.delete()
  Body1.rotate(axis=X, angle=-90deg)
  Body1_3 [ferrite] = Body1_3#1054.section(plane=ZX)
  Body1_3#1054.delete()
  Body1_3.rotate(axis=X, angle=-90deg)
  Np1_Separate1 [copper] = Np1.separate_bodies()
  Np2_Separate1 [copper] = Np2.separate_bodies()
  Np3_Separate1 [copper] = Np3.separate_bodies()
  Np4_Separate1 [copper] = Np4.separate_bodies()
  Ns1_Separate1 [copper] = Ns1.separate_bodies()
  Ns2_Separate1 [copper] = Ns2.separate_bodies()
  Ns3_Separate1 [copper] = Ns3.separate_bodies()
  Ns4_Separate1 [copper] = Ns4.separate_bodies()
  group core_assembled_flatwise = Np1..Np4, Ns1..Ns4, Np1_Separate1, Np2_Separate1, Np3_Separate1, Np4_Separate1, Ns1_Separate1, Ns2_Separate1, Ns3_Separate1, Ns4_Separate1
  group core = Body1, Body1_3
boundaries and excitations:
  Balloon1: Balloon Edges=Region.edge(all 4)
  Np1: Coil Objects=Np1 Conductor_number=1 Winding=Primary PolarityType=Positive
  Np2: Coil Objects=Np2 Conductor_number=1 Winding=Primary PolarityType=Positive
  Np3: Coil Objects=Np3 Conductor_number=1 Winding=Primary PolarityType=Positive
  Np4: Coil Objects=Np4 Conductor_number=1 Winding=Primary PolarityType=Positive
  Np1_Separate1: Coil Objects=Np1_Separate1 Conductor_number=1 Winding=Primary PolarityType=Negative
  Np2_Separate1: Coil Objects=Np2_Separate1 Conductor_number=1 Winding=Primary PolarityType=Negative
  Np3_Separate1: Coil Objects=Np3_Separate1 Conductor_number=1 Winding=Primary PolarityType=Negative
  Np4_Separate1: Coil Objects=Np4_Separate1 Conductor_number=1 Winding=Primary PolarityType=Negative
  Ns1: Coil Objects=Ns1 Conductor_number=1 Winding=Secondary PolarityType=Negative
  Ns2: Coil Objects=Ns2 Conductor_number=1 Winding=Secondary PolarityType=Negative
  Ns3: Coil Objects=Ns3 Conductor_number=1 Winding=Secondary PolarityType=Negative
  Ns4_Separate1: Coil Objects=Ns4_Separate1 Conductor_number=1 Winding=Secondary PolarityType=Negative
  Ns4: Coil Objects=Ns4 Conductor_number=1 Winding=Secondary PolarityType=Positive
  Ns3_Separate1: Coil Objects=Ns3_Separate1 Conductor_number=1 Winding=Secondary PolarityType=Positive
  Ns2_Separate1: Coil Objects=Ns2_Separate1 Conductor_number=1 Winding=Secondary PolarityType=Positive
  Ns1_Separate1: Coil Objects=Ns1_Separate1 Conductor_number=1 Winding=Secondary PolarityType=Positive
  Primary: Winding Group Type=Current IsSolid=true Current=200A ParallelBranchesNum=1 Phase=0deg
  Secondary: Winding Group Type=Current IsSolid=true Current=200A ParallelBranchesNum=1 Phase=0deg
parameters:
  Matrix1: Matrix Primary, Secondary:
mesh:
  Length1: LengthBased RefineInside Objects=[Body1, Body1_3] MaxLength=2mm
  Length2: LengthBased RefineInside Objects=[Np1, Np1_Separate1, Np2, Np2_Separate1, Np3, Np3_Separate1, Np4, Np4_Separate1, Ns1, Ns1_Separate1, Ns2, Ns2_Separate1, Ns3, Ns3_Separate1, Ns4, Ns4_Separate1] MaxLength=0.2mm
setups:
  Setup1: EddyCurrent MaximumPasses=20 MinimumPasses=2 MinimumConvergedPasses=1 PercentRefinement=30 PercentError=0.5 ConstantDelta=0s NonLinearResidual=0.0001 Frequency=27500Hz SweepRanges{10Hz to 50000Hz step 1000Hz} SaveAllFields
field plots:
  JAtPhase1: J over Np1, Np1_Separate1, Np2, Np2_Separate1, Np3, Np3_Separate1, Np4, Np4_Separate1, Ns1, Ns1_Separate1, Ns2, Ns2_Separate1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 on Setup1 : LastAdaptive at Freq=27500Hz Phase=0deg
reports:
  Loss Plot1: SolidLoss vs Freq on Setup1 : LastAdaptive
