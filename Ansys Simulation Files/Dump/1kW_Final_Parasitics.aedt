# Ansys Electronics Desktop project, version 2025.1
materials:
  aluminum: permeability=1.000021 conductivity=38000000
  copper: permeability=0.999991 conductivity=58000000
  ferrite - Copy: core_loss_curve{25kHz (0, 0) (0.050633, 1) (0.0590114, 1.50406) (0.0691674, 2.34392) (0.0792528, 3.65275) (0.088772, 5.02746) (0.0939521, 6.11121) (0.1, 7.16954) (0.109499, 8.56175) (0.121957, 11.5767) (0.138164, 16.5092) (0.153013, 23.1293) (0.173347, 32.9841) (0.195272, 44.5991) (0.21382, 61.3838) (0.235462, 78.6962) (0.259294, 104.536) (0.280722, 138.862) (0.295422, 151.746)} core_loss_curve{100kHz (0, 0) (0.0263744, 1.03613) (0.0293752, 1.42608) (0.0332788, 2.03369) (0.0396755, 3.1693) (0.0449479, 4.44016) (0.0523856, 6.91954) (0.0628101, 11.373) (0.0753091, 20.068) (0.0882699, 32.4039) (0.103461, 49.6099) (0.118547, 74.6161) (0.142138, 118.363) (0.165658, 191.122) (0.184506, 245.025) (0.1975, 325.48) (0.215037, 409.937) (0.242235, 554.291) (0.26827, 762.898) (0.287163, 911.04)} core_loss_curve{200kHz (0, 0) (0.0153013, 1.07357) (0.0196383, 2.03369) (0.0260769, 4.28533) (0.0305648, 7.42858) (0.0396755, 14.0722) (0.0481134, 22.7224) (0.059347, 38.6962) (0.0757374, 74.6161) (0.0994345, 162.909) (0.110748, 216.401) (0.130546, 319.755) (0.147894, 472.47) (0.164721, 605.722) (0.183462, 848.612) (0.194168, 1013.4) (0.210213, 1167.99) (0.235462, 1607.55) (0.252045, 2024.69) (0.274425, 2333.54) (0.290439, 2939.06)} core_loss_curve{500kHz (0, 0) (0.0101716, 5.89811) (0.01199, 8.71505) (0.0149581, 13.5815) (0.0170423, 18.6929) (0.0202031, 30.1834) (0.0235462, 38.6962) (0.0266752, 55.1837) (0.0309135, 72.0142) (0.0356225, 99.1166) (0.0401281, 129.346) (0.0465037, 187.76) (0.0515018, 236.481) (0.0580159, 319.755) (0.067616, 447.974) (0.0761681, 574.318) (0.0892769, 776.557) (0.101141, 1068.81) (0.1199, 1524.21) (0.142138, 2292.49) (0.174333, 3327.81) (0.199753, 5186.04) (0.22248, 6531.74) (0.249202, 8373.92)} permittivity=12 permeability=3300 conductivity=0.25 core_loss_type="Power Ferrite" core_loss_cm=0.062032234 core_loss_x=1.7066326 core_loss_y=2.5354555 mass_density=4800 core_loss_equiv_cut_depth=0.001meter
  silicon - Copy: permittivity=9
  vacuum: permittivity=1

design 8turns_3D_Capacitance_FullInterleaved_INTER (Maxwell 3D, Electrostatic, model units mm)
geometry:
  Np1..Np8, Ns1..Ns8 [copper] = imported_body(C:\Users\karlr\Documents\flatwise_v3\Flatwise_1kW_final.step)
  plate_1, plate_2 [silicon - Copy] = imported_body(C:\Users\karlr\Documents\flatwise_v3\Flatwise_1kW_final.step)
  Body1 [ferrite - Copy] = imported_body(C:\Users\karlr\Documents\flatwise_v3\Flatwise_1kW_final.step)
  Body1_1, Body1_2 [aluminum] = imported_body(C:\Users\karlr\Documents\flatwise_v3\Flatwise_1kW_final.step)
  Body1_3 [ferrite - Copy] = imported_body(C:\Users\karlr\Documents\flatwise_v3\Flatwise_1kW_final.step)
  Body1_4, Body1_5 [aluminum] = imported_body(C:\Users\karlr\Documents\flatwise_v3\Flatwise_1kW_final.step)
  Np1_Section1 = Np1.section(plane=ZX)
  Np2_Section1 = Np2.section(plane=ZX)
  Np3_Section1 [copper] = Np3.section(plane=ZX)
  Np4_Section1 [copper] = Np4.section(plane=ZX)
  Np5_Section1 [copper] = Np5.section(plane=ZX)
  Np6_Section1 [copper] = Np6.section(plane=ZX)
  Np7_Section1 [copper] = Np7.section(plane=ZX)
  Np8_Section1 [copper] = Np8.section(plane=ZX)
  Ns1_Section1 = Ns1.section(plane=ZX)
  Ns2_Section1 = Ns2.section(plane=ZX)
  Ns3_Section1 [copper] = Ns3.section(plane=ZX)
  Ns4_Section1 [copper] = Ns4.section(plane=ZX)
  Ns5_Section1 [copper] = Ns5.section(plane=ZX)
  Ns6_Section1 [copper] = Ns6.section(plane=ZX)
  Ns7_Section1 [copper] = Ns7.section(plane=ZX)
  Ns8_Section1 [copper] = Ns8.section(plane=ZX)
  Np1_Section1_Separate1 [copper] = Np1_Section1.separate_bodies()
  Np1_Section1.delete()
  Np2_Section1_Separate1 [copper] = Np2_Section1.separate_bodies()
  Np2_Section1.delete()
  Np3_Section1.separate_bodies()
  Np4_Section1.separate_bodies()
  Np5_Section1.separate_bodies()
  Np6_Section1.separate_bodies()
  Np7_Section1.separate_bodies()
  Np8_Section1.separate_bodies()
  Ns1_Section1_Separate1 [copper] = Ns1_Section1.separate_bodies()
  Ns1_Section1.delete()
  Ns2_Section1_Separate1 [copper] = Ns2_Section1.separate_bodies()
  Ns2_Section1.delete()
  Ns3_Section1.separate_bodies()
  Ns4_Section1.separate_bodies()
  Ns5_Section1.separate_bodies()
  Ns6_Section1.separate_bodies()
  Ns7_Section1.separate_bodies()
  Ns8_Section1.separate_bodies()
  Region [vacuum] = region(percentage_offset=0 on all sides)
  group core_assembled_flatwise = Np1..Np8, Ns1..Ns8, plate_1, plate_2, Np3_Section1, Np4_Section1, Np5_Section1, Np6_Section1, Np7_Section1, Np8_Section1, Ns3_Section1, Ns4_Section1, Ns5_Section1, Ns6_Section1, Ns7_Section1, Ns8_Section1, Np1_Section1_Separate1, Np2_Section1_Separate1, Ns1_Section1_Separate1, Ns2_Section1_Separate1
  group core_together_1 = Body1, Body1_1, Body1_2
  group core_together = Body1_3, Body1_4, Body1_5
boundaries and excitations:
  Np: Voltage Objects=[Np1..Np8] Voltage=1V
  Ns: Voltage Objects=[Ns1..Ns8] Voltage=0mV
parameters:
  Matrix1: Matrix Np, Ns: NumberOfTurns=1
mesh:
  Length1: LengthBased Objects=[plate_1, plate_2, Np1..Np8, Ns1..Ns8] MaxLength=1.5mm
  Length2: LengthBased Objects=[Body1_1, Body1_2, Body1, Body1_4, Body1_5, Body1_3] MaxLength=4.5mm
  initial mesh: GlobalSurfApproximation{CurvedSurfaceApproxChoice=UseSlider SliderMeshSettings=9} GlobalCurvilinear{Apply}
setups:
  Setup1: Electrostatic MaximumPasses=20 MinimumPasses=2 MinimumConvergedPasses=1 PercentRefinement=30 PercentError=1 ConstantDelta=0s NonLinearResidual=0.001

design 8turns_3D_Capacitance_NoInterleaved_Flatwise_INTER (Maxwell 3D, Electrostatic, model units mm)
geometry:
  Np1..Np8, Ns1..Ns8 [copper] = imported_body(C:\Users\karlr\Documents\flatwise_v3\Flatwise_1kW_final.step)
  plate_1, plate_2 [silicon - Copy] = imported_body(C:\Users\karlr\Documents\flatwise_v3\Flatwise_1kW_final.step)
  Body1 [ferrite - Copy] = imported_body(C:\Users\karlr\Documents\flatwise_v3\Flatwise_1kW_final.step)
  Body1_1, Body1_2 [aluminum] = imported_body(C:\Users\karlr\Documents\flatwise_v3\Flatwise_1kW_final.step)
  Body1_3 [ferrite - Copy] = imported_body(C:\Users\karlr\Documents\flatwise_v3\Flatwise_1kW_final.step)
  Body1_4, Body1_5 [aluminum] = imported_body(C:\Users\karlr\Documents\flatwise_v3\Flatwise_1kW_final.step)
  Np1_Section1 = Np1.section(plane=ZX)
  Np2_Section1 = Np2.section(plane=ZX)
  Np3_Section1 [copper] = Np3.section(plane=ZX)
  Np4_Section1 [copper] = Np4.section(plane=ZX)
  Np5_Section1 [copper] = Np5.section(plane=ZX)
  Np6_Section1 [copper] = Np6.section(plane=ZX)
  Np7_Section1 [copper] = Np7.section(plane=ZX)
  Np8_Section1 [copper] = Np8.section(plane=ZX)
  Ns1_Section1 = Ns1.section(plane=ZX)
  Ns2_Section1 = Ns2.section(plane=ZX)
  Ns3_Section1 [copper] = Ns3.section(plane=ZX)
  Ns4_Section1 [copper] = Ns4.section(plane=ZX)
  Ns5_Section1 [copper] = Ns5.section(plane=ZX)
  Ns6_Section1 [copper] = Ns6.section(plane=ZX)
  Ns7_Section1 [copper] = Ns7.section(plane=ZX)
  Ns8_Section1 [copper] = Ns8.section(plane=ZX)
  Np1_Section1_Separate1 [copper] = Np1_Section1.separate_bodies()
  Np1_Section1.delete()
  Np2_Section1_Separate1 [copper] = Np2_Section1.separate_bodies()
  Np2_Section1.delete()
  Np3_Section1.separate_bodies()
  Np4_Section1.separate_bodies()
  Np5_Section1.separate_bodies()
  Np6_Section1.separate_bodies()
  Np7_Section1.separate_bodies()
  Np8_Section1.separate_bodies()
  Ns1_Section1_Separate1 [copper] = Ns1_Section1.separate_bodies()
  Ns1_Section1.delete()
  Ns2_Section1_Separate1 [copper] = Ns2_Section1.separate_bodies()
  Ns2_Section1.delete()
  Ns3_Section1.separate_bodies()
  Ns4_Section1.separate_bodies()
  Ns5_Section1.separate_bodies()
  Ns6_Section1.separate_bodies()
  Ns7_Section1.separate_bodies()
  Ns8_Section1.separate_bodies()
  Region [vacuum] = region(percentage_offset=0 on all sides)
  group core_assembled_flatwise = Np1..Np8, Ns1..Ns8, plate_1, plate_2, Np3_Section1, Np4_Section1, Np5_Section1, Np6_Section1, Np7_Section1, Np8_Section1, Ns3_Section1, Ns4_Section1, Ns5_Section1, Ns6_Section1, Ns7_Section1, Ns8_Section1, Np1_Section1_Separate1, Np2_Section1_Separate1, Ns1_Section1_Separate1, Ns2_Section1_Separate1
  group core_together_1 = Body1, Body1_1, Body1_2
  group core_together = Body1_3, Body1_4, Body1_5
boundaries and excitations:
  Np: Voltage Objects=[Ns1, Np1, Ns2, Np2, Np3, Np4, Ns3, Ns4] Voltage=1V
  Ns: Voltage Objects=[Np5..Np8, Ns5..Ns8] Voltage=0mV
parameters:
  Matrix1: Matrix Np, Ns: NumberOfTurns=1
mesh:
  Length1: LengthBased Objects=[plate_1, plate_2, Np1..Np8, Ns1..Ns8] MaxLength=1.5mm
  Length2: LengthBased Objects=[Body1_1, Body1_2, Body1, Body1_4, Body1_5, Body1_3] MaxLength=4.5mm
  initial mesh: GlobalSurfApproximation{CurvedSurfaceApproxChoice=UseSlider SliderMeshSettings=9} GlobalCurvilinear{Apply}
setups:
  Setup1: Electrostatic MaximumPasses=20 MinimumPasses=2 MinimumConvergedPasses=1 PercentRefinement=30 PercentError=1 NonLinearResidual=0.001

design 8turns_3D_Capacitance_PSSP_Flatwise_INTER (Maxwell 3D, Electrostatic, model units mm)
geometry:
  Np1..Np8, Ns1..Ns8 [copper] = imported_body(C:\Users\karlr\Documents\flatwise_v3\Flatwise_1kW_final.step)
  plate_1, plate_2 [silicon - Copy] = imported_body(C:\Users\karlr\Documents\flatwise_v3\Flatwise_1kW_final.step)
  Body1 [ferrite - Copy] = imported_body(C:\Users\karlr\Documents\flatwise_v3\Flatwise_1kW_final.step)
  Body1_1, Body1_2 [aluminum] = imported_body(C:\Users\karlr\Documents\flatwise_v3\Flatwise_1kW_final.step)
  Body1_3 [ferrite - Copy] = imported_body(C:\Users\karlr\Documents\flatwise_v3\Flatwise_1kW_final.step)
  Body1_4, Body1_5 [aluminum] = imported_body(C:\Users\karlr\Documents\flatwise_v3\Flatwise_1kW_final.step)
  Np1_Section1 = Np1.section(plane=ZX)
  Np2_Section1 = Np2.section(plane=ZX)
  Np3_Section1 [copper] = Np3.section(plane=ZX)
  Np4_Section1 [copper] = Np4.section(plane=ZX)
  Np5_Section1 [copper] = Np5.section(plane=ZX)
  Np6_Section1 [copper] = Np6.section(plane=ZX)
  Np7_Section1 [copper] = Np7.section(plane=ZX)
  Np8_Section1 [copper] = Np8.section(plane=ZX)
  Ns1_Section1 = Ns1.section(plane=ZX)
  Ns2_Section1 = Ns2.section(plane=ZX)
  Ns3_Section1 [copper] = Ns3.section(plane=ZX)
  Ns4_Section1 [copper] = Ns4.section(plane=ZX)
  Ns5_Section1 [copper] = Ns5.section(plane=ZX)
  Ns6_Section1 [copper] = Ns6.section(plane=ZX)
  Ns7_Section1 [copper] = Ns7.section(plane=ZX)
  Ns8_Section1 [copper] = Ns8.section(plane=ZX)
  Np1_Section1_Separate1 [copper] = Np1_Section1.separate_bodies()
  Np1_Section1.delete()
  Np2_Section1_Separate1 [copper] = Np2_Section1.separate_bodies()
  Np2_Section1.delete()
  Np3_Section1.separate_bodies()
  Np4_Section1.separate_bodies()
  Np5_Section1.separate_bodies()
  Np6_Section1.separate_bodies()
  Np7_Section1.separate_bodies()
  Np8_Section1.separate_bodies()
  Ns1_Section1_Separate1 [copper] = Ns1_Section1.separate_bodies()
  Ns1_Section1.delete()
  Ns2_Section1_Separate1 [copper] = Ns2_Section1.separate_bodies()
  Ns2_Section1.delete()
  Ns3_Section1.separate_bodies()
  Ns4_Section1.separate_bodies()
  Ns5_Section1.separate_bodies()
  Ns6_Section1.separate_bodies()
  Ns7_Section1.separate_bodies()
  Ns8_Section1.separate_bodies()
  Region [vacuum] = region(percentage_offset=0 on all sides)
  group core_assembled_flatwise = Np1..Np8, Ns1..Ns8, plate_1, plate_2, Np3_Section1, Np4_Section1, Np5_Section1, Np6_Section1, Np7_Section1, Np8_Section1, Ns3_Section1, Ns4_Section1, Ns5_Section1, Ns6_Section1, Ns7_Section1, Ns8_Section1, Np1_Section1_Separate1, Np2_Section1_Separate1, Ns1_Section1_Separate1, Ns2_Section1_Separate1
  group core_together_1 = Body1, Body1_1, Body1_2
  group core_together = Body1_3, Body1_4, Body1_5
boundaries and excitations:
  Np: Voltage Objects=[Np1, Np3, Np5, Np7, Ns2, Ns4, Ns6, Ns8] Voltage=1V
  Ns: Voltage Objects=[Np2, Np4, Np6, Np8, Ns1, Ns3, Ns5, Ns7] Voltage=0mV
parameters:
  Matrix1: Matrix Np, Ns: NumberOfTurns=1
mesh:
  Length1: LengthBased Objects=[plate_1, plate_2, Np1..Np8, Ns1..Ns8] MaxLength=1.5mm
  Length2: LengthBased Objects=[Body1_1, Body1_2, Body1, Body1_4, Body1_5, Body1_3] MaxLength=4.5mm
  initial mesh: GlobalSurfApproximation{CurvedSurfaceApproxChoice=UseSlider SliderMeshSettings=9} GlobalCurvilinear{Apply}
setups:
  Setup1: Electrostatic MaximumPasses=20 MinimumPasses=2 MinimumConvergedPasses=1 PercentRefinement=30 PercentError=1 NonLinearResidual=0.001

design 8turns_3D_CoreLoss_FullInterleaved_Flatwise1 (Maxwell 3D, Electrostatic, model units mm)
geometry:
  Np1..Np8, Ns1..Ns8 [copper] = imported_body(C:\Users\karlr\Documents\flatwise_v3\Flatwise_1kW_final.step)
  plate_1, plate_2 [silicon - Copy] = imported_body(C:\Users\karlr\Documents\flatwise_v3\Flatwise_1kW_final.step)
  Body1 [ferrite - Copy] = imported_body(C:\Users\karlr\Documents\flatwise_v3\Flatwise_1kW_final.step)
  Body1_1, Body1_2 [aluminum] = imported_body(C:\Users\karlr\Documents\flatwise_v3\Flatwise_1kW_final.step)
  Body1_3 [ferrite - Copy] = imported_body(C:\Users\karlr\Documents\flatwise_v3\Flatwise_1kW_final.step)
  Body1_4, Body1_5 [aluminum] = imported_body(C:\Users\karlr\Documents\flatwise_v3\Flatwise_1kW_final.step)
  Np1_Section1 = Np1.section(plane=ZX)
  Np2_Section1 = Np2.section(plane=ZX)
  Np3_Section1 [copper] = Np3.section(plane=ZX)
  Np4_Section1 [copper] = Np4.section(plane=ZX)
  Np5_Section1 [copper] = Np5.section(plane=ZX)
  Np6_Section1 [copper] = Np6.section(plane=ZX)
  Np7_Section1 [copper] = Np7.section(plane=ZX)
  Np8_Section1 [copper] = Np8.section(plane=ZX)
  Ns1_Section1 = Ns1.section(plane=ZX)
  Ns2_Section1 = Ns2.section(plane=ZX)
  Ns3_Section1 [copper] = Ns3.section(plane=ZX)
  Ns4_Section1 [copper] = Ns4.section(plane=ZX)
  Ns5_Section1 [copper] = Ns5.section(plane=ZX)
  Ns6_Section1 [copper] = Ns6.section(plane=ZX)
  Ns7_Section1 [copper] = Ns7.section(plane=ZX)
  Ns8_Section1 [copper] = Ns8.section(plane=ZX)
  Np1_Section1_Separate1 [copper] = Np1_Section1.separate_bodies()
  Np1_Section1.delete()
  Np2_Section1_Separate1 [copper] = Np2_Section1.separate_bodies()
  Np2_Section1.delete()
  Np3_Section1.separate_bodies()
  Np4_Section1.separate_bodies()
  Np5_Section1.separate_bodies()
  Np6_Section1.separate_bodies()
  Np7_Section1.separate_bodies()
  Np8_Section1.separate_bodies()
  Ns1_Section1_Separate1 [copper] = Ns1_Section1.separate_bodies()
  Ns1_Section1.delete()
  Ns2_Section1_Separate1 [copper] = Ns2_Section1.separate_bodies()
  Ns2_Section1.delete()
  Ns3_Section1.separate_bodies()
  Ns4_Section1.separate_bodies()
  Ns5_Section1.separate_bodies()
  Ns6_Section1.separate_bodies()
  Ns7_Section1.separate_bodies()
  Ns8_Section1.separate_bodies()
  Region [vacuum] = region(percentage_offset=0 on all sides)
  group core_assembled_flatwise = Np1..Np8, Ns1..Ns8, plate_1, plate_2, Np3_Section1, Np4_Section1, Np5_Section1, Np6_Section1, Np7_Section1, Np8_Section1, Ns3_Section1, Ns4_Section1, Ns5_Section1, Ns6_Section1, Ns7_Section1, Ns8_Section1, Np1_Section1_Separate1, Np2_Section1_Separate1, Ns1_Section1_Separate1, Ns2_Section1_Separate1
  group core_together_1 = Body1, Body1_1, Body1_2
  group core_together = Body1_3, Body1_4, Body1_5
boundaries and excitations:
  Voltage1: Voltage Objects=Np1 Voltage=1V
  Voltage2: Voltage Objects=Np2 Voltage=1V
  Voltage3: Voltage Objects=Np3 Voltage=1V
  Voltage4: Voltage Objects=Np4 Voltage=1V
  Voltage5: Voltage Objects=Np5 Voltage=1V
  Voltage6: Voltage Objects=Np6 Voltage=1V
  Voltage7: Voltage Objects=Np7 Voltage=1V
  Voltage8: Voltage Objects=Np8 Voltage=1V
  Voltage9: Voltage Objects=Ns1 Voltage=0V
  Voltage10: Voltage Objects=Ns2 Voltage=0V
  Voltage11: Voltage Objects=Ns3 Voltage=0V
  Voltage12: Voltage Objects=Ns4 Voltage=0V
  Voltage13: Voltage Objects=Ns5 Voltage=0V
  Voltage14: Voltage Objects=Ns6 Voltage=0V
  Voltage15: Voltage Objects=Ns7 Voltage=0V
  Voltage16: Voltage Objects=Ns8 Voltage=0V
mesh:
  Length1: LengthBased Objects=[plate_1, plate_2, Np1..Np8, Ns1..Ns8] MaxLength=1.5mm
  Length2: LengthBased Objects=[Body1_1, Body1_2, Body1, Body1_4, Body1_5, Body1_3] MaxLength=4.5mm
  initial mesh: GlobalSurfApproximation{CurvedSurfaceApproxChoice=UseSlider SliderMeshSettings=9} GlobalCurvilinear{Apply}
setups:
  Setup1: Electrostatic MaximumPasses=20 MinimumPasses=2 MinimumConvergedPasses=1 PercentRefinement=30 PercentError=1 NonLinearResidual=0.001

design 8turns_3D_CoreLoss_FullInterleaved_INTRA_primary (Maxwell 3D, Electrostatic, model units mm)
geometry:
  Np1..Np8, Ns1..Ns8 [copper] = imported_body(C:\Users\karlr\Documents\flatwise_v3\Flatwise_1kW_final.step)
  plate_1, plate_2 [silicon - Copy] = imported_body(C:\Users\karlr\Documents\flatwise_v3\Flatwise_1kW_final.step)
  Body1 [ferrite - Copy] = imported_body(C:\Users\karlr\Documents\flatwise_v3\Flatwise_1kW_final.step)
  Body1_1, Body1_2 [aluminum] = imported_body(C:\Users\karlr\Documents\flatwise_v3\Flatwise_1kW_final.step)
  Body1_3 [ferrite - Copy] = imported_body(C:\Users\karlr\Documents\flatwise_v3\Flatwise_1kW_final.step)
  Body1_4, Body1_5 [aluminum] = imported_body(C:\Users\karlr\Documents\flatwise_v3\Flatwise_1kW_final.step)
  Np1_Section1 = Np1.section(plane=ZX)
  Np2_Section1 = Np2.section(plane=ZX)
  Np3_Section1 [copper] = Np3.section(plane=ZX)
  Np4_Section1 [copper] = Np4.section(plane=ZX)
  Np5_Section1 [copper] = Np5.section(plane=ZX)
  Np6_Section1 [copper] = Np6.section(plane=ZX)
  Np7_Section1 [copper] = Np7.section(plane=ZX)
  Np8_Section1 [copper] = Np8.section(plane=ZX)
  Ns1_Section1 = Ns1.section(plane=ZX)
  Ns2_Section1 = Ns2.section(plane=ZX)
  Ns3_Section1 [copper] = Ns3.section(plane=ZX)
  Ns4_Section1 [copper] = Ns4.section(plane=ZX)
  Ns5_Section1 [copper] = Ns5.section(plane=ZX)
  Ns6_Section1 [copper] = Ns6.section(plane=ZX)
  Ns7_Section1 [copper] = Ns7.section(plane=ZX)
  Ns8_Section1 [copper] = Ns8.section(plane=ZX)
  Np1_Section1_Separate1 [copper] = Np1_Section1.separate_bodies()
  Np1_Section1.delete()
  Np2_Section1_Separate1 [copper] = Np2_Section1.separate_bodies()
  Np2_Section1.delete()
  Np3_Section1.separate_bodies()
  Np4_Section1.separate_bodies()
  Np5_Section1.separate_bodies()
  Np6_Section1.separate_bodies()
  Np7_Section1.separate_bodies()
  Np8_Section1.separate_bodies()
  Ns1_Section1_Separate1 [copper] = Ns1_Section1.separate_bodies()
  Ns1_Section1.delete()
  Ns2_Section1_Separate1 [copper] = Ns2_Section1.separate_bodies()
  Ns2_Section1.delete()
  Ns3_Section1.separate_bodies()
  Ns4_Section1.separate_bodies()
  Ns5_Section1.separate_bodies()
  Ns6_Section1.separate_bodies()
  Ns7_Section1.separate_bodies()
  Ns8_Section1.separate_bodies()
  Region [vacuum] = region(percentage_offset=0 on all sides)
  group core_assembled_flatwise = Np1..Np8, Ns1..Ns8, plate_1, plate_2, Np3_Section1, Np4_Section1, Np5_Section1, Np6_Section1, Np7_Section1, Np8_Section1, Ns3_Section1, Ns4_Section1, Ns5_Section1, Ns6_Section1, Ns7_Section1, Ns8_Section1, Np1_Section1_Separate1, Np2_Section1_Separate1, Ns1_Section1_Separate1, Ns2_Section1_Separate1
  group core_together_1 = Body1, Body1_1, Body1_2
  group core_together = Body1_3, Body1_4, Body1_5
boundaries and excitations:
  Voltage1: Voltage Objects=Np1 Voltage=1V
  Voltage2: Voltage Objects=Np2 Voltage="(1/7*6) V"
  Voltage3: Voltage Objects=Np3 Voltage="(1/7*5) V"
  Voltage4: Voltage Objects=Np4 Voltage="(1/7*4) V"
  Voltage5: Voltage Objects=Np5 Voltage="(1/7*3) V"
  Voltage6: Voltage Objects=Np6 Voltage="(1/7*2) V"
  Voltage7: Voltage Objects=Np7 Voltage="(1/7*1) V"
  Voltage8: Voltage Objects=Np8 Voltage=0V
parameters:
  Matrix1: Matrix Voltage1..Voltage8: NumberOfTurns=1
mesh:
  Length1: LengthBased Objects=[plate_1, plate_2, Np1..Np8, Ns1..Ns8] MaxLength=1.5mm
  Length2: LengthBased Objects=[Body1_1, Body1_2, Body1, Body1_4, Body1_5, Body1_3] MaxLength=4.5mm
  initial mesh: GlobalSurfApproximation{CurvedSurfaceApproxChoice=UseSlider SliderMeshSettings=9} GlobalCurvilinear{Apply}
setups:
  Setup1: Electrostatic MaximumPasses=20 MinimumPasses=2 MinimumConvergedPasses=1 PercentRefinement=30 PercentError=1 NonLinearResidual=0.001

design 8turns_3D_CoreLoss_FullInterleaved_INTRA_secondary (Maxwell 3D, Electrostatic, model units mm)
geometry:
  Np1..Np8, Ns1..Ns8 [copper] = imported_body(C:\Users\karlr\Documents\flatwise_v3\Flatwise_1kW_final.step)
  plate_1, plate_2 [silicon - Copy] = imported_body(C:\Users\karlr\Documents\flatwise_v3\Flatwise_1kW_final.step)
  Body1 [ferrite - Copy] = imported_body(C:\Users\karlr\Documents\flatwise_v3\Flatwise_1kW_final.step)
  Body1_1, Body1_2 [aluminum] = imported_body(C:\Users\karlr\Documents\flatwise_v3\Flatwise_1kW_final.step)
  Body1_3 [ferrite - Copy] = imported_body(C:\Users\karlr\Documents\flatwise_v3\Flatwise_1kW_final.step)
  Body1_4, Body1_5 [aluminum] = imported_body(C:\Users\karlr\Documents\flatwise_v3\Flatwise_1kW_final.step)
  Np1_Section1 = Np1.section(plane=ZX)
  Np2_Section1 = Np2.section(plane=ZX)
  Np3_Section1 [copper] = Np3.section(plane=ZX)
  Np4_Section1 [copper] = Np4.section(plane=ZX)
  Np5_Section1 [copper] = Np5.section(plane=ZX)
  Np6_Section1 [copper] = Np6.section(plane=ZX)
  Np7_Section1 [copper] = Np7.section(plane=ZX)
  Np8_Section1 [copper] = Np8.section(plane=ZX)
  Ns1_Section1 = Ns1.section(plane=ZX)
  Ns2_Section1 = Ns2.section(plane=ZX)
  Ns3_Section1 [copper] = Ns3.section(plane=ZX)
  Ns4_Section1 [copper] = Ns4.section(plane=ZX)
  Ns5_Section1 [copper] = Ns5.section(plane=ZX)
  Ns6_Section1 [copper] = Ns6.section(plane=ZX)
  Ns7_Section1 [copper] = Ns7.section(plane=ZX)
  Ns8_Section1 [copper] = Ns8.section(plane=ZX)
  Np1_Section1_Separate1 [copper] = Np1_Section1.separate_bodies()
  Np1_Section1.delete()
  Np2_Section1_Separate1 [copper] = Np2_Section1.separate_bodies()
  Np2_Section1.delete()
  Np3_Section1.separate_bodies()
  Np4_Section1.separate_bodies()
  Np5_Section1.separate_bodies()
  Np6_Section1.separate_bodies()
  Np7_Section1.separate_bodies()
  Np8_Section1.separate_bodies()
  Ns1_Section1_Separate1 [copper] = Ns1_Section1.separate_bodies()
  Ns1_Section1.delete()
  Ns2_Section1_Separate1 [copper] = Ns2_Section1.separate_bodies()
  Ns2_Section1.delete()
  Ns3_Section1.separate_bodies()
  Ns4_Section1.separate_bodies()
  Ns5_Section1.separate_bodies()
  Ns6_Section1.separate_bodies()
  Ns7_Section1.separate_bodies()
  Ns8_Section1.separate_bodies()
  Region [vacuum] = region(percentage_offset=0 on all sides)
  group core_assembled_flatwise = Np1..Np8, Ns1..Ns8, plate_1, plate_2, Np3_Section1, Np4_Section1, Np5_Section1, Np6_Section1, Np7_Section1, Np8_Section1, Ns3_Section1, Ns4_Section1, Ns5_Section1, Ns6_Section1, Ns7_Section1, Ns8_Section1, Np1_Section1_Separate1, Np2_Section1_Separate1, Ns1_Section1_Separate1, Ns2_Section1_Separate1
  group core_together_1 = Body1, Body1_1, Body1_2
  group core_together = Body1_3, Body1_4, Body1_5
boundaries and excitations:
  Voltage1: Voltage Objects=Ns1 Voltage=1V
  Voltage2: Voltage Objects=Ns2 Voltage="(1/7*6) V"
  Voltage3: Voltage Objects=Ns3 Voltage="(1/7*5) V"
  Voltage4: Voltage Objects=Ns4 Voltage="(1/7*4) V"
  Voltage5: Voltage Objects=Ns5 Voltage="(1/7*3) V"
  Voltage6: Voltage Objects=Ns6 Voltage="(1/7*2) V"
  Voltage7: Voltage Objects=Ns7 Voltage="(1/7*1) V"
  Voltage8: Voltage Objects=Ns8 Voltage=0V
parameters:
  Matrix1: Matrix Voltage1..Voltage8: NumberOfTurns=1
mesh:
  Length1: LengthBased Objects=[plate_1, plate_2, Np1..Np8, Ns1..Ns8] MaxLength=1.5mm
  Length2: LengthBased Objects=[Body1_1, Body1_2, Body1, Body1_4, Body1_5, Body1_3] MaxLength=4.5mm
  initial mesh: GlobalSurfApproximation{CurvedSurfaceApproxChoice=UseSlider SliderMeshSettings=9} GlobalCurvilinear{Apply}
setups:
  Setup1: Electrostatic MaximumPasses=20 MinimumPasses=2 MinimumConvergedPasses=1 PercentRefinement=30 PercentError=1 NonLinearResidual=0.001

design 8turns_3D_CoreLoss_PSSP_INTRA_primary (Maxwell 3D, Electrostatic, model units mm)
geometry:
  Np1..Np8, Ns1..Ns8 [copper] = imported_body(C:\Users\karlr\Documents\flatwise_v3\Flatwise_1kW_final.step)
  plate_1, plate_2 [silicon - Copy] = imported_body(C:\Users\karlr\Documents\flatwise_v3\Flatwise_1kW_final.step)
  Body1 [ferrite - Copy] = imported_body(C:\Users\karlr\Documents\flatwise_v3\Flatwise_1kW_final.step)
  Body1_1, Body1_2 [aluminum] = imported_body(C:\Users\karlr\Documents\flatwise_v3\Flatwise_1kW_final.step)
  Body1_3 [ferrite - Copy] = imported_body(C:\Users\karlr\Documents\flatwise_v3\Flatwise_1kW_final.step)
  Body1_4, Body1_5 [aluminum] = imported_body(C:\Users\karlr\Documents\flatwise_v3\Flatwise_1kW_final.step)
  Np1_Section1 = Np1.section(plane=ZX)
  Np2_Section1 = Np2.section(plane=ZX)
  Np3_Section1 [copper] = Np3.section(plane=ZX)
  Np4_Section1 [copper] = Np4.section(plane=ZX)
  Np5_Section1 [copper] = Np5.section(plane=ZX)
  Np6_Section1 [copper] = Np6.section(plane=ZX)
  Np7_Section1 [copper] = Np7.section(plane=ZX)
  Np8_Section1 [copper] = Np8.section(plane=ZX)
  Ns1_Section1 = Ns1.section(plane=ZX)
  Ns2_Section1 = Ns2.section(plane=ZX)
  Ns3_Section1 [copper] = Ns3.section(plane=ZX)
  Ns4_Section1 [copper] = Ns4.section(plane=ZX)
  Ns5_Section1 [copper] = Ns5.section(plane=ZX)
  Ns6_Section1 [copper] = Ns6.section(plane=ZX)
  Ns7_Section1 [copper] = Ns7.section(plane=ZX)
  Ns8_Section1 [copper] = Ns8.section(plane=ZX)
  Np1_Section1_Separate1 [copper] = Np1_Section1.separate_bodies()
  Np1_Section1.delete()
  Np2_Section1_Separate1 [copper] = Np2_Section1.separate_bodies()
  Np2_Section1.delete()
  Np3_Section1.separate_bodies()
  Np4_Section1.separate_bodies()
  Np5_Section1.separate_bodies()
  Np6_Section1.separate_bodies()
  Np7_Section1.separate_bodies()
  Np8_Section1.separate_bodies()
  Ns1_Section1_Separate1 [copper] = Ns1_Section1.separate_bodies()
  Ns1_Section1.delete()
  Ns2_Section1_Separate1 [copper] = Ns2_Section1.separate_bodies()
  Ns2_Section1.delete()
  Ns3_Section1.separate_bodies()
  Ns4_Section1.separate_bodies()
  Ns5_Section1.separate_bodies()
  Ns6_Section1.separate_bodies()
  Ns7_Section1.separate_bodies()
  Ns8_Section1.separate_bodies()
  Region [vacuum] = region(percentage_offset=0 on all sides)
  group core_assembled_flatwise = Np1..Np8, Ns1..Ns8, plate_1, plate_2, Np3_Section1, Np4_Section1, Np5_Section1, Np6_Section1, Np7_Section1, Np8_Section1, Ns3_Section1, Ns4_Section1, Ns5_Section1, Ns6_Section1, Ns7_Section1, Ns8_Section1, Np1_Section1_Separate1, Np2_Section1_Separate1, Ns1_Section1_Separate1, Ns2_Section1_Separate1
  group core_together_1 = Body1, Body1_1, Body1_2
  group core_together = Body1_3, Body1_4, Body1_5
boundaries and excitations:
  Voltage1: Voltage Objects=Np1 Voltage=1V
  Voltage2: Voltage Objects=Ns2 Voltage="(1/7*6) V"
  Voltage3: Voltage Objects=Np3 Voltage="(1/7*5) V"
  Voltage4: Voltage Objects=Ns4 Voltage="(1/7*4) V"
  Voltage5: Voltage Objects=Np5 Voltage="(1/7*3) V"
  Voltage6: Voltage Objects=Ns6 Voltage="(1/7*2) V"
  Voltage7: Voltage Objects=Np7 Voltage="(1/7*1) V"
  Voltage8: Voltage Objects=Ns8 Voltage=0V
parameters:
  Matrix1: Matrix Voltage1..Voltage8: NumberOfTurns=1
mesh:
  Length1: LengthBased Objects=[plate_1, plate_2, Np1..Np8, Ns1..Ns8] MaxLength=1.5mm
  Length2: LengthBased Objects=[Body1_1, Body1_2, Body1, Body1_4, Body1_5, Body1_3] MaxLength=4.5mm
  initial mesh: GlobalSurfApproximation{CurvedSurfaceApproxChoice=UseSlider SliderMeshSettings=9} GlobalCurvilinear{Apply}
setups:
  Setup1: Electrostatic MaximumPasses=20 MinimumPasses=2 MinimumConvergedPasses=1 PercentRefinement=30 PercentError=1 NonLinearResidual=0.001

design 8turns_3D_CoreLoss_NoInterleaving_INTRA_primary (Maxwell 3D, Electrostatic, model units mm)
geometry:
  Np1..Np8, Ns1..Ns8 [copper] = imported_body(C:\Users\karlr\Documents\flatwise_v3\Flatwise_1kW_final.step)
  plate_1, plate_2 [silicon - Copy] = imported_body(C:\Users\karlr\Documents\flatwise_v3\Flatwise_1kW_final.step)
  Body1 [ferrite - Copy] = imported_body(C:\Users\karlr\Documents\flatwise_v3\Flatwise_1kW_final.step)
  Body1_1, Body1_2 [aluminum] = imported_body(C:\Users\karlr\Documents\flatwise_v3\Flatwise_1kW_final.step)
  Body1_3 [ferrite - Copy] = imported_body(C:\Users\karlr\Documents\flatwise_v3\Flatwise_1kW_final.step)
  Body1_4, Body1_5 [aluminum] = imported_body(C:\Users\karlr\Documents\flatwise_v3\Flatwise_1kW_final.step)
  Np1_Section1 = Np1.section(plane=ZX)
  Np2_Section1 = Np2.section(plane=ZX)
  Np3_Section1 [copper] = Np3.section(plane=ZX)
  Np4_Section1 [copper] = Np4.section(plane=ZX)
  Np5_Section1 [copper] = Np5.section(plane=ZX)
  Np6_Section1 [copper] = Np6.section(plane=ZX)
  Np7_Section1 [copper] = Np7.section(plane=ZX)
  Np8_Section1 [copper] = Np8.section(plane=ZX)
  Ns1_Section1 = Ns1.section(plane=ZX)
  Ns2_Section1 = Ns2.section(plane=ZX)
  Ns3_Section1 [copper] = Ns3.section(plane=ZX)
  Ns4_Section1 [copper] = Ns4.section(plane=ZX)
  Ns5_Section1 [copper] = Ns5.section(plane=ZX)
  Ns6_Section1 [copper] = Ns6.section(plane=ZX)
  Ns7_Section1 [copper] = Ns7.section(plane=ZX)
  Ns8_Section1 [copper] = Ns8.section(plane=ZX)
  Np1_Section1_Separate1 [copper] = Np1_Section1.separate_bodies()
  Np1_Section1.delete()
  Np2_Section1_Separate1 [copper] = Np2_Section1.separate_bodies()
  Np2_Section1.delete()
  Np3_Section1.separate_bodies()
  Np4_Section1.separate_bodies()
  Np5_Section1.separate_bodies()
  Np6_Section1.separate_bodies()
  Np7_Section1.separate_bodies()
  Np8_Section1.separate_bodies()
  Ns1_Section1_Separate1 [copper] = Ns1_Section1.separate_bodies()
  Ns1_Section1.delete()
  Ns2_Section1_Separate1 [copper] = Ns2_Section1.separate_bodies()
  Ns2_Section1.delete()
  Ns3_Section1.separate_bodies()
  Ns4_Section1.separate_bodies()
  Ns5_Section1.separate_bodies()
  Ns6_Section1.separate_bodies()
  Ns7_Section1.separate_bodies()
  Ns8_Section1.separate_bodies()
  Region [vacuum] = region(percentage_offset=0 on all sides)
  group core_assembled_flatwise = Np1..Np8, Ns1..Ns8, plate_1, plate_2, Np3_Section1, Np4_Section1, Np5_Section1, Np6_Section1, Np7_Section1, Np8_Section1, Ns3_Section1, Ns4_Section1, Ns5_Section1, Ns6_Section1, Ns7_Section1, Ns8_Section1, Np1_Section1_Separate1, Np2_Section1_Separate1, Ns1_Section1_Separate1, Ns2_Section1_Separate1
  group core_together_1 = Body1, Body1_1, Body1_2
  group core_together = Body1_3, Body1_4, Body1_5
boundaries and excitations:
  Voltage1: Voltage Objects=Np1 Voltage=1V
  Voltage2: Voltage Objects=Ns1 Voltage="(1/7*6) V"
  Voltage3: Voltage Objects=Np2 Voltage="(1/7*5) V"
  Voltage4: Voltage Objects=Ns2 Voltage="(1/7*4) V"
  Voltage5: Voltage Objects=Np3 Voltage="(1/7*3) V"
  Voltage6: Voltage Objects=Ns3 Voltage="(1/7*2) V"
  Voltage7: Voltage Objects=Np4 Voltage="(1/7*1) V"
  Voltage8: Voltage Objects=Ns4 Voltage=0V
parameters:
  Matrix1: Matrix Voltage1..Voltage8: NumberOfTurns=1
mesh:
  Length1: LengthBased Objects=[plate_1, plate_2, Np1..Np8, Ns1..Ns8] MaxLength=1.5mm
  Length2: LengthBased Objects=[Body1_1, Body1_2, Body1, Body1_4, Body1_5, Body1_3] MaxLength=4.5mm
  initial mesh: GlobalSurfApproximation{CurvedSurfaceApproxChoice=UseSlider SliderMeshSettings=9} GlobalCurvilinear{Apply}
setups:
  Setup1: Electrostatic MaximumPasses=20 MinimumPasses=2 MinimumConvergedPasses=1 PercentRefinement=30 PercentError=1 NonLinearResidual=0.001

design 8turns_3D_CoreLoss_NoInterleaving_INTRA_secondary (Maxwell 3D, Electrostatic, model units mm)
geometry:
  Np1..Np8, Ns1..Ns8 [copper] = imported_body(C:\Users\karlr\Documents\flatwise_v3\Flatwise_1kW_final.step)
  plate_1, plate_2 [silicon - Copy] = imported_body(C:\Users\karlr\Documents\flatwise_v3\Flatwise_1kW_final.step)
  Body1 [ferrite - Copy] = imported_body(C:\Users\karlr\Documents\flatwise_v3\Flatwise_1kW_final.step)
  Body1_1, Body1_2 [aluminum] = imported_body(C:\Users\karlr\Documents\flatwise_v3\Flatwise_1kW_final.step)
  Body1_3 [ferrite - Copy] = imported_body(C:\Users\karlr\Documents\flatwise_v3\Flatwise_1kW_final.step)
  Body1_4, Body1_5 [aluminum] = imported_body(C:\Users\karlr\Documents\flatwise_v3\Flatwise_1kW_final.step)
  Np1_Section1 = Np1.section(plane=ZX)
  Np2_Section1 = Np2.section(plane=ZX)
  Np3_Section1 [copper] = Np3.section(plane=ZX)
  Np4_Section1 [copper] = Np4.section(plane=ZX)
  Np5_Section1 [copper] = Np5.section(plane=ZX)
  Np6_Section1 [copper] = Np6.section(plane=ZX)
  Np7_Section1 [copper] = Np7.section(plane=ZX)
  Np8_Section1 [copper] = Np8.section(plane=ZX)
  Ns1_Section1 = Ns1.section(plane=ZX)
  Ns2_Section1 = Ns2.section(plane=ZX)
  Ns3_Section1 [copper] = Ns3.section(plane=ZX)
  Ns4_Section1 [copper] = Ns4.section(plane=ZX)
  Ns5_Section1 [copper] = Ns5.section(plane=ZX)
  Ns6_Section1 [copper] = Ns6.section(plane=ZX)
  Ns7_Section1 [copper] = Ns7.section(plane=ZX)
  Ns8_Section1 [copper] = Ns8.section(plane=ZX)
  Np1_Section1_Separate1 [copper] = Np1_Section1.separate_bodies()
  Np1_Section1.delete()
  Np2_Section1_Separate1 [copper] = Np2_Section1.separate_bodies()
  Np2_Section1.delete()
  Np3_Section1.separate_bodies()
  Np4_Section1.separate_bodies()
  Np5_Section1.separate_bodies()
  Np6_Section1.separate_bodies()
  Np7_Section1.separate_bodies()
  Np8_Section1.separate_bodies()
  Ns1_Section1_Separate1 [copper] = Ns1_Section1.separate_bodies()
  Ns1_Section1.delete()
  Ns2_Section1_Separate1 [copper] = Ns2_Section1.separate_bodies()
  Ns2_Section1.delete()
  Ns3_Section1.separate_bodies()
  Ns4_Section1.separate_bodies()
  Ns5_Section1.separate_bodies()
  Ns6_Section1.separate_bodies()
  Ns7_Section1.separate_bodies()
  Ns8_Section1.separate_bodies()
  Region [vacuum] = region(percentage_offset=0 on all sides)
  group core_assembled_flatwise = Np1..Np8, Ns1..Ns8, plate_1, plate_2, Np3_Section1, Np4_Section1, Np5_Section1, Np6_Section1, Np7_Section1, Np8_Section1, Ns3_Section1, Ns4_Section1, Ns5_Section1, Ns6_Section1, Ns7_Section1, Ns8_Section1, Np1_Section1_Separate1, Np2_Section1_Separate1, Ns1_Section1_Separate1, Ns2_Section1_Separate1
  group core_together_1 = Body1, Body1_1, Body1_2
  group core_together = Body1_3, Body1_4, Body1_5
boundaries and excitations:
  Voltage1: Voltage Objects=Np5 Voltage=1V
  Voltage2: Voltage Objects=Ns1 Voltage="(1/7*6) V"
  Voltage3: Voltage Objects=Np6 Voltage="(1/7*5) V"
  Voltage4: Voltage Objects=Ns6 Voltage="(1/7*4) V"
  Voltage5: Voltage Objects=Np7 Voltage="(1/7*3) V"
  Voltage6: Voltage Objects=Ns7 Voltage="(1/7*2) V"
  Voltage7: Voltage Objects=Np8 Voltage="(1/7*1) V"
  Voltage8: Voltage Objects=Ns8 Voltage=0V
parameters:
  Matrix1: Matrix Voltage1..Voltage8: NumberOfTurns=1
mesh:
  Length1: LengthBased Objects=[plate_1, plate_2, Np1..Np8, Ns1..Ns8] MaxLength=1.5mm
  Length2: LengthBased Objects=[Body1_1, Body1_2, Body1, Body1_4, Body1_5, Body1_3] MaxLength=4.5mm
  initial mesh: GlobalSurfApproximation{CurvedSurfaceApproxChoice=UseSlider SliderMeshSettings=9} GlobalCurvilinear{Apply}
setups:
  Setup1: Electrostatic MaximumPasses=20 MinimumPasses=2 MinimumConvergedPasses=1 PercentRefinement=30 PercentError=1 NonLinearResidual=0.001

design 8turns_3D_Capacitance_EFIELD_FullInterleaved (Maxwell 3D, Electrostatic, model units mm)
geometry:
  Np1..Np8, Ns1..Ns8 [copper] = imported_body(C:\Users\karlr\Documents\flatwise_v3\Flatwise_1kW_final.step)
  plate_1, plate_2 [silicon - Copy] = imported_body(C:\Users\karlr\Documents\flatwise_v3\Flatwise_1kW_final.step)
  Body1 [ferrite - Copy] = imported_body(C:\Users\karlr\Documents\flatwise_v3\Flatwise_1kW_final.step)
  Body1_1, Body1_2 [aluminum] = imported_body(C:\Users\karlr\Documents\flatwise_v3\Flatwise_1kW_final.step)
  Body1_3 [ferrite - Copy] = imported_body(C:\Users\karlr\Documents\flatwise_v3\Flatwise_1kW_final.step)
  Body1_4, Body1_5 [aluminum] = imported_body(C:\Users\karlr\Documents\flatwise_v3\Flatwise_1kW_final.step)
  Np1_Section1 = Np1.section(plane=ZX)
  Np2_Section1 = Np2.section(plane=ZX)
  Np3_Section1 [copper] = Np3.section(plane=ZX)
  Np4_Section1 [copper] = Np4.section(plane=ZX)
  Np5_Section1 [copper] = Np5.section(plane=ZX)
  Np6_Section1 [copper] = Np6.section(plane=ZX)
  Np7_Section1 [copper] = Np7.section(plane=ZX)
  Np8_Section1 [copper] = Np8.section(plane=ZX)
  Ns1_Section1 = Ns1.section(plane=ZX)
  Ns2_Section1 = Ns2.section(plane=ZX)
  Ns3_Section1 [copper] = Ns3.section(plane=ZX)
  Ns4_Section1 [copper] = Ns4.section(plane=ZX)
  Ns5_Section1 [copper] = Ns5.section(plane=ZX)
  Ns6_Section1 [copper] = Ns6.section(plane=ZX)
  Ns7_Section1 [copper] = Ns7.section(plane=ZX)
  Ns8_Section1 [copper] = Ns8.section(plane=ZX)
  Np1_Section1_Separate1 [copper] = Np1_Section1.separate_bodies()
  Np1_Section1.delete()
  Np2_Section1_Separate1 [copper] = Np2_Section1.separate_bodies()
  Np2_Section1.delete()
  Np3_Section1.separate_bodies()
  Np4_Section1.separate_bodies()
  Np5_Section1.separate_bodies()
  Np6_Section1.separate_bodies()
  Np7_Section1.separate_bodies()
  Np8_Section1.separate_bodies()
  Ns1_Section1_Separate1 [copper] = Ns1_Section1.separate_bodies()
  Ns1_Section1.delete()
  Ns2_Section1_Separate1 [copper] = Ns2_Section1.separate_bodies()
  Ns2_Section1.delete()
  Ns3_Section1.separate_bodies()
  Ns4_Section1.separate_bodies()
  Ns5_Section1.separate_bodies()
  Ns6_Section1.separate_bodies()
  Ns7_Section1.separate_bodies()
  Ns8_Section1.separate_bodies()
  Region [vacuum] = region(percentage_offset=0 on all sides)
  group core_assembled_flatwise = Np1..Np8, Ns1..Ns8, plate_1, plate_2, Np3_Section1, Np4_Section1, Np5_Section1, Np6_Section1, Np7_Section1, Np8_Section1, Ns3_Section1, Ns4_Section1, Ns5_Section1, Ns6_Section1, Ns7_Section1, Ns8_Section1, Np1_Section1_Separate1, Np2_Section1_Separate1, Ns1_Section1_Separate1, Ns2_Section1_Separate1
  group core_together_1 = Body1, Body1_1, Body1_2
  group core_together = Body1_3, Body1_4, Body1_5
boundaries and excitations:
  Np: Voltage Objects=[Np1..Np8] Voltage=100V
  Ns: Voltage Objects=[Ns1..Ns8] Voltage=0mV
parameters:
  Matrix1: Matrix Np, Ns: NumberOfTurns=1
mesh:
  Length1: LengthBased Objects=[plate_1, plate_2, Np1..Np8, Ns1..Ns8] MaxLength=1.5mm
  Length2: LengthBased Objects=[Body1_1, Body1_2, Body1, Body1_4, Body1_5, Body1_3] MaxLength=4.5mm
  initial mesh: GlobalSurfApproximation{CurvedSurfaceApproxChoice=UseSlider SliderMeshSettings=9} GlobalCurvilinear{Apply}
setups:
  Setup1: Electrostatic MaximumPasses=20 MinimumPasses=2 MinimumConvergedPasses=1 PercentRefinement=30 PercentError=1 NonLinearResidual=0.001

design 8turns_3D_Capacitance_EFIELD_FullInterleaved_both (Maxwell 3D, Electrostatic, model units mm)
geometry:
  Np1..Np8, Ns1..Ns8 [copper] = imported_body(C:\Users\karlr\Documents\flatwise_v3\Flatwise_1kW_final.step)
  plate_1, plate_2 [silicon - Copy] = imported_body(C:\Users\karlr\Documents\flatwise_v3\Flatwise_1kW_final.step)
  Body1 [ferrite - Copy] = imported_body(C:\Users\karlr\Documents\flatwise_v3\Flatwise_1kW_final.step)
  Body1_1, Body1_2 [aluminum] = imported_body(C:\Users\karlr\Documents\flatwise_v3\Flatwise_1kW_final.step)
  Body1_3 [ferrite - Copy] = imported_body(C:\Users\karlr\Documents\flatwise_v3\Flatwise_1kW_final.step)
  Body1_4, Body1_5 [aluminum] = imported_body(C:\Users\karlr\Documents\flatwise_v3\Flatwise_1kW_final.step)
  Np1_Section1 = Np1.section(plane=ZX)
  Np2_Section1 = Np2.section(plane=ZX)
  Np3_Section1 [copper] = Np3.section(plane=ZX)
  Np4_Section1 [copper] = Np4.section(plane=ZX)
  Np5_Section1 [copper] = Np5.section(plane=ZX)
  Np6_Section1 [copper] = Np6.section(plane=ZX)
  Np7_Section1 [copper] = Np7.section(plane=ZX)
  Np8_Section1 [copper] = Np8.section(plane=ZX)
  Ns1_Section1 = Ns1.section(plane=ZX)
  Ns2_Section1 = Ns2.section(plane=ZX)
  Ns3_Section1 [copper] = Ns3.section(plane=ZX)
  Ns4_Section1 [copper] = Ns4.section(plane=ZX)
  Ns5_Section1 [copper] = Ns5.section(plane=ZX)
  Ns6_Section1 [copper] = Ns6.section(plane=ZX)
  Ns7_Section1 [copper] = Ns7.section(plane=ZX)
  Ns8_Section1 [copper] = Ns8.section(plane=ZX)
  Np1_Section1_Separate1 [copper] = Np1_Section1.separate_bodies()
  Np1_Section1.delete()
  Np2_Section1_Separate1 [copper] = Np2_Section1.separate_bodies()
  Np2_Section1.delete()
  Np3_Section1.separate_bodies()
  Np4_Section1.separate_bodies()
  Np5_Section1.separate_bodies()
  Np6_Section1.separate_bodies()
  Np7_Section1.separate_bodies()
  Np8_Section1.separate_bodies()
  Ns1_Section1_Separate1 [copper] = Ns1_Section1.separate_bodies()
  Ns1_Section1.delete()
  Ns2_Section1_Separate1 [copper] = Ns2_Section1.separate_bodies()
  Ns2_Section1.delete()
  Ns3_Section1.separate_bodies()
  Ns4_Section1.separate_bodies()
  Ns5_Section1.separate_bodies()
  Ns6_Section1.separate_bodies()
  Ns7_Section1.separate_bodies()
  Ns8_Section1.separate_bodies()
  Region [vacuum] = region(percentage_offset=0 on all sides)
  group core_assembled_flatwise = Np1..Np8, Ns1..Ns8, plate_1, plate_2, Np3_Section1, Np4_Section1, Np5_Section1, Np6_Section1, Np7_Section1, Np8_Section1, Ns3_Section1, Ns4_Section1, Ns5_Section1, Ns6_Section1, Ns7_Section1, Ns8_Section1, Np1_Section1_Separate1, Np2_Section1_Separate1, Ns1_Section1_Separate1, Ns2_Section1_Separate1
  group core_together_1 = Body1, Body1_1, Body1_2
  group core_together = Body1_3, Body1_4, Body1_5
boundaries and excitations:
  Np: Voltage Objects=[Np1..Np8] Voltage=100V
  Ns: Voltage Objects=[Ns1..Ns8] Voltage=100V
parameters:
  Matrix1: Matrix Np, Ns: NumberOfTurns=1
mesh:
  Length1: LengthBased Objects=[plate_1, plate_2, Np1..Np8, Ns1..Ns8] MaxLength=1.5mm
  Length2: LengthBased Objects=[Body1_1, Body1_2, Body1, Body1_4, Body1_5, Body1_3] MaxLength=4.5mm
  initial mesh: GlobalSurfApproximation{CurvedSurfaceApproxChoice=UseSlider SliderMeshSettings=9} GlobalCurvilinear{Apply}
setups:
  Setup1: Electrostatic MaximumPasses=20 MinimumPasses=2 MinimumConvergedPasses=1 PercentRefinement=30 PercentError=1 NonLinearResidual=0.001
