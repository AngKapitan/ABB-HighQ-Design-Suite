# Ansys Electronics Desktop project, version 2025.1
materials:
  vacuum: permittivity=1

design Maxwell3DDesign1 (Maxwell 3D, EddyCurrent, model units mm)
geometry:
  Np1, Np10, Np11, Np12, Np2..Np9, Ns1, Ns10, Ns11, Ns12, Ns2..Ns9, plate_1, plate_2, Body1, Body1_1..Body1_5 = imported_body(C:\Users\karlr\Documents\0.3_flatwise_bigairgap.step)
  group core_assembled_flatwise = Np1, Np10, Np11, Np12, Np2..Np9, Ns1, Ns10, Ns11, Ns12, Ns2..Ns9, plate_1, plate_2
  group core_together_1 = Body1, Body1_1, Body1_2
  group core_together = Body1_3, Body1_4, Body1_5
mesh:
  initial mesh: GlobalCurvilinear{Apply}
