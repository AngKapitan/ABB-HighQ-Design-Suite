# Ansys Electronics Desktop project, version 2023.1
project datasets:
  $f_Pcv: (94451.011, 10.239803) (100000, 11.257915) (111386.35, 13.607888) (122505.13, 15.87399) (133035.31, 18.517463) (139960.51, 20.118799) (151030.05, 22.919537) (165055.82, 26.110164) (176983.95, 29.394602) (185019.55, 31.56039) (190981.69, 33.486623) (199652.84, 35.953911) (212727.53, 40.476609) (223801.12, 45.031488) (236949.42, 50.098933) (247707.64, 54.431344) (257316.91, 58.441835) (265608.78, 62.747818) (279435.12, 68.986642) (292122.32, 74.952408) (299629.12, 79.526996) (311252.57, 85.38653) (323326.93, 90.597946) (333745.93, 96.127432) (342322.36, 100.79304) (353353.47, 106.94476) (362433.76, 112.13539) (374112.96, 117.57795) (383726.72, 124.75412) (396092.07, 133.94598) (408855.88, 142.12113) (424716.54, 152.59259) (435630.68, 165.78836) (443999.95, 173.835) (455409.62, 182.27219) (467112.5, 193.39685) (482164.9, 205.20049) (500869.42, 225.60295) (520299.54, 242.22533) (540483.41, 266.30906) (557900.14, 289.33869) (575878.12, 306.99797) (598218.04, 333.54627) (621424.58, 358.1219) (641449.59, 384.50825) (657933.22, 412.83874) (674840.44, 432.87613) (696586.75, 453.88604) (714487.26, 487.32828) (732847.78, 517.0715) (756463.33, 548.63005) (775902.52, 575.25815) (795841.25, 610.36801) (821486.73, 655.33981) (847958.61, 703.62512) (880853.29, 764.47259) (909238.23, 811.13083) (938537.85, 870.89479) (962655.89, 924.04832) (987393.71, 968.89758)
materials:
  aluminum: permeability=1.000021 conductivity=38000000 thermal_conductivity=237.5 mass_density=2689 specific_heat=951 youngs_modulus=69000000000 poissons_ratio=0.31 thermal_expansion_coefficient=2.33e-05
  copper: permeability=0.999991 conductivity=58000000 thermal_conductivity=400 mass_density=8933 specific_heat=385 youngs_modulus=120000000000 poissons_ratio=0.38 thermal_expansion_coefficient=1.77e-05
  ferrite - Copy (2): core_loss_curve{25kHz (0, 0) (0.050633, 1) (0.0590114, 1.50406) (0.0691674, 2.34392) (0.0792528, 3.65275) (0.088772, 5.02746) (0.0939521, 6.11121) (0.1, 7.16954) (0.109499, 8.56175) (0.121957, 11.5767) (0.138164, 16.5092) (0.153013, 23.1293) (0.173347, 32.9841) (0.195272, 44.5991) (0.21382, 61.3838) (0.235462, 78.6962) (0.259294, 104.536) (0.280722, 138.862) (0.295422, 151.746)} core_loss_curve{100kHz (0, 0) (0.0263744, 1.03613) (0.0293752, 1.42608) (0.0332788, 2.03369) (0.0396755, 3.1693) (0.0449479, 4.44016) (0.0523856, 6.91954) (0.0628101, 11.373) (0.0753091, 20.068) (0.0882699, 32.4039) (0.103461, 49.6099) (0.118547, 74.6161) (0.142138, 118.363) (0.165658, 191.122) (0.184506, 245.025) (0.1975, 325.48) (0.215037, 409.937) (0.242235, 554.291) (0.26827, 762.898) (0.287163, 911.04)} core_loss_curve{200kHz (0, 0) (0.0153013, 1.07357) (0.0196383, 2.03369) (0.0260769, 4.28533) (0.0305648, 7.42858) (0.0396755, 14.0722) (0.0481134, 22.7224) (0.059347, 38.6962) (0.0757374, 74.6161) (0.0994345, 162.909) (0.110748, 216.401) (0.130546, 319.755) (0.147894, 472.47) (0.164721, 605.722) (0.183462, 848.612) (0.194168, 1013.4) (0.210213, 1167.99) (0.235462, 1607.55) (0.252045, 2024.69) (0.274425, 2333.54) (0.290439, 2939.06)} core_loss_curve{500kHz (0, 0) (0.0101716, 5.89811) (0.01199, 8.71505) (0.0149581, 13.5815) (0.0170423, 18.6929) (0.0202031, 30.1834) (0.0235462, 38.6962) (0.0266752, 55.1837) (0.0309135, 72.0142) (0.0356225, 99.1166) (0.0401281, 129.346) (0.0465037, 187.76) (0.0515018, 236.481) (0.0580159, 319.755) (0.067616, 447.974) (0.0761681, 574.318) (0.0892769, 776.557) (0.101141, 1068.81) (0.1199, 1524.21) (0.142138, 2292.49) (0.174333, 3327.81) (0.199753, 5186.04) (0.22248, 6531.74) (0.249202, 8373.92)} permittivity=12 permeability=3400 conductivity=0.25 thermal_conductivity=4 core_loss_type="Power Ferrite" core_loss_cm=0.062032234 core_loss_x=1.7066326 core_loss_y=2.5354555 mass_density=4800 specific_heat=750 youngs_modulus=119000000000 thermal_expansion_coefficient=1e-05 core_loss_equiv_cut_depth=0.001meter
  silicon - Copy: permittivity=9 thermal_conductivity=10 mass_density=3700 specific_heat=712 youngs_modulus=135000000000 poissons_ratio=0.25 thermal_expansion_coefficient=2.54e-06
  vacuum: permittivity=1
  air: permittivity=1.0006 permeability=1.0000004 thermal_conductivity=0.0261 mass_density=1.1614 specific_heat=1005 thermal_expansion_coefficient=0.00333 thermal_material_type=Fluid diffusivity=2.88e-05 molecular_mass=0.028966 viscosity=1.84e-05 material_refractive_index=1.000293
  Al-Extruded: thermal_conductivity=205 mass_density=2800 specific_heat=900 youngs_modulus=69000000000 poissons_ratio=0.33 thermal_expansion_coefficient=2.277e-06 thermal_material_type=Solid
  coppe_real: permeability=0.999991 conductivity=59880239.52 thermal_conductivity=393 mass_density=8890 specific_heat=385 youngs_modulus=111000000000 poissons_ratio=0.38 thermal_expansion_coefficient=1.7e-05
  ferrite - real: core_loss_curve{25kHz (0, 0) (0.050633, 1) (0.0590114, 1.50406) (0.0691674, 2.34392) (0.0792528, 3.65275) (0.088772, 5.02746) (0.0939521, 6.11121) (0.1, 7.16954) (0.109499, 8.56175) (0.121957, 11.5767) (0.138164, 16.5092) (0.153013, 23.1293) (0.173347, 32.9841) (0.195272, 44.5991) (0.21382, 61.3838) (0.235462, 78.6962) (0.259294, 104.536) (0.280722, 138.862) (0.295422, 151.746)} core_loss_curve{100kHz (0, 0) (0.0263744, 1.03613) (0.0293752, 1.42608) (0.0332788, 2.03369) (0.0396755, 3.1693) (0.0449479, 4.44016) (0.0523856, 6.91954) (0.0628101, 11.373) (0.0753091, 20.068) (0.0882699, 32.4039) (0.103461, 49.6099) (0.118547, 74.6161) (0.142138, 118.363) (0.165658, 191.122) (0.184506, 245.025) (0.1975, 325.48) (0.215037, 409.937) (0.242235, 554.291) (0.26827, 762.898) (0.287163, 911.04)} core_loss_curve{200kHz (0, 0) (0.0153013, 1.07357) (0.0196383, 2.03369) (0.0260769, 4.28533) (0.0305648, 7.42858) (0.0396755, 14.0722) (0.0481134, 22.7224) (0.059347, 38.6962) (0.0757374, 74.6161) (0.0994345, 162.909) (0.110748, 216.401) (0.130546, 319.755) (0.147894, 472.47) (0.164721, 605.722) (0.183462, 848.612) (0.194168, 1013.4) (0.210213, 1167.99) (0.235462, 1607.55) (0.252045, 2024.69) (0.274425, 2333.54) (0.290439, 2939.06)} core_loss_curve{500kHz (0, 0) (0.0101716, 5.89811) (0.01199, 8.71505) (0.0149581, 13.5815) (0.0170423, 18.6929) (0.0202031, 30.1834) (0.0235462, 38.6962) (0.0266752, 55.1837) (0.0309135, 72.0142) (0.0356225, 99.1166) (0.0401281, 129.346) (0.0465037, 187.76) (0.0515018, 236.481) (0.0580159, 319.755) (0.067616, 447.974) (0.0761681, 574.318) (0.0892769, 776.557) (0.101141, 1068.81) (0.1199, 1524.21) (0.142138, 2292.49) (0.174333, 3327.81) (0.199753, 5186.04) (0.22248, 6531.74) (0.249202, 8373.92)} permittivity=12 permeability=3300 conductivity=0.25 thermal_conductivity=4 core_loss_type="Power Ferrite" core_loss_cm=2.0420624 core_loss_x=1.4062949 core_loss_y=2.7267175 mass_density=4800 specific_heat=750 youngs_modulus=119000000000 thermal_expansion_coefficient=1e-05 core_loss_equiv_cut_depth=0.001meter
  aluminum_real: permeability=1.000021 conductivity=38000000 thermal_conductivity=176.5 mass_density=2700 specific_heat=897 youngs_modulus=69000000000 poissons_ratio=0.31 thermal_expansion_coefficient=2.32e-05
  silicon_TIMreal: permittivity=7 conductivity=1e-11 thermal_conductivity=10 mass_density=3500 specific_heat=712 youngs_modulus=135000000000 poissons_ratio=0.25 thermal_expansion_coefficient=2.54e-06
  ferrite - real2: core_loss_curve{25kHz (0, 0) (0.050633, 1) (0.0590114, 1.50406) (0.0691674, 2.34392) (0.0792528, 3.65275) (0.088772, 5.02746) (0.0939521, 6.11121) (0.1, 7.16954) (0.109499, 8.56175) (0.121957, 11.5767) (0.138164, 16.5092) (0.153013, 23.1293) (0.173347, 32.9841) (0.195272, 44.5991) (0.21382, 61.3838) (0.235462, 78.6962) (0.259294, 104.536) (0.280722, 138.862) (0.295422, 151.746)} core_loss_curve{100kHz (0, 0) (0.0263744, 1.03613) (0.0293752, 1.42608) (0.0332788, 2.03369) (0.0396755, 3.1693) (0.0449479, 4.44016) (0.0523856, 6.91954) (0.0628101, 11.373) (0.0753091, 20.068) (0.0882699, 32.4039) (0.103461, 49.6099) (0.118547, 74.6161) (0.142138, 118.363) (0.165658, 191.122) (0.184506, 245.025) (0.1975, 325.48) (0.215037, 409.937) (0.242235, 554.291) (0.26827, 762.898) (0.287163, 911.04)} core_loss_curve{200kHz (0, 0) (0.0153013, 1.07357) (0.0196383, 2.03369) (0.0260769, 4.28533) (0.0305648, 7.42858) (0.0396755, 14.0722) (0.0481134, 22.7224) (0.059347, 38.6962) (0.0757374, 74.6161) (0.0994345, 162.909) (0.110748, 216.401) (0.130546, 319.755) (0.147894, 472.47) (0.164721, 605.722) (0.183462, 848.612) (0.194168, 1013.4) (0.210213, 1167.99) (0.235462, 1607.55) (0.252045, 2024.69) (0.274425, 2333.54) (0.290439, 2939.06)} core_loss_curve{500kHz (0, 0) (0.0101716, 5.89811) (0.01199, 8.71505) (0.0149581, 13.5815) (0.0170423, 18.6929) (0.0202031, 30.1834) (0.0235462, 38.6962) (0.0266752, 55.1837) (0.0309135, 72.0142) (0.0356225, 99.1166) (0.0401281, 129.346) (0.0465037, 187.76) (0.0515018, 236.481) (0.0580159, 319.755) (0.067616, 447.974) (0.0761681, 574.318) (0.0892769, 776.557) (0.101141, 1068.81) (0.1199, 1524.21) (0.142138, 2292.49) (0.174333, 3327.81) (0.199753, 5186.04) (0.22248, 6531.74) (0.249202, 8373.92)} permittivity=12 permeability=3300 conductivity=0.25 thermal_conductivity=4 core_loss_type="Power Ferrite" core_loss_cm=2.0420624 core_loss_x=1.4062949 core_loss_y=2.7267175 mass_density=4800 specific_heat=750 youngs_modulus=119000000000 thermal_expansion_coefficient=1e-05 core_loss_equiv_cut_depth=0.001meter
  Material1: thermal_conductivity=0.14 mass_density=600 specific_heat=1600
  polyimide: permittivity=3.5 dielectric_loss_tangent=0.008 thermal_conductivity=0.25 mass_density=1400 specific_heat=1150 youngs_modulus=7500000000 poissons_ratio=0.35 thermal_expansion_coefficient=7e-05
  kapton_real: permittivity=3.5 dielectric_loss_tangent=0.008 thermal_conductivity=0.2 mass_density=1420 specific_heat=1090 youngs_modulus=7500000000 poissons_ratio=0.35 thermal_expansion_coefficient=7e-05
  Acrylic Resin-JSME: thermal_conductivity=0.21 mass_density=1190 specific_heat=1400 thermal_material_type=Solid
surface materials:
  Steel-oxidised-surface: surface_emissivity=0.8

design Flatwise_0.30_interleaved_full_old (Maxwell 3D, EddyCurrent, model units mm)
variables:
  freq_hz = 28500Hz
  volt_ac = 141/28500*Freq
geometry:
  Region [vacuum] = region(percentage_offset=0 on all sides)
  Np1..Np8, Ns1..Ns8 [copper] = imported_body(C:\Users\karlr\Documents\ICMaSS_sweeping\flatwise_0.1_0.3.step)
  plate_1, plate_2 [silicon - Copy] = imported_body(C:\Users\karlr\Documents\ICMaSS_sweeping\flatwise_0.1_0.3.step)
  Body1 [ferrite - Copy (2)] = imported_body(C:\Users\karlr\Documents\ICMaSS_sweeping\flatwise_0.1_0.3.step)
  Body1_1, Body1_2 [aluminum] = imported_body(C:\Users\karlr\Documents\ICMaSS_sweeping\flatwise_0.1_0.3.step)
  Body1_3 [ferrite - Copy (2)] = imported_body(C:\Users\karlr\Documents\ICMaSS_sweeping\flatwise_0.1_0.3.step)
  Body1_4, Body1_5 [aluminum] = imported_body(C:\Users\karlr\Documents\ICMaSS_sweeping\flatwise_0.1_0.3.step)
  Np1_Section1 = Np1.section(plane=ZX)
  Np2_Section1 = Np2.section(plane=ZX)
  Np3_Section1 [copper] = Np3.section(plane=ZX)
  Np4_Section1 [copper] = Np4.section(plane=ZX)
  Np5_Section1 [copper] = Np5.section(plane=ZX)
  Np6_Section1 [copper] = Np6.section(plane=ZX)
  Np7_Section1 [copper] = Np7.section(plane=ZX)
  Np8_Section1 [copper] = Np8.section(plane=ZX)
  Ns1_Section1 = Ns1.section(plane=ZX)
  Ns2_Section1 = Ns2.section(plane=ZX)
  Ns3_Section1 [copper] = Ns3.section(plane=ZX)
  Ns4_Section1 [copper] = Ns4.section(plane=ZX)
  Ns5_Section1 [copper] = Ns5.section(plane=ZX)
  Ns6_Section1 [copper] = Ns6.section(plane=ZX)
  Ns7_Section1 [copper] = Ns7.section(plane=ZX)
  Ns8_Section1 [copper] = Ns8.section(plane=ZX)
  Np1_Section1_Separate1 [copper] = Np1_Section1.separate_bodies()
  Np1_Section1.delete()
  Np2_Section1_Separate1 [copper] = Np2_Section1.separate_bodies()
  Np2_Section1.delete()
  Np3_Section1.separate_bodies()
  Np4_Section1.separate_bodies()
  Np5_Section1.separate_bodies()
  Np6_Section1.separate_bodies()
  Np7_Section1.separate_bodies()
  Np8_Section1.separate_bodies()
  Ns1_Section1_Separate1 [copper] = Ns1_Section1.separate_bodies()
  Ns1_Section1.delete()
  Ns2_Section1_Separate1 [copper] = Ns2_Section1.separate_bodies()
  Ns2_Section1.delete()
  Ns3_Section1.separate_bodies()
  Ns4_Section1.separate_bodies()
  Ns5_Section1.separate_bodies()
  Ns6_Section1.separate_bodies()
  Ns7_Section1.separate_bodies()
  Ns8_Section1.separate_bodies()
  Rectangle1 [non-model] = rectangle(corner=(36.6mm, 25.43mm, 1.6666608e-08mm), z_size=18.666667mm, x_size=-36.6mm)
  [Np1..Np8, Ns1..Ns8, plate_1, plate_2, Body1, Body1_1..Body1_5, Np3_Section1, Np4_Section1, Np5_Section1, Np6_Section1, Np7_Section1, Np8_Section1, Ns3_Section1, Ns4_Section1, Ns5_Section1, Ns6_Section1, Ns7_Section1, Ns8_Section1, Np1_Section1_Separate1, Np2_Section1_Separate1, Ns1_Section1_Separate1, Ns2_Section1_Separate1, Rectangle1].move(-18.3mm, -25.43mm, -0.38333333mm)
  [Np1..Np8, Ns1..Ns8, plate_1, plate_2, Body1, Body1_1..Body1_5, Np3_Section1, Np4_Section1, Np5_Section1, Np6_Section1, Np7_Section1, Np8_Section1, Ns3_Section1, Ns4_Section1, Ns5_Section1, Ns6_Section1, Ns7_Section1, Ns8_Section1, Np1_Section1_Separate1, Np2_Section1_Separate1, Ns1_Section1_Separate1, Ns2_Section1_Separate1, Rectangle1].move(-5mm, 0mm, -6.7583333mm)
  Rectangle2 [non-model] = rectangle(corner=(7.3mm, -32.73mm, 2.1916667mm), x_size=-24.6mm, y_size=65.46mm)
  group core_assembled_flatwise = Np1..Np8, Ns1..Ns8, plate_1, plate_2, Np3_Section1, Np4_Section1, Np5_Section1, Np6_Section1, Np7_Section1, Np8_Section1, Ns3_Section1, Ns4_Section1, Ns5_Section1, Ns6_Section1, Ns7_Section1, Ns8_Section1, Np1_Section1_Separate1, Np2_Section1_Separate1, Ns1_Section1_Separate1, Ns2_Section1_Separate1
  group core_together_1 = Body1, Body1_1, Body1_2
  group core_together = Body1_3, Body1_4, Body1_5
boundaries and excitations:
  Ns_1: Coil Terminal Objects=Ns1_Section1_Separate1 Conductor_number=1 Winding=Ns Point_out_of_terminal=true
  Ns_2: Coil Terminal Objects=Ns2_Section1_Separate1 Conductor_number=1 Winding=Ns Point_out_of_terminal=true
  Ns_3: Coil Terminal Objects=Ns3_Section1 Conductor_number=1 Winding=Ns Point_out_of_terminal=true
  Ns_4: Coil Terminal Objects=Ns4_Section1 Conductor_number=1 Winding=Ns Point_out_of_terminal=true
  Ns_5: Coil Terminal Objects=Ns5_Section1 Conductor_number=1 Winding=Ns Point_out_of_terminal=true
  Ns_6: Coil Terminal Objects=Ns6_Section1 Conductor_number=1 Winding=Ns Point_out_of_terminal=true
  Ns_7: Coil Terminal Objects=Ns7_Section1 Conductor_number=1 Winding=Ns Point_out_of_terminal=true
  Ns_8: Coil Terminal Objects=Ns8_Section1 Conductor_number=1 Winding=Ns Point_out_of_terminal=true
  Np_1: Coil Terminal Objects=Np1_Section1_Separate1 Conductor_number=1 Winding=Np Point_out_of_terminal=false
  Np_2: Coil Terminal Objects=Np2_Section1_Separate1 Conductor_number=1 Winding=Np Point_out_of_terminal=false
  Np_3: Coil Terminal Objects=Np3_Section1 Conductor_number=1 Winding=Np Point_out_of_terminal=false
  Np_4: Coil Terminal Objects=Np4_Section1 Conductor_number=1 Winding=Np Point_out_of_terminal=false
  Np_5: Coil Terminal Objects=Np5_Section1 Conductor_number=1 Winding=Np Point_out_of_terminal=false
  Np_6: Coil Terminal Objects=Np6_Section1 Conductor_number=1 Winding=Np Point_out_of_terminal=false
  Np_7: Coil Terminal Objects=Np7_Section1 Conductor_number=1 Winding=Np Point_out_of_terminal=false
  Np_8: Coil Terminal Objects=Np8_Section1 Conductor_number=1 Winding=Np Point_out_of_terminal=false
  Np: Winding Group Type=Voltage IsSolid=true Current=16.36A Resistance=0ohm Inductance=0nH Voltage=volt_ac ParallelBranchesNum=1 Phase=0rad
  Ns: Winding Group Type=Current IsSolid=true Current=1000*1.41/volt_ac*1.414 ParallelBranchesNum=1 Phase=0.1522rad
  core loss on: Body1, Body1_3
parameters:
  Matrix1: Matrix Np, Ns:
mesh:
  Length1: LengthBased Objects=[Body1, Body1_1..Body1_5] MaxLength=2mm
  SkinDepth1: SkinDepthBased Objects=[Np1..Np8, Ns1..Ns8, plate_1, plate_2] SkinDepth=0.020898162mm SurfTriMaxLength=1mm NumLayers=2
  initial mesh: GlobalSurfApproximation{CurvedSurfaceApproxChoice=UseSlider SliderMeshSettings=9} GlobalCurvilinear{Apply}
setups:
  Setup1: EddyCurrent MaximumPasses=20 MinimumPasses=2 MinimumConvergedPasses=1 PercentRefinement=30 PercentError=1 NonLinearResidual=0.0001 SmoothBHCurve Frequency=10MHz SweepRanges{0.1Hz to 1Hz, log, 1 per decade 1Hz to 1000Hz, log, 5 per decade 1000Hz to 10000Hz, log, 10 per decade 10000Hz to 100000Hz, log, 10 per decade 100000Hz to 1000000Hz, log, 10 per decade} SaveAllFields
field plots:
  Mag_B1: B over a plane on Setup1 : LastAdaptive at Freq=1MHz Phase=45deg
  Mesh1: MeshPlots in Np1..Np8, Ns1..Ns8 on Setup1 : LastAdaptive at Freq=1000000Hz Phase=0deg
  Mesh2: MeshPlots over a plane on Setup1 : LastAdaptive at Freq=10000000Hz Phase=0deg
  Mag_J1: J over a plane on Setup1 : LastAdaptive at Freq=25.1189kHz Phase=45deg
reports:
  L Table 1: Matrix1.L(Np,Np), Matrix1.L(Ns,Np), Matrix1.L(Np,Ns), Matrix1.L(Ns,Ns), Matrix1.R(Np,Np), Matrix1.R(Ns,Np), Matrix1.R(Np,Ns), Matrix1.R(Ns,Ns) vs Freq on Setup1 : LastAdaptive

design Flatwise_0.30_interleaved_fullmesh (Maxwell 3D, EddyCurrent, model units mm)
variables:
  freq_hz = 28500Hz
  volt_ac = 141/28500*Freq
geometry:
  Region [vacuum] = region(percentage_offset=0 on all sides)
  Np1..Np8, Ns1..Ns8 [coppe_real] = imported_body(C:\Users\karlr\Documents\ICMaSS_sweeping\flatwise_0.1_0.3.step)
  plate_1, plate_2 [silicon - Copy] = imported_body(C:\Users\karlr\Documents\ICMaSS_sweeping\flatwise_0.1_0.3.step)
  Body1 [ferrite - real] = imported_body(C:\Users\karlr\Documents\ICMaSS_sweeping\flatwise_0.1_0.3.step)
  Body1_1, Body1_2 [aluminum] = imported_body(C:\Users\karlr\Documents\ICMaSS_sweeping\flatwise_0.1_0.3.step)
  Body1_3 [ferrite - Copy (2)] = imported_body(C:\Users\karlr\Documents\ICMaSS_sweeping\flatwise_0.1_0.3.step)
  Body1_4, Body1_5 [aluminum] = imported_body(C:\Users\karlr\Documents\ICMaSS_sweeping\flatwise_0.1_0.3.step)
  Np1_Section1 = Np1.section(plane=ZX)
  Np2_Section1 = Np2.section(plane=ZX)
  Np3_Section1 [copper] = Np3.section(plane=ZX)
  Np4_Section1 [copper] = Np4.section(plane=ZX)
  Np5_Section1 [copper] = Np5.section(plane=ZX)
  Np6_Section1 [copper] = Np6.section(plane=ZX)
  Np7_Section1 [copper] = Np7.section(plane=ZX)
  Np8_Section1 [copper] = Np8.section(plane=ZX)
  Ns1_Section1 = Ns1.section(plane=ZX)
  Ns2_Section1 = Ns2.section(plane=ZX)
  Ns3_Section1 [copper] = Ns3.section(plane=ZX)
  Ns4_Section1 [copper] = Ns4.section(plane=ZX)
  Ns5_Section1 [copper] = Ns5.section(plane=ZX)
  Ns6_Section1 [copper] = Ns6.section(plane=ZX)
  Ns7_Section1 [copper] = Ns7.section(plane=ZX)
  Ns8_Section1 [copper] = Ns8.section(plane=ZX)
  Np1_Section1_Separate1 [copper] = Np1_Section1.separate_bodies()
  Np1_Section1.delete()
  Np2_Section1_Separate1 [copper] = Np2_Section1.separate_bodies()
  Np2_Section1.delete()
  Np3_Section1.separate_bodies()
  Np4_Section1.separate_bodies()
  Np5_Section1.separate_bodies()
  Np6_Section1.separate_bodies()
  Np7_Section1.separate_bodies()
  Np8_Section1.separate_bodies()
  Ns1_Section1_Separate1 [copper] = Ns1_Section1.separate_bodies()
  Ns1_Section1.delete()
  Ns2_Section1_Separate1 [copper] = Ns2_Section1.separate_bodies()
  Ns2_Section1.delete()
  Ns3_Section1.separate_bodies()
  Ns4_Section1.separate_bodies()
  Ns5_Section1.separate_bodies()
  Ns6_Section1.separate_bodies()
  Ns7_Section1.separate_bodies()
  Ns8_Section1.separate_bodies()
  Rectangle1 [non-model] = rectangle(corner=(36.6mm, 25.43mm, 1.6666608e-08mm), z_size=18.666667mm, x_size=-36.6mm)
  [Np1..Np8, Ns1..Ns8, plate_1, plate_2, Body1, Body1_1..Body1_5, Np3_Section1, Np4_Section1, Np5_Section1, Np6_Section1, Np7_Section1, Np8_Section1, Ns3_Section1, Ns4_Section1, Ns5_Section1, Ns6_Section1, Ns7_Section1, Ns8_Section1, Np1_Section1_Separate1, Np2_Section1_Separate1, Ns1_Section1_Separate1, Ns2_Section1_Separate1, Rectangle1].move(-18.3mm, -25.43mm, -0.38333333mm)
  [Np1..Np8, Ns1..Ns8, plate_1, plate_2, Body1, Body1_1..Body1_5, Np3_Section1, Np4_Section1, Np5_Section1, Np6_Section1, Np7_Section1, Np8_Section1, Ns3_Section1, Ns4_Section1, Ns5_Section1, Ns6_Section1, Ns7_Section1, Ns8_Section1, Np1_Section1_Separate1, Np2_Section1_Separate1, Ns1_Section1_Separate1, Ns2_Section1_Separate1, Rectangle1].move(-5mm, 0mm, -6.7583333mm)
  group core_assembled_flatwise = Np1..Np8, Ns1..Ns8, plate_1, plate_2, Np3_Section1, Np4_Section1, Np5_Section1, Np6_Section1, Np7_Section1, Np8_Section1, Ns3_Section1, Ns4_Section1, Ns5_Section1, Ns6_Section1, Ns7_Section1, Ns8_Section1, Np1_Section1_Separate1, Np2_Section1_Separate1, Ns1_Section1_Separate1, Ns2_Section1_Separate1
  group core_together_1 = Body1, Body1_1, Body1_2
  group core_together = Body1_3, Body1_4, Body1_5
boundaries and excitations:
  Ns_1: Coil Terminal Objects=Ns1_Section1_Separate1 Conductor_number=1 Winding=Ns Point_out_of_terminal=true
  Ns_2: Coil Terminal Objects=Ns2_Section1_Separate1 Conductor_number=1 Winding=Ns Point_out_of_terminal=true
  Ns_3: Coil Terminal Objects=Ns3_Section1 Conductor_number=1 Winding=Ns Point_out_of_terminal=true
  Ns_4: Coil Terminal Objects=Ns4_Section1 Conductor_number=1 Winding=Ns Point_out_of_terminal=true
  Ns_5: Coil Terminal Objects=Ns5_Section1 Conductor_number=1 Winding=Ns Point_out_of_terminal=true
  Ns_6: Coil Terminal Objects=Ns6_Section1 Conductor_number=1 Winding=Ns Point_out_of_terminal=true
  Ns_7: Coil Terminal Objects=Ns7_Section1 Conductor_number=1 Winding=Ns Point_out_of_terminal=true
  Ns_8: Coil Terminal Objects=Ns8_Section1 Conductor_number=1 Winding=Ns Point_out_of_terminal=true
  Np_1: Coil Terminal Objects=Np1_Section1_Separate1 Conductor_number=1 Winding=Np Point_out_of_terminal=false
  Np_2: Coil Terminal Objects=Np2_Section1_Separate1 Conductor_number=1 Winding=Np Point_out_of_terminal=false
  Np_3: Coil Terminal Objects=Np3_Section1 Conductor_number=1 Winding=Np Point_out_of_terminal=false
  Np_4: Coil Terminal Objects=Np4_Section1 Conductor_number=1 Winding=Np Point_out_of_terminal=false
  Np_5: Coil Terminal Objects=Np5_Section1 Conductor_number=1 Winding=Np Point_out_of_terminal=false
  Np_6: Coil Terminal Objects=Np6_Section1 Conductor_number=1 Winding=Np Point_out_of_terminal=false
  Np_7: Coil Terminal Objects=Np7_Section1 Conductor_number=1 Winding=Np Point_out_of_terminal=false
  Np_8: Coil Terminal Objects=Np8_Section1 Conductor_number=1 Winding=Np Point_out_of_terminal=false
  Np: Winding Group Type=Voltage IsSolid=true Current=16.36A Resistance=0ohm Inductance=0nH Voltage=volt_ac ParallelBranchesNum=1 Phase=0rad
  Ns: Winding Group Type=Current IsSolid=true Current=1000*1.41/volt_ac*1.414 ParallelBranchesNum=1 Phase=0.1522rad
  core loss on: Body1, Body1_3
parameters:
  Matrix1: Matrix Np, Ns:
mesh:
  Length1: LengthBased Objects=[Body1, Body1_1..Body1_5] MaxLength=2mm
  SkinDepth1: SkinDepthBased Objects=[Np1..Np8, Ns1..Ns8, plate_1, plate_2] SkinDepth=0.20567444mm SurfTriMaxLength=0.3mm NumLayers=2
  initial mesh: GlobalSurfApproximation{CurvedSurfaceApproxChoice=UseSlider SliderMeshSettings=9} GlobalCurvilinear{Apply}
setups:
  Setup1: EddyCurrent MaximumPasses=20 MinimumPasses=2 MinimumConvergedPasses=1 PercentRefinement=30 PercentError=1 NonLinearResidual=0.0001 SmoothBHCurve Frequency=100kHz SweepRanges{point 28500Hz} SaveAllFields
field plots:
  Mag_B1: B over a plane on Setup1 : LastAdaptive at Freq=28500Hz Phase=45deg
  Mesh1: MeshPlots in Np1..Np8, Ns1..Ns8 on Setup1 : LastAdaptive at Freq=28500Hz Phase=0deg
reports:
  L Table 1: Matrix1.L(Np,Np), Matrix1.L(Ns,Np), Matrix1.L(Np,Ns), Matrix1.L(Ns,Ns), Matrix1.R(Np,Np), Matrix1.R(Ns,Np), Matrix1.R(Np,Ns), Matrix1.R(Ns,Ns) vs Freq on Setup1 : LastAdaptive

design Flatwise_100kW (Maxwell 3D, EddyCurrent, model units mm)
variables:
  freq_hz = 28500Hz
  volt_ac = 1410/28500*Freq
geometry:
  Region [vacuum] = region(percentage_offset=0 on all sides)
  Rectangle1 [non-model] = rectangle(corner=(0mm, 25.45mm, 0mm), z_size=18.7mm, x_size=38.6mm)
  Body1, Body1_1 [aluminum_real] = imported_body(D:\Karl_HighPower\flatwise_100kW.step)
  Body1_2 [ferrite - real2] = imported_body(D:\Karl_HighPower\flatwise_100kW.step)
  Body1_3, Body1_4 [aluminum_real] = imported_body(D:\Karl_HighPower\flatwise_100kW.step)
  Body1_5 [ferrite - real2] = imported_body(D:\Karl_HighPower\flatwise_100kW.step)
  plate_1, plate_2 [silicon_TIMreal] = imported_body(D:\Karl_HighPower\flatwise_100kW.step)
  Ns1, Ns7, Ns4, Ns8, Ns2, Ns6, Ns5, Ns3, Np1, Np7, Np4, Np8, Np2, Np6, Np5, Np3 [coppe_real] = imported_body(D:\Karl_HighPower\flatwise_100kW.step)
  Np1_Section1 [coppe_real] = Np1.section(plane=ZX)
  Np2_Section1 [coppe_real] = Np2.section(plane=ZX)
  Np3_Section1 [coppe_real] = Np3.section(plane=ZX)
  Np4_Section1 [coppe_real] = Np4.section(plane=ZX)
  Np5_Section1 [coppe_real] = Np5.section(plane=ZX)
  Np6_Section1 [coppe_real] = Np6.section(plane=ZX)
  Np7_Section1 [coppe_real] = Np7.section(plane=ZX)
  Np8_Section1 [coppe_real] = Np8.section(plane=ZX)
  Ns1_Section1 [coppe_real] = Ns1.section(plane=ZX)
  Ns2_Section1 [coppe_real] = Ns2.section(plane=ZX)
  Ns3_Section1 [coppe_real] = Ns3.section(plane=ZX)
  Ns4_Section1 [coppe_real] = Ns4.section(plane=ZX)
  Ns5_Section1 [coppe_real] = Ns5.section(plane=ZX)
  Ns6_Section1 [coppe_real] = Ns6.section(plane=ZX)
  Ns7_Section1 [coppe_real] = Ns7.section(plane=ZX)
  Ns8_Section1 [coppe_real] = Ns8.section(plane=ZX)
  Np1_Section1.separate_bodies()
  Np2_Section1.separate_bodies()
  Np3_Section1.separate_bodies()
  Np4_Section1.separate_bodies()
  Np5_Section1.separate_bodies()
  Np6_Section1.separate_bodies()
  Np7_Section1.separate_bodies()
  Np8_Section1.separate_bodies()
  Ns1_Section1.separate_bodies()
  Ns2_Section1.separate_bodies()
  Ns3_Section1.separate_bodies()
  Ns4_Section1.separate_bodies()
  Ns5_Section1.separate_bodies()
  Ns6_Section1.separate_bodies()
  Ns7_Section1.separate_bodies()
  Ns8_Section1.separate_bodies()
  Rectangle2 [non-model] = rectangle(corner=(0mm, 100.345mm, 0mm), z_size=89mm, x_size=127.6mm)
  group flatwise_100kW = Body1, Body1_1..Body1_5, plate_1, plate_2, Ns1, Ns7, Ns4, Ns8, Ns2, Ns6, Ns5, Ns3, Np1, Np7, Np4, Np8, Np2, Np6, Np5, Np3, Np1_Section1, Np2_Section1, Np3_Section1, Np4_Section1, Np5_Section1, Np6_Section1, Np7_Section1, Np8_Section1, Ns1_Section1, Ns2_Section1, Ns3_Section1, Ns4_Section1, Ns5_Section1, Ns6_Section1, Ns7_Section1, Ns8_Section1
boundaries and excitations:
  Np_1: Coil Terminal Objects=Np1_Section1 Conductor_number=1 Winding=Np Point_out_of_terminal=false
  Np_2: Coil Terminal Objects=Np2_Section1 Conductor_number=1 Winding=Np Point_out_of_terminal=false
  Np_3: Coil Terminal Objects=Np3_Section1 Conductor_number=1 Winding=Np Point_out_of_terminal=false
  Np_4: Coil Terminal Objects=Np4_Section1 Conductor_number=1 Winding=Np Point_out_of_terminal=false
  Np_5: Coil Terminal Objects=Np5_Section1 Conductor_number=1 Winding=Np Point_out_of_terminal=false
  Np_6: Coil Terminal Objects=Np6_Section1 Conductor_number=1 Winding=Np Point_out_of_terminal=false
  Np_7: Coil Terminal Objects=Np7_Section1 Conductor_number=1 Winding=Np Point_out_of_terminal=false
  Np_8: Coil Terminal Objects=Np8_Section1 Conductor_number=1 Winding=Np Point_out_of_terminal=false
  Ns_1: Coil Terminal Objects=Ns1_Section1 Conductor_number=1 Winding=Ns Point_out_of_terminal=true
  Ns_2: Coil Terminal Objects=Ns2_Section1 Conductor_number=1 Winding=Ns Point_out_of_terminal=true
  Ns_3: Coil Terminal Objects=Ns3_Section1 Conductor_number=1 Winding=Ns Point_out_of_terminal=true
  Ns_4: Coil Terminal Objects=Ns4_Section1 Conductor_number=1 Winding=Ns Point_out_of_terminal=true
  Ns_5: Coil Terminal Objects=Ns5_Section1 Conductor_number=1 Winding=Ns Point_out_of_terminal=true
  Ns_6: Coil Terminal Objects=Ns6_Section1 Conductor_number=1 Winding=Ns Point_out_of_terminal=true
  Ns_7: Coil Terminal Objects=Ns7_Section1 Conductor_number=1 Winding=Ns Point_out_of_terminal=true
  Ns_8: Coil Terminal Objects=Ns8_Section1 Conductor_number=1 Winding=Ns Point_out_of_terminal=true
  Np: Winding Group Type=Voltage IsSolid=true Current=16.36A Resistance=0ohm Inductance=0nH Voltage=volt_ac ParallelBranchesNum=1 Phase=0rad
  Ns: Winding Group Type=Current IsSolid=true Current=100000*1.41/volt_ac*1.414 ParallelBranchesNum=1 Phase=0.1522rad
  eddy effects on: Body1, Body1_1, Body1_3, Body1_4, Ns1, Ns7, Ns4, Ns8, Ns2, Ns6, Ns5, Ns3, Np1, Np7, Np4, Np8, Np2, Np6, Np5, Np3
  core loss on: Body1_2, Body1_5
parameters:
  Matrix1: Matrix Np, Ns:
mesh:
  SkinDepth1: SkinDepthBased disabled Objects=[Np1..Np8, Ns1..Ns8] SkinDepth=0.20567444mm SurfTriMaxLength=1mm NumLayers=2
  Length1: LengthBased Objects=[Body1, Body1_1, Body1_3, Body1_4, Body1_2, Body1_5, plate_1, plate_2] MaxLength=10mm
  Wire: LengthBased Objects=[Np1..Np8, Ns1..Ns8] MaxLength=5mm
  initial mesh: GlobalSurfApproximation{CurvedSurfaceApproxChoice=UseSlider SliderMeshSettings=9} GlobalCurvilinear{Apply}
setups:
  Setup1: EddyCurrent MaximumPasses=20 MinimumPasses=4 MinimumConvergedPasses=1 PercentRefinement=30 PercentError=1 NonLinearResidual=0.0001 SmoothBHCurve Frequency=28.5kHz SweepRanges{point 28500Hz} SaveAllFields
field plots:
  Mesh1: MeshPlots in Region on Setup1 : LastAdaptive at Freq=28500Hz Phase=0deg
  Mesh2: MeshPlots over a plane on Setup1 : LastAdaptive at Freq=28500Hz Phase=0deg
  Mag_B1: B over a plane on Setup1 : LastAdaptive at Freq=28500Hz Phase=45deg
  Mesh3: MeshPlots in Np1..Np8, Ns1..Ns8 on Setup1 : LastAdaptive at Freq=28500Hz Phase=0deg
reports:
  L Table 1: Matrix1.L(Np,Np), Matrix1.L(Ns,Np), Matrix1.L(Np,Ns), Matrix1.L(Ns,Ns), Matrix1.R(Np,Np), Matrix1.R(Ns,Np), Matrix1.R(Np,Ns), Matrix1.R(Ns,Ns) vs Freq on Setup1 : LastAdaptive

design Edgewise_100kW (Maxwell 3D, EddyCurrent, model units mm)
variables:
  freq_hz = 28500Hz
  volt_ac = 1410/28500*Freq
geometry:
  Region [vacuum] = region(percentage_offset=0 on all sides)
  Body1 [ferrite - real2] = imported_body(D:\Karl_HighPower\core_assembled_edgewise_100kW.step)
  Body1_1, Body1_2 [aluminum_real] = imported_body(D:\Karl_HighPower\core_assembled_edgewise_100kW.step)
  Body1_3 [ferrite - real2] = imported_body(D:\Karl_HighPower\core_assembled_edgewise_100kW.step)
  Body1_4, Body1_5 [aluminum_real] = imported_body(D:\Karl_HighPower\core_assembled_edgewise_100kW.step)
  plate1, plate2 [silicon_TIMreal] = imported_body(D:\Karl_HighPower\core_assembled_edgewise_100kW.step)
  Ns8, Ns4, Ns1, Ns5, Ns7, Ns3, Ns2, Ns6, Np8, Np4, Np1, Np5, Np7, Np3, Np2, Np6 [coppe_real] = imported_body(D:\Karl_HighPower\core_assembled_edgewise_100kW.step)
  Np1_Section1 [coppe_real] = Np1.section(plane=ZX)
  Np2_Section1 [coppe_real] = Np2.section(plane=ZX)
  Np3_Section1 [coppe_real] = Np3.section(plane=ZX)
  Np4_Section1 [coppe_real] = Np4.section(plane=ZX)
  Np5_Section1 [coppe_real] = Np5.section(plane=ZX)
  Np6_Section1 [coppe_real] = Np6.section(plane=ZX)
  Np7_Section1 [coppe_real] = Np7.section(plane=ZX)
  Np8_Section1 [coppe_real] = Np8.section(plane=ZX)
  Ns1_Section1 [coppe_real] = Ns1.section(plane=ZX)
  Ns2_Section1 [coppe_real] = Ns2.section(plane=ZX)
  Ns3_Section1 [coppe_real] = Ns3.section(plane=ZX)
  Ns4_Section1 [coppe_real] = Ns4.section(plane=ZX)
  Ns5_Section1 [coppe_real] = Ns5.section(plane=ZX)
  Ns6_Section1 [coppe_real] = Ns6.section(plane=ZX)
  Ns7_Section1 [coppe_real] = Ns7.section(plane=ZX)
  Ns8_Section1 [coppe_real] = Ns8.section(plane=ZX)
  Np1_Section1.separate_bodies()
  Np2_Section1.separate_bodies()
  Np3_Section1.separate_bodies()
  Np4_Section1.separate_bodies()
  Np5_Section1.separate_bodies()
  Np6_Section1.separate_bodies()
  Np7_Section1.separate_bodies()
  Np8_Section1.separate_bodies()
  Ns1_Section1.separate_bodies()
  Ns2_Section1.separate_bodies()
  Ns3_Section1.separate_bodies()
  Ns4_Section1.separate_bodies()
  Ns5_Section1.separate_bodies()
  Ns6_Section1.separate_bodies()
  Ns7_Section1.separate_bodies()
  Ns8_Section1.separate_bodies()
  Rectangle1 [non-model] = rectangle(corner=(178mm, 100.345mm, 0mm), z_size=63.8mm, x_size=-178mm)
  group core_assembled_edgewise_100kW = Body1, Body1_1..Body1_5, plate1, plate2, Ns8, Ns4, Ns1, Ns5, Ns7, Ns3, Ns2, Ns6, Np8, Np4, Np1, Np5, Np7, Np3, Np2, Np6, Np1_Section1, Np2_Section1, Np3_Section1, Np4_Section1, Np5_Section1, Np6_Section1, Np7_Section1, Np8_Section1, Ns1_Section1, Ns2_Section1, Ns3_Section1, Ns4_Section1, Ns5_Section1, Ns6_Section1, Ns7_Section1, Ns8_Section1
boundaries and excitations:
  Np_1: Coil Terminal Objects=Np1_Section1 Conductor_number=1 Winding=Np Point_out_of_terminal=false
  Np_2: Coil Terminal Objects=Np2_Section1 Conductor_number=1 Winding=Np Point_out_of_terminal=false
  Np_3: Coil Terminal Objects=Np3_Section1 Conductor_number=1 Winding=Np Point_out_of_terminal=false
  Np_4: Coil Terminal Objects=Np4_Section1 Conductor_number=1 Winding=Np Point_out_of_terminal=false
  Np_5: Coil Terminal Objects=Np5_Section1 Conductor_number=1 Winding=Np Point_out_of_terminal=false
  Np_6: Coil Terminal Objects=Np6_Section1 Conductor_number=1 Winding=Np Point_out_of_terminal=false
  Np_7: Coil Terminal Objects=Np7_Section1 Conductor_number=1 Winding=Np Point_out_of_terminal=false
  Np_8: Coil Terminal Objects=Np8_Section1 Conductor_number=1 Winding=Np Point_out_of_terminal=false
  Ns_1: Coil Terminal Objects=Ns1_Section1 Conductor_number=1 Winding=Ns Point_out_of_terminal=true
  Ns_2: Coil Terminal Objects=Ns2_Section1 Conductor_number=1 Winding=Ns Point_out_of_terminal=true
  Ns_3: Coil Terminal Objects=Ns3_Section1 Conductor_number=1 Winding=Ns Point_out_of_terminal=true
  Ns_4: Coil Terminal Objects=Ns4_Section1 Conductor_number=1 Winding=Ns Point_out_of_terminal=true
  Ns_5: Coil Terminal Objects=Ns5_Section1 Conductor_number=1 Winding=Ns Point_out_of_terminal=true
  Ns_6: Coil Terminal Objects=Ns6_Section1 Conductor_number=1 Winding=Ns Point_out_of_terminal=true
  Ns_7: Coil Terminal Objects=Ns7_Section1 Conductor_number=1 Winding=Ns Point_out_of_terminal=true
  Ns_8: Coil Terminal Objects=Ns8_Section1 Conductor_number=1 Winding=Ns Point_out_of_terminal=true
  Np: Winding Group Type=Voltage IsSolid=true Current=16.36A Resistance=0ohm Inductance=0nH Voltage=volt_ac ParallelBranchesNum=1 Phase=0rad
  Ns: Winding Group Type=Current IsSolid=true Current=100000*1.41/volt_ac*1.414 ParallelBranchesNum=1 Phase=0.1522rad
  eddy effects on: Body1_1, Body1_2, Body1_4, Body1_5, Ns8, Ns4, Ns1, Ns5, Ns7, Ns3, Ns2, Ns6, Np8, Np4, Np1, Np5, Np7, Np3, Np2, Np6
  core loss on: Body1, Body1_3
parameters:
  Matrix1: Matrix Np, Ns:
mesh:
  Length1: LengthBased Objects=[Body1, Body1_3, Body1_1, Body1_2, Body1_4, Body1_5, plate1, plate2] MaxLength=10mm
  Length2: LengthBased Objects=[Np1..Np8, Ns1..Ns8] MaxLength=5mm
  initial mesh: GlobalSurfApproximation{CurvedSurfaceApproxChoice=UseSlider SliderMeshSettings=9} GlobalCurvilinear{Apply}
setups:
  Setup1: EddyCurrent MaximumPasses=20 MinimumPasses=4 MinimumConvergedPasses=1 PercentRefinement=30 PercentError=1 NonLinearResidual=0.0001 SmoothBHCurve Frequency=28.5kHz SweepRanges{point 28500Hz} SaveAllFields
field plots:
  Mesh1: MeshPlots in Region on Setup1 : LastAdaptive at Freq=28500Hz Phase=0deg
  Mag_B1: B over a plane on Setup1 : LastAdaptive at Freq=28500Hz Phase=45deg
reports:
  L Table 1: Matrix1.L(Np,Np), Matrix1.L(Ns,Np), Matrix1.L(Np,Ns), Matrix1.L(Ns,Ns), Matrix1.R(Np,Np), Matrix1.R(Ns,Np), Matrix1.R(Np,Ns), Matrix1.R(Ns,Ns) vs Freq on Setup1 : LastAdaptive

design Flatwise_100kW_.25 (Maxwell 3D, EddyCurrent, model units mm)
variables:
  freq_hz = 28500Hz
  volt_ac = 1410/28500*Freq
geometry:
  Region [vacuum] = region(percentage_offset=0 on all sides)
  Body1_1 [aluminum_real] = imported_body(D:\Karl_HighPower\flatwise_100kW.step)
  Body1_2 [ferrite - real2] = imported_body(D:\Karl_HighPower\flatwise_100kW.step)
  Body1_4 [aluminum_real] = imported_body(D:\Karl_HighPower\flatwise_100kW.step)
  Body1_5 [ferrite - real2] = imported_body(D:\Karl_HighPower\flatwise_100kW.step)
  plate_1, plate_2 [silicon_TIMreal] = imported_body(D:\Karl_HighPower\flatwise_100kW.step)
  Ns1, Ns7, Ns4, Ns8, Ns2, Ns6, Ns5, Ns3, Np1, Np7, Np4, Np8, Np2, Np6, Np5, Np3 [coppe_real] = imported_body(D:\Karl_HighPower\flatwise_100kW.step)
  [Body1_1, Body1_2, Body1_4, Body1_5, plate_1, plate_2, Ns1, Ns7, Ns4, Ns8, Ns2, Ns6, Ns5, Ns3, Np1, Np7, Np4, Np8, Np2, Np6, Np5, Np3].move(-63.8mm, -100.345mm, 0mm)
  [Body1_1, Body1_2, Body1_4, Body1_5, plate_1, plate_2, Ns1, Ns7, Ns4, Ns8, Ns2, Ns6, Ns5, Ns3, Np1, Np7, Np4, Np8, Np2, Np6, Np5, Np3].move(0mm, 0mm, -45.1mm)
  [Body1_1, Body1_2, Body1_4, Body1_5, plate_1, plate_2, Ns1, Ns7, Ns4, Ns8, Ns2, Ns6, Ns5, Ns3, Np1, Np7, Np4, Np8, Np2, Np6, Np5, Np3].split(plane=ZX, keep=PositiveOnly)
  [Body1_1, Body1_2, Body1_4, Body1_5, plate_1, plate_2, Ns1, Ns7, Ns4, Ns8, Ns2, Ns6, Ns5, Ns3, Np1, Np7, Np4, Np8, Np2, Np6, Np5, Np3].split(plane=YZ, keep=PositiveOnly)
  group flatwise_100kW = Body1_1, Body1_2, Body1_4, Body1_5, plate_1, plate_2, Ns1, Ns7, Ns4, Ns8, Ns2, Ns6, Ns5, Ns3, Np1, Np7, Np4, Np8, Np2, Np6, Np5, Np3
boundaries and excitations:
  Symmetry1: Symmetry Faces=Region.face(-y) IsOdd=true
  Symmetry2: Symmetry Faces=Region.face(-x) IsOdd=true
  Ns_in_1: Coil Terminal Faces=Ns8.face(at (49.15, 0, -0.6)) Conductor_number=1 Winding=Ns Point_out_of_terminal=false
  Ns_in_2: Coil Terminal Faces=Ns7.face(at (44.55, 0, -0.6)) Conductor_number=1 Winding=Ns Point_out_of_terminal=false
  Ns_in_3: Coil Terminal Faces=Ns6.face(at (39.95, 0, -0.6)) Conductor_number=1 Winding=Ns Point_out_of_terminal=false
  Ns_in_4: Coil Terminal Faces=Ns5.face(at (35.35, 0, -0.6)) Conductor_number=1 Winding=Ns Point_out_of_terminal=false
  Ns_in_5: Coil Terminal Faces=Ns4.face(at (30.75, 0, -0.6)) Conductor_number=1 Winding=Ns Point_out_of_terminal=false
  Ns_in_6: Coil Terminal Faces=Ns3.face(at (26.15, 0, -0.6)) Conductor_number=1 Winding=Ns Point_out_of_terminal=false
  Ns_in_7: Coil Terminal Faces=Ns2.face(at (21.55, 0, -0.6)) Conductor_number=1 Winding=Ns Point_out_of_terminal=false
  Ns_in_8: Coil Terminal Faces=Ns1.face(at (16.95, 0, -0.6)) Conductor_number=1 Winding=Ns Point_out_of_terminal=false
  Np_in_1: Coil Terminal Faces=Np1.face(at (14.65, 0, -0.6)) Conductor_number=1 Winding=Np Point_out_of_terminal=true
  Np_in_2: Coil Terminal Faces=Np2.face(at (19.25, 0, -0.6)) Conductor_number=1 Winding=Np Point_out_of_terminal=true
  Np_in_3: Coil Terminal Faces=Np3.face(at (23.85, 0, -0.6)) Conductor_number=1 Winding=Np Point_out_of_terminal=true
  Np_in_4: Coil Terminal Faces=Np4.face(at (28.45, 0, -0.6)) Conductor_number=1 Winding=Np Point_out_of_terminal=true
  Np_in_5: Coil Terminal Faces=Np5.face(at (33.05, 0, -0.6)) Conductor_number=1 Winding=Np Point_out_of_terminal=true
  Np_in_6: Coil Terminal Faces=Np6.face(at (37.65, 0, -0.6)) Conductor_number=1 Winding=Np Point_out_of_terminal=true
  Np_in_7: Coil Terminal Faces=Np7.face(at (42.25, 0, -0.6)) Conductor_number=1 Winding=Np Point_out_of_terminal=true
  Np_in_8: Coil Terminal Faces=Np8.face(at (46.85, 0, -0.6)) Conductor_number=1 Winding=Np Point_out_of_terminal=true
  Ns_out_1: Coil Terminal Faces=Ns8.face(at (0, 136.995, -0.6)) Conductor_number=1 Winding=Ns Point_out_of_terminal=true
  Ns_out_2: Coil Terminal Faces=Ns7.face(at (0, 132.395, -0.6)) Conductor_number=1 Winding=Ns Point_out_of_terminal=true
  Ns_out_3: Coil Terminal Faces=Ns6.face(at (0, 127.795, -0.6)) Conductor_number=1 Winding=Ns Point_out_of_terminal=true
  Ns_out_4: Coil Terminal Faces=Ns5.face(at (0, 123.195, -0.6)) Conductor_number=1 Winding=Ns Point_out_of_terminal=true
  Ns_out_5: Coil Terminal Faces=Ns4.face(at (0, 118.595, -0.6)) Conductor_number=1 Winding=Ns Point_out_of_terminal=true
  Ns_out_6: Coil Terminal Faces=Ns3.face(at (0, 113.995, -0.6)) Conductor_number=1 Winding=Ns Point_out_of_terminal=true
  Ns_out_7: Coil Terminal Faces=Ns2.face(at (0, 109.395, -0.6)) Conductor_number=1 Winding=Ns Point_out_of_terminal=true
  Ns_out_8: Coil Terminal Faces=Ns1.face(at (0, 104.795, -0.6)) Conductor_number=1 Winding=Ns Point_out_of_terminal=true
  Np_out_1: Coil Terminal Faces=Np8.face(at (0, 134.695, -0.6)) Conductor_number=1 Winding=Np Point_out_of_terminal=false
  Np_out_2: Coil Terminal Faces=Np7.face(at (0, 130.095, -0.6)) Conductor_number=1 Winding=Np Point_out_of_terminal=false
  Np_out_3: Coil Terminal Faces=Np6.face(at (0, 125.495, -0.6)) Conductor_number=1 Winding=Np Point_out_of_terminal=false
  Np_out_4: Coil Terminal Faces=Np5.face(at (0, 120.895, -0.6)) Conductor_number=1 Winding=Np Point_out_of_terminal=false
  Np_out_5: Coil Terminal Faces=Np4.face(at (0, 116.295, -0.6)) Conductor_number=1 Winding=Np Point_out_of_terminal=false
  Np_out_6: Coil Terminal Faces=Np3.face(at (0, 111.695, -0.6)) Conductor_number=1 Winding=Np Point_out_of_terminal=false
  Np_out_7: Coil Terminal Faces=Np2.face(at (0, 107.095, -0.6)) Conductor_number=1 Winding=Np Point_out_of_terminal=false
  Np_out_8: Coil Terminal Faces=Np1.face(at (0, 102.495, -0.6)) Conductor_number=1 Winding=Np Point_out_of_terminal=false
  Np: Winding Group Type=Voltage IsSolid=true Current=16.36A Resistance=0ohm Inductance=0nH Voltage=volt_ac ParallelBranchesNum=1 Phase=0rad
  Ns: Winding Group Type=Current IsSolid=true Current=1000*1.41/volt_ac*1.414 ParallelBranchesNum=1 Phase=0.1522rad
  eddy effects on: Body1_1, Body1_4, Ns1, Ns7, Ns4, Ns8, Ns2, Ns6, Ns5, Ns3, Np1, Np7, Np4, Np8, Np2, Np6, Np5, Np3
  core loss on: Body1_2, Body1_5
parameters:
  Matrix1: Matrix Np, Ns:
mesh:
  SkinDepth1: SkinDepthBased disabled Objects=[Np1..Np8, Ns1..Ns8] SkinDepth=0.20567444mm SurfTriMaxLength=1mm NumLayers=2
  Length1: LengthBased Objects=[Body1_1, Body1_4, Body1_2, Body1_5, plate_1, plate_2] MaxLength=10mm
  Wire: LengthBased Objects=[Np1..Np8, Ns1..Ns8] MaxLength=1mm
  initial mesh: GlobalSurfApproximation{CurvedSurfaceApproxChoice=UseSlider SliderMeshSettings=9} GlobalCurvilinear{Apply}
setups:
  Setup1: EddyCurrent MaximumPasses=20 MinimumPasses=4 MinimumConvergedPasses=1 PercentRefinement=30 PercentError=1 NonLinearResidual=0.0001 SmoothBHCurve Frequency=100kHz SweepRanges{point 28500Hz} SaveAllFields
field plots:
  Mesh1: MeshPlots in Body1_1, Body1_2, Body1_4, Body1_5, plate_1, plate_2, Ns1, Ns7, Ns4, Ns8, Ns2, Ns6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 on Setup1 : LastAdaptive at Freq=28500Hz Phase=0deg
reports:
  L Table 1: Matrix1.L(Np,Np), Matrix1.L(Ns,Np), Matrix1.L(Np,Ns), Matrix1.L(Ns,Ns), Matrix1.R(Np,Np), Matrix1.R(Ns,Np), Matrix1.R(Np,Ns), Matrix1.R(Ns,Ns) vs Freq on Setup1 : LastAdaptive

design Flatwise_100kW_.125 (Maxwell 3D, EddyCurrent, model units mm)
variables:
  freq_hz = 28500Hz
  volt_ac = 1410/28500*Freq
geometry:
  Region [vacuum] = region(percentage_offset=0 on all sides)
  Body1_4 [aluminum_real] = imported_body(D:\Karl_HighPower\flatwise_100kW.step)
  Body1_5 [ferrite - real2] = imported_body(D:\Karl_HighPower\flatwise_100kW.step)
  plate_2 [silicon_TIMreal] = imported_body(D:\Karl_HighPower\flatwise_100kW.step)
  Ns1, Ns7, Ns4, Ns8, Ns2, Ns6, Ns5, Ns3, Np1, Np7, Np4, Np8, Np2, Np6, Np5, Np3 [coppe_real] = imported_body(D:\Karl_HighPower\flatwise_100kW.step)
  [Body1_4, Body1_5, plate_2, Ns1, Ns7, Ns4, Ns8, Ns2, Ns6, Ns5, Ns3, Np1, Np7, Np4, Np8, Np2, Np6, Np5, Np3].move(-63.8mm, -100.345mm, 0mm)
  [Body1_4, Body1_5, plate_2, Ns1, Ns7, Ns4, Ns8, Ns2, Ns6, Ns5, Ns3, Np1, Np7, Np4, Np8, Np2, Np6, Np5, Np3].move(0mm, 0mm, -45.1mm)
  [Body1_4, Body1_5, plate_2, Ns1, Ns7, Ns4, Ns8, Ns2, Ns6, Ns5, Ns3, Np1, Np7, Np4, Np8, Np2, Np6, Np5, Np3].split(plane=ZX, keep=PositiveOnly)
  [Body1_4, Body1_5, plate_2, Ns1, Ns7, Ns4, Ns8, Ns2, Ns6, Ns5, Ns3, Np1, Np7, Np4, Np8, Np2, Np6, Np5, Np3].split(plane=YZ, keep=PositiveOnly)
  [Body1_4, Body1_5, plate_2, Ns1, Ns7, Ns4, Ns8, Ns2, Ns6, Ns5, Ns3, Np1, Np7, Np4, Np8, Np2, Np6, Np5, Np3].move(0mm, 0mm, 0.6mm)
  [Body1_4, Body1_5, plate_2, Ns1, Ns7, Ns4, Ns8, Ns2, Ns6, Ns5, Ns3, Np1, Np7, Np4, Np8, Np2, Np6, Np5, Np3].split(plane=XY, keep=PositiveOnly)
  Rectangle1 [non-model] = rectangle(corner=(0mm, 69.5725mm, 0mm), z_size=44.5mm, x_size=63.8mm)
  group flatwise_100kW = Body1_4, Body1_5, plate_2, Ns1, Ns7, Ns4, Ns8, Ns2, Ns6, Ns5, Ns3, Np1, Np7, Np4, Np8, Np2, Np6, Np5, Np3
boundaries and excitations:
  Symmetry1: Symmetry Faces=Region.face(-y) IsOdd=true
  Symmetry2: Symmetry Faces=Region.face(-x) IsOdd=true
  Symmetry3: Symmetry Faces=Region.face(-z) IsOdd=true
  Ns_in_1: Coil Terminal Faces=Ns8.face(at (49.15, 0, 15)) Conductor_number=1 Winding=Ns Point_out_of_terminal=false
  Ns_in_2: Coil Terminal Faces=Ns7.face(at (44.55, 0, 15)) Conductor_number=1 Winding=Ns Point_out_of_terminal=false
  Ns_in_3: Coil Terminal Faces=Ns6.face(at (39.95, 0, 15)) Conductor_number=1 Winding=Ns Point_out_of_terminal=false
  Ns_in_4: Coil Terminal Faces=Ns5.face(at (35.35, 0, 15)) Conductor_number=1 Winding=Ns Point_out_of_terminal=false
  Ns_in_5: Coil Terminal Faces=Ns4.face(at (30.75, 0, 15)) Conductor_number=1 Winding=Ns Point_out_of_terminal=false
  Ns_in_6: Coil Terminal Faces=Ns3.face(at (26.15, 0, 15)) Conductor_number=1 Winding=Ns Point_out_of_terminal=false
  Ns_in_7: Coil Terminal Faces=Ns2.face(at (21.55, 0, 15)) Conductor_number=1 Winding=Ns Point_out_of_terminal=false
  Ns_in_8: Coil Terminal Faces=Ns1.face(at (16.95, 0, 15)) Conductor_number=1 Winding=Ns Point_out_of_terminal=false
  Np_in_1: Coil Terminal Faces=Np1.face(at (14.65, 0, 15)) Conductor_number=1 Winding=Np Point_out_of_terminal=true
  Np_in_2: Coil Terminal Faces=Np2.face(at (19.25, 0, 15)) Conductor_number=1 Winding=Np Point_out_of_terminal=true
  Np_in_3: Coil Terminal Faces=Np3.face(at (23.85, 0, 15)) Conductor_number=1 Winding=Np Point_out_of_terminal=true
  Np_in_4: Coil Terminal Faces=Np4.face(at (28.45, 0, 15)) Conductor_number=1 Winding=Np Point_out_of_terminal=true
  Np_in_5: Coil Terminal Faces=Np5.face(at (33.05, 0, 15)) Conductor_number=1 Winding=Np Point_out_of_terminal=true
  Np_in_6: Coil Terminal Faces=Np6.face(at (37.65, 0, 15)) Conductor_number=1 Winding=Np Point_out_of_terminal=true
  Np_in_7: Coil Terminal Faces=Np7.face(at (42.25, 0, 15)) Conductor_number=1 Winding=Np Point_out_of_terminal=true
  Np_in_8: Coil Terminal Faces=Np8.face(at (46.85, 0, 15)) Conductor_number=1 Winding=Np Point_out_of_terminal=true
  Ns_out_1: Coil Terminal Faces=Ns8.face(at (0, 136.995, 15)) Conductor_number=1 Winding=Ns Point_out_of_terminal=true
  Ns_out_2: Coil Terminal Faces=Ns7.face(at (0, 132.395, 15)) Conductor_number=1 Winding=Ns Point_out_of_terminal=true
  Ns_out_3: Coil Terminal Faces=Ns6.face(at (0, 127.795, 15)) Conductor_number=1 Winding=Ns Point_out_of_terminal=true
  Ns_out_4: Coil Terminal Faces=Ns5.face(at (0, 123.195, 15)) Conductor_number=1 Winding=Ns Point_out_of_terminal=true
  Ns_out_5: Coil Terminal Faces=Ns4.face(at (0, 118.595, 15)) Conductor_number=1 Winding=Ns Point_out_of_terminal=true
  Ns_out_6: Coil Terminal Faces=Ns3.face(at (0, 113.995, 15)) Conductor_number=1 Winding=Ns Point_out_of_terminal=true
  Ns_out_7: Coil Terminal Faces=Ns2.face(at (0, 109.395, 15)) Conductor_number=1 Winding=Ns Point_out_of_terminal=true
  Ns_out_8: Coil Terminal Faces=Ns1.face(at (0, 104.795, 15)) Conductor_number=1 Winding=Ns Point_out_of_terminal=true
  Np_out_1: Coil Terminal Faces=Np8.face(at (0, 134.695, 15)) Conductor_number=1 Winding=Np Point_out_of_terminal=false
  Np_out_2: Coil Terminal Faces=Np7.face(at (0, 130.095, 15)) Conductor_number=1 Winding=Np Point_out_of_terminal=false
  Np_out_3: Coil Terminal Faces=Np6.face(at (0, 125.495, 15)) Conductor_number=1 Winding=Np Point_out_of_terminal=false
  Np_out_4: Coil Terminal Faces=Np5.face(at (0, 120.895, 15)) Conductor_number=1 Winding=Np Point_out_of_terminal=false
  Np_out_5: Coil Terminal Faces=Np4.face(at (0, 116.295, 15)) Conductor_number=1 Winding=Np Point_out_of_terminal=false
  Np_out_6: Coil Terminal Faces=Np3.face(at (0, 111.695, 15)) Conductor_number=1 Winding=Np Point_out_of_terminal=false
  Np_out_7: Coil Terminal Faces=Np2.face(at (0, 107.095, 15)) Conductor_number=1 Winding=Np Point_out_of_terminal=false
  Np_out_8: Coil Terminal Faces=Np1.face(at (0, 102.495, 15)) Conductor_number=1 Winding=Np Point_out_of_terminal=false
  Np: Winding Group Type=Voltage IsSolid=true Current=16.36A Resistance=0ohm Inductance=0nH Voltage=volt_ac ParallelBranchesNum=1 Phase=0rad
  Ns: Winding Group Type=Current IsSolid=true Current=100000*1.41/volt_ac*1.414 ParallelBranchesNum=1 Phase=0.1522rad
  eddy effects on: Body1_4, Ns1, Ns7, Ns4, Ns8, Ns2, Ns6, Ns5, Ns3, Np1, Np7, Np4, Np8, Np2, Np6, Np5, Np3
  core loss on: Body1_5
parameters:
  Matrix1: Matrix Np, Ns:
mesh:
  Length1: LengthBased Objects=[Body1_4, Body1_5, plate_2] MaxLength=5mm
  Wire: LengthBased Objects=[Np1..Np8, Ns1..Ns8] MaxLength=2mm
  initial mesh: GlobalSurfApproximation{CurvedSurfaceApproxChoice=UseSlider SliderMeshSettings=9} GlobalCurvilinear{Apply}
setups:
  Setup1: EddyCurrent MaximumPasses=20 MinimumPasses=4 MinimumConvergedPasses=1 PercentRefinement=30 PercentError=1 NonLinearResidual=0.0001 SmoothBHCurve Frequency=28.5kHz SweepRanges{point 28500Hz} SaveAllFields
field plots:
  Mesh1: MeshPlots over Region.face(all 6) Body1_4.face(all 8) Body1_5.face(all 10) plate_2.face(all 8) Ns1.face(all 8) Ns7.face(all 8) Ns4.face(all 8) Ns8.face(all 8) Ns2.face(all 8) Ns6.face(all 8) Ns5.face(all 8) Ns3.face(all 8) Np1.face(all 8) Np7.face(all 8) Np4.face(all 8) Np8.face(all 8) Np2.face(all 8) Np6.face(all 8) Np5.face(all 8) Np3.face(all 8) on Setup1 : LastAdaptive at Freq=28500Hz Phase=0deg
  Mag_B1: B over a plane on Setup1 : LastAdaptive at Freq=28500Hz Phase=45deg
  Mag_B2: B over Body1_5.face(at (31.9, 0, 22.55)) on Setup1 : LastAdaptive at Freq=28.5kHz Phase=45deg
reports:
  L Table 1: Matrix1.L(Np,Np), Matrix1.L(Ns,Np), Matrix1.L(Np,Ns), Matrix1.L(Ns,Ns), Matrix1.R(Np,Np), Matrix1.R(Ns,Np), Matrix1.R(Np,Ns), Matrix1.R(Ns,Ns) vs Freq on Setup1 : LastAdaptive

design Flatwise_100kW_.126 (Maxwell 3D, EddyCurrent, model units mm)
variables:
  freq_hz = 28500Hz
  volt_ac = 1410/28500*Freq
geometry:
  Region [vacuum] = region(percentage_offset=0 on all sides)
  Body1_4 [aluminum_real] = imported_body(D:\Karl_HighPower\flatwise_100kW.step)
  Body1_5 [ferrite - real2] = imported_body(D:\Karl_HighPower\flatwise_100kW.step)
  plate_2 [silicon_TIMreal] = imported_body(D:\Karl_HighPower\flatwise_100kW.step)
  Ns1, Ns7, Ns4, Ns8, Ns2, Ns6, Ns5, Ns3, Np1, Np7, Np4, Np8, Np2, Np6, Np5, Np3 [coppe_real] = imported_body(D:\Karl_HighPower\flatwise_100kW.step)
  [Body1_4, Body1_5, plate_2, Ns1, Ns7, Ns4, Ns8, Ns2, Ns6, Ns5, Ns3, Np1, Np7, Np4, Np8, Np2, Np6, Np5, Np3].move(-63.8mm, -100.345mm, 0mm)
  [Body1_4, Body1_5, plate_2, Ns1, Ns7, Ns4, Ns8, Ns2, Ns6, Ns5, Ns3, Np1, Np7, Np4, Np8, Np2, Np6, Np5, Np3].move(0mm, 0mm, -45.1mm)
  [Body1_4, Body1_5, plate_2, Ns1, Ns7, Ns4, Ns8, Ns2, Ns6, Ns5, Ns3, Np1, Np7, Np4, Np8, Np2, Np6, Np5, Np3].split(plane=ZX, keep=PositiveOnly)
  [Body1_4, Body1_5, plate_2, Ns1, Ns7, Ns4, Ns8, Ns2, Ns6, Ns5, Ns3, Np1, Np7, Np4, Np8, Np2, Np6, Np5, Np3].split(plane=YZ, keep=PositiveOnly)
  [Body1_4, Body1_5, plate_2, Ns1, Ns7, Ns4, Ns8, Ns2, Ns6, Ns5, Ns3, Np1, Np7, Np4, Np8, Np2, Np6, Np5, Np3].move(0mm, 0mm, 0.6mm)
  [Body1_4, Body1_5, plate_2, Ns1, Ns7, Ns4, Ns8, Ns2, Ns6, Ns5, Ns3, Np1, Np7, Np4, Np8, Np2, Np6, Np5, Np3].split(plane=XY, keep=PositiveOnly)
  Rectangle1 [non-model] = rectangle(corner=(0mm, 69.5725mm, 0mm), z_size=44.5mm, x_size=63.8mm)
  group flatwise_100kW = Body1_4, Body1_5, plate_2, Ns1, Ns7, Ns4, Ns8, Ns2, Ns6, Ns5, Ns3, Np1, Np7, Np4, Np8, Np2, Np6, Np5, Np3
boundaries and excitations:
  Symmetry1: Symmetry Faces=Region.face(-y) IsOdd=true
  Symmetry2: Symmetry Faces=Region.face(-x) IsOdd=true
  Symmetry3: Symmetry Faces=Region.face(-z) IsOdd=true
  Ns_in_1: Coil Terminal Faces=Ns8.face(at (49.15, 0, 15)) Conductor_number=1 Winding=Ns Point_out_of_terminal=false
  Ns_in_2: Coil Terminal Faces=Ns7.face(at (44.55, 0, 15)) Conductor_number=1 Winding=Ns Point_out_of_terminal=false
  Ns_in_3: Coil Terminal Faces=Ns6.face(at (39.95, 0, 15)) Conductor_number=1 Winding=Ns Point_out_of_terminal=false
  Ns_in_4: Coil Terminal Faces=Ns5.face(at (35.35, 0, 15)) Conductor_number=1 Winding=Ns Point_out_of_terminal=false
  Ns_in_5: Coil Terminal Faces=Ns4.face(at (30.75, 0, 15)) Conductor_number=1 Winding=Ns Point_out_of_terminal=false
  Ns_in_6: Coil Terminal Faces=Ns3.face(at (26.15, 0, 15)) Conductor_number=1 Winding=Ns Point_out_of_terminal=false
  Ns_in_7: Coil Terminal Faces=Ns2.face(at (21.55, 0, 15)) Conductor_number=1 Winding=Ns Point_out_of_terminal=false
  Ns_in_8: Coil Terminal Faces=Ns1.face(at (16.95, 0, 15)) Conductor_number=1 Winding=Ns Point_out_of_terminal=false
  Np_in_1: Coil Terminal Faces=Np1.face(at (14.65, 0, 15)) Conductor_number=1 Winding=Np Point_out_of_terminal=true
  Np_in_2: Coil Terminal Faces=Np2.face(at (19.25, 0, 15)) Conductor_number=1 Winding=Np Point_out_of_terminal=true
  Np_in_3: Coil Terminal Faces=Np3.face(at (23.85, 0, 15)) Conductor_number=1 Winding=Np Point_out_of_terminal=true
  Np_in_4: Coil Terminal Faces=Np4.face(at (28.45, 0, 15)) Conductor_number=1 Winding=Np Point_out_of_terminal=true
  Np_in_5: Coil Terminal Faces=Np5.face(at (33.05, 0, 15)) Conductor_number=1 Winding=Np Point_out_of_terminal=true
  Np_in_6: Coil Terminal Faces=Np6.face(at (37.65, 0, 15)) Conductor_number=1 Winding=Np Point_out_of_terminal=true
  Np_in_7: Coil Terminal Faces=Np7.face(at (42.25, 0, 15)) Conductor_number=1 Winding=Np Point_out_of_terminal=true
  Np_in_8: Coil Terminal Faces=Np8.face(at (46.85, 0, 15)) Conductor_number=1 Winding=Np Point_out_of_terminal=true
  Ns_out_1: Coil Terminal Faces=Ns8.face(at (0, 136.995, 15)) Conductor_number=1 Winding=Ns Point_out_of_terminal=true
  Ns_out_2: Coil Terminal Faces=Ns7.face(at (0, 132.395, 15)) Conductor_number=1 Winding=Ns Point_out_of_terminal=true
  Ns_out_3: Coil Terminal Faces=Ns6.face(at (0, 127.795, 15)) Conductor_number=1 Winding=Ns Point_out_of_terminal=true
  Ns_out_4: Coil Terminal Faces=Ns5.face(at (0, 123.195, 15)) Conductor_number=1 Winding=Ns Point_out_of_terminal=true
  Ns_out_5: Coil Terminal Faces=Ns4.face(at (0, 118.595, 15)) Conductor_number=1 Winding=Ns Point_out_of_terminal=true
  Ns_out_6: Coil Terminal Faces=Ns3.face(at (0, 113.995, 15)) Conductor_number=1 Winding=Ns Point_out_of_terminal=true
  Ns_out_7: Coil Terminal Faces=Ns2.face(at (0, 109.395, 15)) Conductor_number=1 Winding=Ns Point_out_of_terminal=true
  Ns_out_8: Coil Terminal Faces=Ns1.face(at (0, 104.795, 15)) Conductor_number=1 Winding=Ns Point_out_of_terminal=true
  Np_out_1: Coil Terminal Faces=Np8.face(at (0, 134.695, 15)) Conductor_number=1 Winding=Np Point_out_of_terminal=false
  Np_out_2: Coil Terminal Faces=Np7.face(at (0, 130.095, 15)) Conductor_number=1 Winding=Np Point_out_of_terminal=false
  Np_out_3: Coil Terminal Faces=Np6.face(at (0, 125.495, 15)) Conductor_number=1 Winding=Np Point_out_of_terminal=false
  Np_out_4: Coil Terminal Faces=Np5.face(at (0, 120.895, 15)) Conductor_number=1 Winding=Np Point_out_of_terminal=false
  Np_out_5: Coil Terminal Faces=Np4.face(at (0, 116.295, 15)) Conductor_number=1 Winding=Np Point_out_of_terminal=false
  Np_out_6: Coil Terminal Faces=Np3.face(at (0, 111.695, 15)) Conductor_number=1 Winding=Np Point_out_of_terminal=false
  Np_out_7: Coil Terminal Faces=Np2.face(at (0, 107.095, 15)) Conductor_number=1 Winding=Np Point_out_of_terminal=false
  Np_out_8: Coil Terminal Faces=Np1.face(at (0, 102.495, 15)) Conductor_number=1 Winding=Np Point_out_of_terminal=false
  Np: Winding Group Type=Voltage IsSolid=true Current=16.36A Resistance=0ohm Inductance=0nH Voltage=volt_ac ParallelBranchesNum=1 Phase=0rad
  Ns: Winding Group Type=Current IsSolid=true Current=100000*1.41/volt_ac*1.414 ParallelBranchesNum=1 Phase=0.1522rad
  eddy effects on: Body1_4, Ns1, Ns7, Ns4, Ns8, Ns2, Ns6, Ns5, Ns3, Np1, Np7, Np4, Np8, Np2, Np6, Np5, Np3
  core loss on: Body1_5
parameters:
  Matrix1: Matrix Np, Ns:
mesh:
  Length1: LengthBased Objects=[Body1_4, Body1_5, plate_2] MaxLength=5mm
  Wire: LengthBased Objects=[Np1..Np8, Ns1..Ns8] MaxLength=2mm
  initial mesh: GlobalSurfApproximation{CurvedSurfaceApproxChoice=UseSlider SliderMeshSettings=9} GlobalCurvilinear{Apply}
setups:
  Setup1: EddyCurrent MaximumPasses=20 MinimumPasses=4 MinimumConvergedPasses=1 PercentRefinement=30 PercentError=1 NonLinearResidual=0.0001 SmoothBHCurve Frequency=28.5kHz SweepRanges{point 28500Hz} SaveAllFields
field plots:
  Mesh1: MeshPlots over Region.face(all 6) Body1_4.face(all 8) Body1_5.face(all 10) plate_2.face(all 8) Ns1.face(all 8) Ns7.face(all 8) Ns4.face(all 8) Ns8.face(all 8) Ns2.face(all 8) Ns6.face(all 8) Ns5.face(all 8) Ns3.face(all 8) Np1.face(all 8) Np7.face(all 8) Np4.face(all 8) Np8.face(all 8) Np2.face(all 8) Np6.face(all 8) Np5.face(all 8) Np3.face(all 8) on Setup1 : LastAdaptive at Freq=28500Hz Phase=0deg
  Mag_B1: B over a plane on Setup1 : LastAdaptive at Freq=28500Hz Phase=45deg
  Mag_B2: B over Body1_5.face(at (31.9, 0, 22.55)) on Setup1 : LastAdaptive at Freq=28.5kHz Phase=45deg
reports:
  L Table 1: Matrix1.L(Np,Np), Matrix1.L(Ns,Np), Matrix1.L(Np,Ns), Matrix1.L(Ns,Ns), Matrix1.R(Np,Np), Matrix1.R(Ns,Np), Matrix1.R(Np,Ns), Matrix1.R(Ns,Ns) vs Freq on Setup1 : LastAdaptive

design Edgewise_100kW_Detail (Maxwell 3D, EddyCurrent, model units mm)
variables:
  freq_hz = 28500Hz
  volt_ac = 1410/28500*Freq
geometry:
  Region [vacuum] = region(percentage_offset=0 on all sides)
  Body1 [ferrite - real2] = imported_body(D:\Karl_HighPower\core_assembled_edgewise_100kW.step)
  Body1_1, Body1_2 [aluminum_real] = imported_body(D:\Karl_HighPower\core_assembled_edgewise_100kW.step)
  Body1_3 [ferrite - real2] = imported_body(D:\Karl_HighPower\core_assembled_edgewise_100kW.step)
  Body1_4, Body1_5 [aluminum_real] = imported_body(D:\Karl_HighPower\core_assembled_edgewise_100kW.step)
  plate1, plate2 [silicon_TIMreal] = imported_body(D:\Karl_HighPower\core_assembled_edgewise_100kW.step)
  Ns8, Ns4, Ns1, Ns5, Ns7, Ns3, Ns2, Ns6, Np8, Np4, Np1, Np5, Np7, Np3, Np2, Np6 [coppe_real] = imported_body(D:\Karl_HighPower\core_assembled_edgewise_100kW.step)
  Np1_Section1 [coppe_real] = Np1.section(plane=ZX)
  Np2_Section1 [coppe_real] = Np2.section(plane=ZX)
  Np3_Section1 [coppe_real] = Np3.section(plane=ZX)
  Np4_Section1 [coppe_real] = Np4.section(plane=ZX)
  Np5_Section1 [coppe_real] = Np5.section(plane=ZX)
  Np6_Section1 [coppe_real] = Np6.section(plane=ZX)
  Np7_Section1 [coppe_real] = Np7.section(plane=ZX)
  Np8_Section1 [coppe_real] = Np8.section(plane=ZX)
  Ns1_Section1 [coppe_real] = Ns1.section(plane=ZX)
  Ns2_Section1 [coppe_real] = Ns2.section(plane=ZX)
  Ns3_Section1 [coppe_real] = Ns3.section(plane=ZX)
  Ns4_Section1 [coppe_real] = Ns4.section(plane=ZX)
  Ns5_Section1 [coppe_real] = Ns5.section(plane=ZX)
  Ns6_Section1 [coppe_real] = Ns6.section(plane=ZX)
  Ns7_Section1 [coppe_real] = Ns7.section(plane=ZX)
  Ns8_Section1 [coppe_real] = Ns8.section(plane=ZX)
  Np1_Section1.separate_bodies()
  Np2_Section1.separate_bodies()
  Np3_Section1.separate_bodies()
  Np4_Section1.separate_bodies()
  Np5_Section1.separate_bodies()
  Np6_Section1.separate_bodies()
  Np7_Section1.separate_bodies()
  Np8_Section1.separate_bodies()
  Ns1_Section1.separate_bodies()
  Ns2_Section1.separate_bodies()
  Ns3_Section1.separate_bodies()
  Ns4_Section1.separate_bodies()
  Ns5_Section1.separate_bodies()
  Ns6_Section1.separate_bodies()
  Ns7_Section1.separate_bodies()
  Ns8_Section1.separate_bodies()
  Rectangle1 [non-model] = rectangle(corner=(178mm, 100.345mm, 0mm), z_size=63.8mm, x_size=-178mm)
  group core_assembled_edgewise_100kW = Body1, Body1_1..Body1_5, plate1, plate2, Ns8, Ns4, Ns1, Ns5, Ns7, Ns3, Ns2, Ns6, Np8, Np4, Np1, Np5, Np7, Np3, Np2, Np6, Np1_Section1, Np2_Section1, Np3_Section1, Np4_Section1, Np5_Section1, Np6_Section1, Np7_Section1, Np8_Section1, Ns1_Section1, Ns2_Section1, Ns3_Section1, Ns4_Section1, Ns5_Section1, Ns6_Section1, Ns7_Section1, Ns8_Section1
boundaries and excitations:
  Np_1: Coil Terminal Objects=Np1_Section1 Conductor_number=1 Winding=Np Point_out_of_terminal=false
  Np_2: Coil Terminal Objects=Np2_Section1 Conductor_number=1 Winding=Np Point_out_of_terminal=false
  Np_3: Coil Terminal Objects=Np3_Section1 Conductor_number=1 Winding=Np Point_out_of_terminal=false
  Np_4: Coil Terminal Objects=Np4_Section1 Conductor_number=1 Winding=Np Point_out_of_terminal=false
  Np_5: Coil Terminal Objects=Np5_Section1 Conductor_number=1 Winding=Np Point_out_of_terminal=false
  Np_6: Coil Terminal Objects=Np6_Section1 Conductor_number=1 Winding=Np Point_out_of_terminal=false
  Np_7: Coil Terminal Objects=Np7_Section1 Conductor_number=1 Winding=Np Point_out_of_terminal=false
  Np_8: Coil Terminal Objects=Np8_Section1 Conductor_number=1 Winding=Np Point_out_of_terminal=false
  Ns_1: Coil Terminal Objects=Ns1_Section1 Conductor_number=1 Winding=Ns Point_out_of_terminal=true
  Ns_2: Coil Terminal Objects=Ns2_Section1 Conductor_number=1 Winding=Ns Point_out_of_terminal=true
  Ns_3: Coil Terminal Objects=Ns3_Section1 Conductor_number=1 Winding=Ns Point_out_of_terminal=true
  Ns_4: Coil Terminal Objects=Ns4_Section1 Conductor_number=1 Winding=Ns Point_out_of_terminal=true
  Ns_5: Coil Terminal Objects=Ns5_Section1 Conductor_number=1 Winding=Ns Point_out_of_terminal=true
  Ns_6: Coil Terminal Objects=Ns6_Section1 Conductor_number=1 Winding=Ns Point_out_of_terminal=true
  Ns_7: Coil Terminal Objects=Ns7_Section1 Conductor_number=1 Winding=Ns Point_out_of_terminal=true
  Ns_8: Coil Terminal Objects=Ns8_Section1 Conductor_number=1 Winding=Ns Point_out_of_terminal=true
  Np: Winding Group Type=Voltage IsSolid=true Current=16.36A Resistance=0ohm Inductance=0nH Voltage=volt_ac ParallelBranchesNum=1 Phase=0rad
  Ns: Winding Group Type=Current IsSolid=true Current=100000*1.41/volt_ac*1.414 ParallelBranchesNum=1 Phase=0.1522rad
  eddy effects on: Body1_1, Body1_2, Body1_4, Body1_5, Ns8, Ns4, Ns1, Ns5, Ns7, Ns3, Ns2, Ns6, Np8, Np4, Np1, Np5, Np7, Np3, Np2, Np6
  core loss on: Body1, Body1_3
parameters:
  Matrix1: Matrix Np, Ns:
mesh:
  Length1: LengthBased Objects=[Body1, Body1_3, Body1_1, Body1_2, Body1_4, Body1_5, plate1, plate2] MaxLength=10mm
  Length2: LengthBased Objects=[Np1..Np8, Ns1..Ns8] MaxLength=3mm
  initial mesh: GlobalSurfApproximation{CurvedSurfaceApproxChoice=UseSlider SliderMeshSettings=9} GlobalCurvilinear{Apply}
setups:
  Setup1: EddyCurrent MaximumPasses=20 MinimumPasses=6 MinimumConvergedPasses=1 PercentRefinement=30 PercentError=1 NonLinearResidual=0.0001 SmoothBHCurve Frequency=28.5kHz SweepRanges{point 28500Hz} SaveAllFields
field plots:
  Mesh1: MeshPlots in Region on Setup1 : LastAdaptive at Freq=28500Hz Phase=0deg
  Mag_B1: B over a plane on Setup1 : LastAdaptive at Freq=28500Hz Phase=45deg
reports:
  L Table 1: Matrix1.L(Np,Np), Matrix1.L(Ns,Np), Matrix1.L(Np,Ns), Matrix1.L(Ns,Ns), Matrix1.R(Np,Np), Matrix1.R(Ns,Np), Matrix1.R(Np,Ns), Matrix1.R(Ns,Ns) vs Freq on Setup1 : LastAdaptive

design Flatwise_100kW_Detail (Maxwell 3D, EddyCurrent, model units mm)
variables:
  freq_hz = 28500Hz
  volt_ac = 1410/28500*Freq
geometry:
  Region [vacuum] = region(percentage_offset=0 on all sides)
  Rectangle1 [non-model] = rectangle(corner=(0mm, 25.45mm, 0mm), z_size=18.7mm, x_size=38.6mm)
  Body1, Body1_1 [aluminum_real] = imported_body(D:\Karl_HighPower\flatwise_100kW.step)
  Body1_2 [ferrite - real2] = imported_body(D:\Karl_HighPower\flatwise_100kW.step)
  Body1_3, Body1_4 [aluminum_real] = imported_body(D:\Karl_HighPower\flatwise_100kW.step)
  Body1_5 [ferrite - real2] = imported_body(D:\Karl_HighPower\flatwise_100kW.step)
  plate_1, plate_2 [silicon_TIMreal] = imported_body(D:\Karl_HighPower\flatwise_100kW.step)
  Ns1, Ns7, Ns4, Ns8, Ns2, Ns6, Ns5, Ns3, Np1, Np7, Np4, Np8, Np2, Np6, Np5, Np3 [coppe_real] = imported_body(D:\Karl_HighPower\flatwise_100kW.step)
  Np1_Section1 [coppe_real] = Np1.section(plane=ZX)
  Np2_Section1 [coppe_real] = Np2.section(plane=ZX)
  Np3_Section1 [coppe_real] = Np3.section(plane=ZX)
  Np4_Section1 [coppe_real] = Np4.section(plane=ZX)
  Np5_Section1 [coppe_real] = Np5.section(plane=ZX)
  Np6_Section1 [coppe_real] = Np6.section(plane=ZX)
  Np7_Section1 [coppe_real] = Np7.section(plane=ZX)
  Np8_Section1 [coppe_real] = Np8.section(plane=ZX)
  Ns1_Section1 [coppe_real] = Ns1.section(plane=ZX)
  Ns2_Section1 [coppe_real] = Ns2.section(plane=ZX)
  Ns3_Section1 [coppe_real] = Ns3.section(plane=ZX)
  Ns4_Section1 [coppe_real] = Ns4.section(plane=ZX)
  Ns5_Section1 [coppe_real] = Ns5.section(plane=ZX)
  Ns6_Section1 [coppe_real] = Ns6.section(plane=ZX)
  Ns7_Section1 [coppe_real] = Ns7.section(plane=ZX)
  Ns8_Section1 [coppe_real] = Ns8.section(plane=ZX)
  Np1_Section1.separate_bodies()
  Np2_Section1.separate_bodies()
  Np3_Section1.separate_bodies()
  Np4_Section1.separate_bodies()
  Np5_Section1.separate_bodies()
  Np6_Section1.separate_bodies()
  Np7_Section1.separate_bodies()
  Np8_Section1.separate_bodies()
  Ns1_Section1.separate_bodies()
  Ns2_Section1.separate_bodies()
  Ns3_Section1.separate_bodies()
  Ns4_Section1.separate_bodies()
  Ns5_Section1.separate_bodies()
  Ns6_Section1.separate_bodies()
  Ns7_Section1.separate_bodies()
  Ns8_Section1.separate_bodies()
  Rectangle2 [non-model] = rectangle(corner=(0mm, 100.345mm, 0mm), z_size=89mm, x_size=127.6mm)
  group flatwise_100kW = Body1, Body1_1..Body1_5, plate_1, plate_2, Ns1, Ns7, Ns4, Ns8, Ns2, Ns6, Ns5, Ns3, Np1, Np7, Np4, Np8, Np2, Np6, Np5, Np3, Np1_Section1, Np2_Section1, Np3_Section1, Np4_Section1, Np5_Section1, Np6_Section1, Np7_Section1, Np8_Section1, Ns1_Section1, Ns2_Section1, Ns3_Section1, Ns4_Section1, Ns5_Section1, Ns6_Section1, Ns7_Section1, Ns8_Section1
boundaries and excitations:
  Np_1: Coil Terminal Objects=Np1_Section1 Conductor_number=1 Winding=Np Point_out_of_terminal=false
  Np_2: Coil Terminal Objects=Np2_Section1 Conductor_number=1 Winding=Np Point_out_of_terminal=false
  Np_3: Coil Terminal Objects=Np3_Section1 Conductor_number=1 Winding=Np Point_out_of_terminal=false
  Np_4: Coil Terminal Objects=Np4_Section1 Conductor_number=1 Winding=Np Point_out_of_terminal=false
  Np_5: Coil Terminal Objects=Np5_Section1 Conductor_number=1 Winding=Np Point_out_of_terminal=false
  Np_6: Coil Terminal Objects=Np6_Section1 Conductor_number=1 Winding=Np Point_out_of_terminal=false
  Np_7: Coil Terminal Objects=Np7_Section1 Conductor_number=1 Winding=Np Point_out_of_terminal=false
  Np_8: Coil Terminal Objects=Np8_Section1 Conductor_number=1 Winding=Np Point_out_of_terminal=false
  Ns_1: Coil Terminal Objects=Ns1_Section1 Conductor_number=1 Winding=Ns Point_out_of_terminal=true
  Ns_2: Coil Terminal Objects=Ns2_Section1 Conductor_number=1 Winding=Ns Point_out_of_terminal=true
  Ns_3: Coil Terminal Objects=Ns3_Section1 Conductor_number=1 Winding=Ns Point_out_of_terminal=true
  Ns_4: Coil Terminal Objects=Ns4_Section1 Conductor_number=1 Winding=Ns Point_out_of_terminal=true
  Ns_5: Coil Terminal Objects=Ns5_Section1 Conductor_number=1 Winding=Ns Point_out_of_terminal=true
  Ns_6: Coil Terminal Objects=Ns6_Section1 Conductor_number=1 Winding=Ns Point_out_of_terminal=true
  Ns_7: Coil Terminal Objects=Ns7_Section1 Conductor_number=1 Winding=Ns Point_out_of_terminal=true
  Ns_8: Coil Terminal Objects=Ns8_Section1 Conductor_number=1 Winding=Ns Point_out_of_terminal=true
  Np: Winding Group Type=Voltage IsSolid=true Current=16.36A Resistance=0ohm Inductance=0nH Voltage=volt_ac ParallelBranchesNum=1 Phase=0rad
  Ns: Winding Group Type=Current IsSolid=true Current=100000*1.41/volt_ac*1.414 ParallelBranchesNum=1 Phase=0.1522rad
  eddy effects on: Body1, Body1_1, Body1_3, Body1_4, Ns1, Ns7, Ns4, Ns8, Ns2, Ns6, Ns5, Ns3, Np1, Np7, Np4, Np8, Np2, Np6, Np5, Np3
  core loss on: Body1_2, Body1_5
parameters:
  Matrix1: Matrix Np, Ns:
mesh:
  SkinDepth1: SkinDepthBased disabled Objects=[Np1..Np8, Ns1..Ns8] SkinDepth=0.20567444mm SurfTriMaxLength=1mm NumLayers=2
  Length1: LengthBased Objects=[Body1, Body1_1, Body1_3, Body1_4, Body1_2, Body1_5, plate_1, plate_2] MaxLength=10mm
  Wire: LengthBased Objects=[Np1..Np8, Ns1..Ns8] MaxLength=2.5mm
  initial mesh: GlobalSurfApproximation{CurvedSurfaceApproxChoice=UseSlider SliderMeshSettings=9} GlobalCurvilinear{Apply}
setups:
  Setup1: EddyCurrent MaximumPasses=20 MinimumPasses=6 MinimumConvergedPasses=1 PercentRefinement=30 PercentError=1 NonLinearResidual=0.0001 SmoothBHCurve Frequency=28.5kHz SweepRanges{point 28500Hz} SaveAllFields
field plots:
  Mesh1: MeshPlots in Region on Setup1 : LastAdaptive at Freq=28500Hz Phase=0deg
  Mesh2: MeshPlots over a plane on Setup1 : LastAdaptive at Freq=28500Hz Phase=0deg
  Mag_B1: B over a plane on Setup1 : LastAdaptive at Freq=28500Hz Phase=45deg
reports:
  L Table 1: Matrix1.L(Np,Np), Matrix1.L(Ns,Np), Matrix1.L(Np,Ns), Matrix1.L(Ns,Ns), Matrix1.R(Np,Np), Matrix1.R(Ns,Np), Matrix1.R(Np,Ns), Matrix1.R(Ns,Ns) vs Freq on Setup1 : LastAdaptive

design Maxwell2DDesign4 (Maxwell 2D, Electrostatic, about Z geometry, model units mm)
geometry:
  Body1_2#36218, Body1_5#36398, Np3#36474, Np5#36526, Np6#36578, Np2#36630, Np8#36682, Np4#36734, Np7#36786, Np1#36838, Ns3#36890, Ns5#36942, Ns6#36994, Ns2#37046, Ns8#37098, Ns4#37150, Ns7#37202, Ns1#37254, plate_1#37306, plate_2#37358 = imported_body(D:\Karl,reverseengineer\core_assembled_flatwise.step)
  Region [vacuum] = region(percentage_offset=0 on all sides)
  [Body1_2#36218, Body1_5#36398, Np3#36474, Np5#36526, Np6#36578, Np2#36630, Np8#36682, Np4#36734, Np7#36786, Np1#36838, Ns3#36890, Ns5#36942, Ns6#36994, Ns2#37046, Ns8#37098, Ns4#37150, Ns7#37202, Ns1#37254, plate_1#37306, plate_2#37358].move(-28.7mm, -25.45mm, -13.7mm)
  [Body1_2#36218, Body1_5#36398, Np3#36474, Np5#36526, Np6#36578, Np2#36630, Np8#36682, Np4#36734, Np7#36786, Np1#36838, Ns3#36890, Ns5#36942, Ns6#36994, Ns2#37046, Ns8#37098, Ns4#37150, Ns7#37202, Ns1#37254, plate_1#37306, plate_2#37358].move(9.4mm, -25.45mm, 9.7178433mm)
  [Body1_2#36218, Body1_5#36398, Np3#36474, Np5#36526, Np6#36578, Np2#36630, Np8#36682, Np4#36734, Np7#36786, Np1#36838, Ns3#36890, Ns5#36942, Ns6#36994, Ns2#37046, Ns8#37098, Ns4#37150, Ns7#37202, Ns1#37254, plate_1#37306, plate_2#37358].move(0mm, 25.45mm, -5.4178433mm)
  Body1_2 [ferrite - real] = Body1_2#36218.section(plane=ZX)
  Body1_2#36218.delete()
  Body1_5 [ferrite - real] = Body1_5#36398.section(plane=ZX)
  Body1_5#36398.delete()
  Np3 [coppe_real] = Np3#36474.section(plane=ZX)
  Np3#36474.delete()
  Np5 [coppe_real] = Np5#36526.section(plane=ZX)
  Np5#36526.delete()
  Np6 [coppe_real] = Np6#36578.section(plane=ZX)
  Np6#36578.delete()
  Np2 [coppe_real] = Np2#36630.section(plane=ZX)
  Np2#36630.delete()
  Np8 [coppe_real] = Np8#36682.section(plane=ZX)
  Np8#36682.delete()
  Np4 [coppe_real] = Np4#36734.section(plane=ZX)
  Np4#36734.delete()
  Np7 [coppe_real] = Np7#36786.section(plane=ZX)
  Np7#36786.delete()
  Np1 [coppe_real] = Np1#36838.section(plane=ZX)
  Np1#36838.delete()
  Ns3 [coppe_real] = Ns3#36890.section(plane=ZX)
  Ns3#36890.delete()
  Ns5 [coppe_real] = Ns5#36942.section(plane=ZX)
  Ns5#36942.delete()
  Ns6 [coppe_real] = Ns6#36994.section(plane=ZX)
  Ns6#36994.delete()
  Ns2 [coppe_real] = Ns2#37046.section(plane=ZX)
  Ns2#37046.delete()
  Ns8 [coppe_real] = Ns8#37098.section(plane=ZX)
  Ns8#37098.delete()
  Ns4 [coppe_real] = Ns4#37150.section(plane=ZX)
  Ns4#37150.delete()
  Ns7 [coppe_real] = Ns7#37202.section(plane=ZX)
  Ns7#37202.delete()
  Ns1 [coppe_real] = Ns1#37254.section(plane=ZX)
  Ns1#37254.delete()
  plate_1 [silicon_TIMreal] = plate_1#37306.section(plane=ZX)
  plate_1#37306.delete()
  plate_2 [silicon_TIMreal] = plate_2#37358.section(plane=ZX)
  plate_2#37358.delete()
  [Body1_2, Body1_5, Np3, Np5, Np6, Np2, Np8, Np4, Np7, Np1, Ns3, Ns5, Ns6, Ns2, Ns8, Ns4, Ns7, Ns1, plate_1, plate_2].move(19.3mm, 0mm, 9.4mm)
  group core_togetherv4 = Body1_2
  group core_togetherv41 = Body1_5
  group Wire_face_flatwise_newv8 = Np3, Np5, Np6, Np2, Np8, Np4, Np7, Np1, Ns3, Ns5, Ns6, Ns2, Ns8, Ns4, Ns7, Ns1, plate_1, plate_2
mesh:
  EdgeCut1: EdgeCutLayerMesh Objects=[Body1_5, Region, Body1_2, Np3, Np5, Np6, Np2, Np8, Np4, Np7, Np1, Ns3, Ns5, Ns6, Ns2, Ns8, Ns4, Ns7, Ns1, plate_1, plate_2] Layer_Thickenss=0.01mm
  initial mesh: GlobalSurfApproximation{CurvedSurfaceApproxChoice=UseSlider SliderMeshSettings=9}
setups:
  Setup1: Electrostatic MaximumPasses=20 MinimumPasses=5 MinimumConvergedPasses=1 PercentRefinement=30 PercentError=1 NonLinearResidual=0.001
field plots:
  Mesh1: MeshPlots over Region, Body1_2, Body1_5, Np3, Np5, Np6, Np2, Np8, Np4, Np7, Np1, Ns3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 on Setup1 : LastAdaptive

design Edgewise_100kW_Thermal (Icepak, SteadyState TemperatureAndFlow, model units mm)
options: Default_Fluid_Material=air Default_Solid_Material=Al-Extruded Default_Surface_Material=Steel-oxidised-surface AmbientTemperature=20cel AmbientPressure=0n_per_meter_sq AmbientRadiationTemperature=20cel Gravity_Vector_CS_ID=Global Gravity_Vector_Axis=Z Positive=false Altitude=0meter
geometry:
  Region [air] = region(percentage_offset=50 on all sides)
  Body1 [ferrite - real2] = imported_body(D:\Karl_HighPower\core_assembled_edgewise_100kW.step)
  Body1_1, Body1_2 [aluminum_real] = imported_body(D:\Karl_HighPower\core_assembled_edgewise_100kW.step)
  Body1_3 [ferrite - real2] = imported_body(D:\Karl_HighPower\core_assembled_edgewise_100kW.step)
  Body1_4, Body1_5 [aluminum_real] = imported_body(D:\Karl_HighPower\core_assembled_edgewise_100kW.step)
  plate1, plate2 [silicon_TIMreal] = imported_body(D:\Karl_HighPower\core_assembled_edgewise_100kW.step)
  Ns8, Ns4, Ns1, Ns5, Ns7, Ns3, Ns2, Ns6, Np8, Np4, Np1, Np5, Np7, Np3, Np2, Np6 [coppe_real] = imported_body(D:\Karl_HighPower\core_assembled_edgewise_100kW.step)
  Box1 [Al-Extruded] = box(corner=(178mm, -64mm, 0mm), size=(-178mm, 328.69mm, -5mm))
  point Point1 = (89mm, 100.345mm, 0mm)
  Box2 [Al-Extruded] = box(corner=(0mm, -64mm, -5mm), size=(400mm, 600mm, -15mm))
  Box2.move(400mm, -336mm, 5mm)
  Box2.move(-511mm, 200.345mm, -5mm)
  group core_assembled_edgewise_100kW = Body1, Body1_1..Body1_5, plate1, plate2, Ns8, Ns4, Ns1, Ns5, Ns7, Ns3, Ns2, Ns6, Np8, Np4, Np1, Np5, Np7, Np3, Np2, Np6
mesh:
  MeshRegions:  Global{MeshMethod=MesherHD ComputeGap MeshRegionResolution=3 MinGapX=1mm MinGapY=1mm MinGapZ=1mm Objects=Region FacetLevel=3 ProximitySizeFunction CurvatureSizeFunction OptimizePCBMesh}
  MeshOperations:

design [Thermal]Edgewise_100kW (Icepak, SteadyState TemperatureAndFlow, model units mm)
options: Default_Fluid_Material=air Default_Solid_Material=Al-Extruded Default_Surface_Material=Steel-oxidised-surface AmbientTemperature=25cel AmbientPressure=0n_per_meter_sq AmbientRadiationTemperature=25cel Gravity_Vector_CS_ID=Global Gravity_Vector_Axis=Z Positive=false SherlockExportDirectory=C:/Users/karlr/Documents/Ansoft/1kW_Final.aedtexport/[Thermal]8turns_3D_CoreLoss_FullInterleaved_Flatwise/ Altitude=0meter
geometry:
  Region [air] = region(percentage_offset=1000 on all sides)
  Body1 [ferrite - real2] = imported_body(D:\Karl_HighPower\core_assembled_edgewise_100kW.step)
  Body1_1, Body1_2 [aluminum_real] = imported_body(D:\Karl_HighPower\core_assembled_edgewise_100kW.step)
  Body1_3 [ferrite - real2] = imported_body(D:\Karl_HighPower\core_assembled_edgewise_100kW.step)
  Body1_4, Body1_5 [aluminum_real] = imported_body(D:\Karl_HighPower\core_assembled_edgewise_100kW.step)
  plate1, plate2 [silicon_TIMreal] = imported_body(D:\Karl_HighPower\core_assembled_edgewise_100kW.step)
  Ns8, Ns4, Ns1, Ns5, Ns7, Ns3, Ns2, Ns6, Np8, Np4, Np1, Np5, Np7, Np3, Np2, Np6 [coppe_real] = imported_body(D:\Karl_HighPower\core_assembled_edgewise_100kW.step)
  Box1 [silicon - Copy] = box(corner=(178mm, -64mm, 0mm), size=(-178mm, 328.69mm, -5mm))
  Box2 [aluminum] = box(corner=(0mm, -64mm, -5mm), size=(400mm, 600mm, -15mm))
  Box2.move(400mm, -336mm, 5mm)
  Box2.move(-511mm, 200.345mm, -5mm)
  Box3 [non-model] = box(corner=(12.5mm, -64mm, 49.3mm), size=(153mm, 328.69mm, 2mm))
  Box4 [non-model] = box(corner=(12.5mm, -64mm, 12.5mm), size=(153mm, 328.69mm, 2mm))
  Box5 [non-model] = box(corner=(12.5mm, -64mm, 12.5mm), size=(153mm, 328.69mm, 38.8mm))
  group core_assembled_edgewise_100kW = Body1, Body1_1..Body1_5, plate1, plate2, Ns8, Ns4, Ns1, Ns5, Ns7, Ns3, Ns2, Ns6, Np8, Np4, Np1, Np5, Np7, Np3, Np2, Np6
boundaries and excitations:
  Opening1: Opening Faces=Region.face(-y) Temperature=AmbientTemp External_Rad._Temperature=AmbientRadTemp Inlet_Type=Velocity Static_Pressure=AmbientPressure X_Velocity=0m_per_sec Y_Velocity=0m_per_sec Z_Velocity=0m_per_sec
  Opening2: Opening Faces=Region.face(+y) Temperature=AmbientTemp External_Rad._Temperature=AmbientRadTemp Inlet_Type=Pressure Total_Pressure=AmbientPressure
  StationaryWall1: Stationary Wall Faces=Box2.face(-z) Thickness=0mm Solid_Material=Al-Extruded External_Condition="Heat Transfer Coefficient" Heat_Flux=0irrad_W_per_m2 Temperature=AmbientTemp Heat_Transfer_Coefficient=100w_per_m2kel Reference_Temperature=AmbientTemp Heat_Transfer_Data{Heat_Transfer_Convection_Type="Forced Convection"} External_Material=Steel-oxidised-surface External_Radiation_Reference_Temperature=AmbientTemp External_Radiation_View_Factor=1
  EMLoss1: EM Loss Objects=[Body1, Body1_1..Body1_5, Ns8, Ns4, Ns1, Ns5, Ns7, Ns3, Ns2, Ns6, Np8, Np4, Np1, Np5, Np7, Np3, Np2, Np6] LinkID=873 Project="This Project*" Product=ElectronicsDesktop Design=Edgewise_100kW Params{freq_hz=28500Hz} ForceSourceToSolve PreservePartnerSoln PathRelativeTo=TargetProject Intrinsics(28.5kHz) LossMultiplier=1
mesh:
  MeshRegions:  Global{MeshMethod=MesherHD ComputeGap MeshRegionResolution=5 MinGapX=1mm MinGapY=1mm MinGapZ=1mm Objects=Region FacetLevel=5 ProximitySizeFunction CurvatureSizeFunction OptimizePCBMesh} MeshRegion1{disabled MeshMethod=MesherHD UserSpecifiedSettings MaxElementSizeX=2mm MaxElementSizeY=5mm MaxElementSizeZ=0.06667mm MinElementsInGap=3 MinElementsOnEdge=2 MaxSizeRatio=2 EnableMLM EnforeMLMType=3D MaxLevels=0 BufferLayers=0 UniformMeshParametersType=Average 2DMLMType=2DMLM_None MinGapX=1mm MinGapY=1mm MinGapZ=1mm Objects=Box3 ProximitySizeFunction CurvatureSizeFunction OptimizePCBMesh} MeshRegion2{disabled MeshMethod=MesherHD UserSpecifiedSettings MaxElementSizeX=2mm MaxElementSizeY=5mm MaxElementSizeZ=0.06667mm MinElementsInGap=3 MinElementsOnEdge=2 MaxSizeRatio=2 EnableMLM EnforeMLMType=3D MaxLevels=0 BufferLayers=0 UniformMeshParametersType=Average 2DMLMType=2DMLM_None MinGapX=1mm MinGapY=1mm MinGapZ=1mm Objects=Box4 ProximitySizeFunction CurvatureSizeFunction OptimizePCBMesh} MeshRegion3{MeshMethod=MesherHD MeshRegionResolution=5 MinGapX=1mm MinGapY=1mm MinGapZ=1mm Objects=Box5 ProximitySizeFunction CurvatureSizeFunction OptimizePCBMesh}
  MeshOperations:
setups:
  Setup1: IcepakSteadyState Flow_Regime=Laminar Include_Temperature=true Include_Flow=true Include_Gravity Solution_Initialization_-_Z_Velocity=0.000980665m_per_sec Convergence_Criteria_-_Flow=0.001 Convergence_Criteria_-_Energy=1e-07 Convergence_Criteria_-_Discrete_Ordinates=1e-06 Radiation_Model="Discrete Ordinates Model" Flow_Iteration_Per_Radiation_Iteration=10 ThetaDivision=2 PhiDivision=2 ThetaPixels=2 PhiPixels=2 Under-relaxation_-_Pressure=0.7 Under-relaxation_-_Momentum=0.3 Under-relaxation_-_Temperature=1 Discretization_Scheme_-_Pressure=Standard Discretization_Scheme_-_Momentum=First Discretization_Scheme_-_Temperature=First Discretization_Scheme_-_Discrete_Ordinates=First Convergence_Criteria_-_Max_Iterations=10000

design [Thermal]Flatwise_100kW (Icepak, SteadyState TemperatureAndFlow, model units mm)
options: Default_Fluid_Material=air Default_Solid_Material=Al-Extruded Default_Surface_Material=Steel-oxidised-surface AmbientTemperature=25cel AmbientPressure=0n_per_meter_sq AmbientRadiationTemperature=25cel Gravity_Vector_CS_ID=Global Gravity_Vector_Axis=Z Positive=false SherlockExportDirectory=C:/Users/karlr/Documents/Ansoft/1kW_Final.aedtexport/[Thermal]8turns_3D_CoreLoss_FullInterleaved_Flatwise/ Altitude=0meter
geometry:
  Region [air] = region(percentage_offset=1000 on all sides)
  Box2 [aluminum] = box(corner=(0mm, -64mm, -5mm), size=(400mm, 600mm, -15mm))
  Box2.move(400mm, -336mm, 5mm)
  Box2.move(-511mm, 200.345mm, -5mm)
  Body1, Body1_1 [aluminum_real] = imported_body(D:\Karl_HighPower\flatwise_100kW.step)
  Body1_2 [ferrite - real2] = imported_body(D:\Karl_HighPower\flatwise_100kW.step)
  Body1_3, Body1_4 [aluminum_real] = imported_body(D:\Karl_HighPower\flatwise_100kW.step)
  Body1_5 [ferrite - real2] = imported_body(D:\Karl_HighPower\flatwise_100kW.step)
  plate_1, plate_2 [silicon_TIMreal] = imported_body(D:\Karl_HighPower\flatwise_100kW.step)
  Ns1 [coppe_real] = imported_body(D:\Karl_HighPower\flatwise_100kW.step)
  Ns7 [coppe_real] = imported_body(D:\Karl_HighPower\flatwise_100kW.step)
  Ns4 [coppe_real] = imported_body(D:\Karl_HighPower\flatwise_100kW.step)
  Ns8 [coppe_real] = imported_body(D:\Karl_HighPower\flatwise_100kW.step)
  Ns2 [coppe_real] = imported_body(D:\Karl_HighPower\flatwise_100kW.step)
  Ns6 [coppe_real] = imported_body(D:\Karl_HighPower\flatwise_100kW.step)
  Ns5 [coppe_real] = imported_body(D:\Karl_HighPower\flatwise_100kW.step)
  Ns3 [coppe_real] = imported_body(D:\Karl_HighPower\flatwise_100kW.step)
  Np1 [coppe_real] = imported_body(D:\Karl_HighPower\flatwise_100kW.step)
  Np7 [coppe_real] = imported_body(D:\Karl_HighPower\flatwise_100kW.step)
  Np4 [coppe_real] = imported_body(D:\Karl_HighPower\flatwise_100kW.step)
  Np8 [coppe_real] = imported_body(D:\Karl_HighPower\flatwise_100kW.step)
  Np2 [coppe_real] = imported_body(D:\Karl_HighPower\flatwise_100kW.step)
  Np6 [coppe_real] = imported_body(D:\Karl_HighPower\flatwise_100kW.step)
  Np5 [coppe_real] = imported_body(D:\Karl_HighPower\flatwise_100kW.step)
  Np3 [coppe_real] = imported_body(D:\Karl_HighPower\flatwise_100kW.step)
  Box3 [Al-Extruded] = box(corner=(127.6mm, 239.49mm, 0mm), size=(-127.6mm, -278.29mm, -5mm))
  Box2.move(246.2mm, -40.345mm, 5mm)
  Box2.move(-315.2mm, -620mm, 0mm)
  Box2.move(-50mm, 0mm, -110mm)
  Box2.move(93.8mm, 660.345mm, 105mm)
  group flatwise_100kW = Body1, Body1_1..Body1_5, plate_1, plate_2, Ns1, Ns7, Ns4, Ns8, Ns2, Ns6, Ns5, Ns3, Np1, Np7, Np4, Np8, Np2, Np6, Np5, Np3
boundaries and excitations:
  Opening1: Opening Faces=Region.face(-y) Temperature=AmbientTemp External_Rad._Temperature=AmbientRadTemp Inlet_Type=Velocity Static_Pressure=AmbientPressure X_Velocity=0m_per_sec Y_Velocity=0m_per_sec Z_Velocity=0m_per_sec
  Opening2: Opening Faces=Region.face(+y) Temperature=AmbientTemp External_Rad._Temperature=AmbientRadTemp Inlet_Type=Pressure Total_Pressure=AmbientPressure
  StationaryWall1: Stationary Wall Faces=Box2.face(-z) Thickness=0mm Solid_Material=Al-Extruded External_Condition="Heat Transfer Coefficient" Heat_Flux=0irrad_W_per_m2 Temperature=AmbientTemp Heat_Transfer_Coefficient=100w_per_m2kel Reference_Temperature=AmbientTemp Heat_Transfer_Data{Heat_Transfer_Convection_Type="Forced Convection"} External_Material=Steel-oxidised-surface External_Radiation_Reference_Temperature=AmbientTemp External_Radiation_View_Factor=1
  EMLoss1: EM Loss Objects=[Body1, Body1_1..Body1_5, Ns1, Ns7, Ns4, Ns8, Ns2, Ns6, Ns5, Ns3, Np1, Np7, Np4, Np8, Np2, Np6, Np5, Np3] LinkID=899 Project="This Project*" Product=ElectronicsDesktop Design=Flatwise_100kW Params{freq_hz=28500Hz} ForceSourceToSolve PreservePartnerSoln PathRelativeTo=TargetProject Intrinsics(28.5kHz) LossMultiplier=1
mesh:
  MeshRegions:  Global{MeshMethod=MesherHD UserSpecifiedSettings ComputeGap MaxElementSizeX=2mm MaxElementSizeY=5mm MaxElementSizeZ=1mm MinElementsInGap=3 MinElementsOnEdge=2 MaxSizeRatio=2 EnableMLM EnforeMLMType=3D MaxLevels=0 BufferLayers=0 UniformMeshParametersType=Average MinGapX=1mm MinGapY=1mm MinGapZ=1mm Objects=Region FacetLevel=5 ProximitySizeFunction CurvatureSizeFunction OptimizePCBMesh}
  MeshOperations:
setups:
  Setup1: IcepakSteadyState Flow_Regime=Laminar Include_Temperature=true Include_Flow=true Include_Gravity Solution_Initialization_-_Z_Velocity=0.000980665m_per_sec Convergence_Criteria_-_Flow=0.001 Convergence_Criteria_-_Energy=1e-07 Convergence_Criteria_-_Discrete_Ordinates=1e-06 Radiation_Model="Discrete Ordinates Model" Flow_Iteration_Per_Radiation_Iteration=10 ThetaDivision=2 PhiDivision=2 ThetaPixels=2 PhiPixels=2 Under-relaxation_-_Pressure=0.7 Under-relaxation_-_Momentum=0.3 Under-relaxation_-_Temperature=1 Discretization_Scheme_-_Pressure=Standard Discretization_Scheme_-_Momentum=First Discretization_Scheme_-_Temperature=First Discretization_Scheme_-_Discrete_Ordinates=First Convergence_Criteria_-_Max_Iterations=10000

design [Thermal]Edgewise_100kW1 (Icepak, SteadyState TemperatureAndFlow, model units mm)
options: Default_Fluid_Material=air Default_Solid_Material=Al-Extruded Default_Surface_Material=Steel-oxidised-surface AmbientTemperature=25cel AmbientPressure=0n_per_meter_sq AmbientRadiationTemperature=25cel Gravity_Vector_CS_ID=Global Gravity_Vector_Axis=Z Positive=false SherlockExportDirectory=C:/Users/karlr/Documents/Ansoft/1kW_Final.aedtexport/[Thermal]8turns_3D_CoreLoss_FullInterleaved_Flatwise/ Altitude=0meter
geometry:
  Region [air] = region(percentage_offset=1000 on all sides)
  Body1 [ferrite - real2] = imported_body(D:\Karl_HighPower\core_assembled_edgewise_100kW.step)
  Body1_1, Body1_2 [aluminum_real] = imported_body(D:\Karl_HighPower\core_assembled_edgewise_100kW.step)
  Body1_3 [ferrite - real2] = imported_body(D:\Karl_HighPower\core_assembled_edgewise_100kW.step)
  Body1_4, Body1_5 [aluminum_real] = imported_body(D:\Karl_HighPower\core_assembled_edgewise_100kW.step)
  plate1, plate2 [silicon_TIMreal] = imported_body(D:\Karl_HighPower\core_assembled_edgewise_100kW.step)
  Ns8, Ns4, Ns1, Ns5, Ns7, Ns3, Ns2, Ns6, Np8, Np4, Np1, Np5, Np7, Np3, Np2, Np6 [coppe_real] = imported_body(D:\Karl_HighPower\core_assembled_edgewise_100kW.step)
  Box1 [silicon - Copy] = box(corner=(178mm, -64mm, 0mm), size=(-178mm, 328.69mm, -5mm))
  Box3 [non-model] = box(corner=(12.5mm, -64mm, 49.3mm), size=(153mm, 328.69mm, 2mm))
  Box4 [non-model] = box(corner=(12.5mm, -64mm, 12.5mm), size=(153mm, 328.69mm, 2mm))
  Box5 [non-model] = box(corner=(12.5mm, -64mm, 12.5mm), size=(153mm, 328.69mm, 38.8mm))
  Box6 [non-model] = box(corner=(14.5mm, -62mm, 14.5mm), size=(149mm, 324.69mm, 34.8mm))
  group core_assembled_edgewise_100kW = Body1, Body1_1..Body1_5, plate1, plate2, Ns8, Ns4, Ns1, Ns5, Ns7, Ns3, Ns2, Ns6, Np8, Np4, Np1, Np5, Np7, Np3, Np2, Np6
boundaries and excitations:
  Opening1: Opening Faces=Region.face(-y) Temperature=AmbientTemp External_Rad._Temperature=AmbientRadTemp Inlet_Type=Velocity Static_Pressure=AmbientPressure X_Velocity=0m_per_sec Y_Velocity=0m_per_sec Z_Velocity=0m_per_sec
  Opening2: Opening Faces=Region.face(+y) Temperature=AmbientTemp External_Rad._Temperature=AmbientRadTemp Inlet_Type=Pressure Total_Pressure=AmbientPressure
  EMLoss1: EM Loss Objects=[Body1, Body1_1..Body1_5, Ns8, Ns4, Ns1, Ns5, Ns7, Ns3, Ns2, Ns6, Np8, Np4, Np1, Np5, Np7, Np3, Np2, Np6] LinkID=873 Project="This Project*" Product=ElectronicsDesktop Design=Edgewise_100kW Params{freq_hz=28500Hz} ForceSourceToSolve PreservePartnerSoln PathRelativeTo=TargetProject Intrinsics(28.5kHz) LossMultiplier=1
  StationaryWall1: Stationary Wall Faces=Box1.face(-z) Thickness=0mm Solid_Material=Al-Extruded External_Condition=Temperature Heat_Flux=0irrad_W_per_m2 Temperature=20cel Heat_Transfer_Coefficient=0w_per_m2kel Reference_Temperature=AmbientTemp Heat_Transfer_Data{Heat_Transfer_Convection_Type="Forced Convection"} External_Material=Steel-oxidised-surface External_Radiation_Reference_Temperature=AmbientTemp External_Radiation_View_Factor=1
mesh:
  MeshRegions:  Global{MeshMethod=MesherHD ComputeGap MeshRegionResolution=5 MinGapX=1mm MinGapY=1mm MinGapZ=1mm Objects=Region FacetLevel=5 ProximitySizeFunction CurvatureSizeFunction OptimizePCBMesh} MeshRegion1{disabled MeshMethod=MesherHD UserSpecifiedSettings MaxElementSizeX=2mm MaxElementSizeY=5mm MaxElementSizeZ=0.06667mm MinElementsInGap=3 MinElementsOnEdge=2 MaxSizeRatio=2 EnableMLM EnforeMLMType=3D MaxLevels=0 BufferLayers=0 UniformMeshParametersType=Average 2DMLMType=2DMLM_None MinGapX=1mm MinGapY=1mm MinGapZ=1mm Objects=Box3 ProximitySizeFunction CurvatureSizeFunction OptimizePCBMesh} MeshRegion2{disabled MeshMethod=MesherHD UserSpecifiedSettings MaxElementSizeX=2mm MaxElementSizeY=5mm MaxElementSizeZ=0.06667mm MinElementsInGap=3 MinElementsOnEdge=2 MaxSizeRatio=2 EnableMLM EnforeMLMType=3D MaxLevels=0 BufferLayers=0 UniformMeshParametersType=Average 2DMLMType=2DMLM_None MinGapX=1mm MinGapY=1mm MinGapZ=1mm Objects=Box4 ProximitySizeFunction CurvatureSizeFunction OptimizePCBMesh} MeshRegion3{disabled MeshMethod=MesherHD MeshRegionResolution=5 MinGapX=1mm MinGapY=1mm MinGapZ=1mm Objects=Box5 ProximitySizeFunction CurvatureSizeFunction OptimizePCBMesh} MeshRegion4{MeshMethod=MesherHD MeshRegionResolution=5 MinGapX=1mm MinGapY=1mm MinGapZ=1mm Objects=Box6 ProximitySizeFunction CurvatureSizeFunction OptimizePCBMesh}
  MeshOperations:
setups:
  Setup1: IcepakSteadyState Flow_Regime=Laminar Include_Temperature=true Include_Flow=true Include_Gravity Solution_Initialization_-_Z_Velocity=0.000980665m_per_sec Convergence_Criteria_-_Flow=0.001 Convergence_Criteria_-_Energy=1e-07 Convergence_Criteria_-_Discrete_Ordinates=1e-06 Radiation_Model="Discrete Ordinates Model" Flow_Iteration_Per_Radiation_Iteration=10 ThetaDivision=2 PhiDivision=2 ThetaPixels=2 PhiPixels=2 Under-relaxation_-_Pressure=0.7 Under-relaxation_-_Momentum=0.3 Under-relaxation_-_Temperature=1 Discretization_Scheme_-_Pressure=Standard Discretization_Scheme_-_Momentum=First Discretization_Scheme_-_Temperature=First Discretization_Scheme_-_Discrete_Ordinates=First Convergence_Criteria_-_Max_Iterations=1000

design [Thermal]Flatwise_100kW1 (Icepak, SteadyState TemperatureAndFlow, model units mm)
options: Default_Fluid_Material=air Default_Solid_Material=Al-Extruded Default_Surface_Material=Steel-oxidised-surface AmbientTemperature=25cel AmbientPressure=0n_per_meter_sq AmbientRadiationTemperature=25cel Gravity_Vector_CS_ID=Global Gravity_Vector_Axis=Z Positive=false SherlockExportDirectory=C:/Users/karlr/Documents/Ansoft/1kW_Final.aedtexport/[Thermal]8turns_3D_CoreLoss_FullInterleaved_Flatwise/ Altitude=0meter
geometry:
  Region [air] = region(percentage_offset=1000 on all sides)
  Body1, Body1_1 [aluminum_real] = imported_body(D:\Karl_HighPower\flatwise_100kW.step)
  Body1_2 [ferrite - real2] = imported_body(D:\Karl_HighPower\flatwise_100kW.step)
  Body1_3, Body1_4 [aluminum_real] = imported_body(D:\Karl_HighPower\flatwise_100kW.step)
  Body1_5 [ferrite - real2] = imported_body(D:\Karl_HighPower\flatwise_100kW.step)
  plate_1, plate_2 [silicon_TIMreal] = imported_body(D:\Karl_HighPower\flatwise_100kW.step)
  Ns1 [coppe_real] = imported_body(D:\Karl_HighPower\flatwise_100kW.step)
  Ns7 [coppe_real] = imported_body(D:\Karl_HighPower\flatwise_100kW.step)
  Ns4 [coppe_real] = imported_body(D:\Karl_HighPower\flatwise_100kW.step)
  Ns8 [coppe_real] = imported_body(D:\Karl_HighPower\flatwise_100kW.step)
  Ns2 [coppe_real] = imported_body(D:\Karl_HighPower\flatwise_100kW.step)
  Ns6 [coppe_real] = imported_body(D:\Karl_HighPower\flatwise_100kW.step)
  Ns5 [coppe_real] = imported_body(D:\Karl_HighPower\flatwise_100kW.step)
  Ns3 [coppe_real] = imported_body(D:\Karl_HighPower\flatwise_100kW.step)
  Np1 [coppe_real] = imported_body(D:\Karl_HighPower\flatwise_100kW.step)
  Np7 [coppe_real] = imported_body(D:\Karl_HighPower\flatwise_100kW.step)
  Np4 [coppe_real] = imported_body(D:\Karl_HighPower\flatwise_100kW.step)
  Np8 [coppe_real] = imported_body(D:\Karl_HighPower\flatwise_100kW.step)
  Np2 [coppe_real] = imported_body(D:\Karl_HighPower\flatwise_100kW.step)
  Np6 [coppe_real] = imported_body(D:\Karl_HighPower\flatwise_100kW.step)
  Np5 [coppe_real] = imported_body(D:\Karl_HighPower\flatwise_100kW.step)
  Np3 [coppe_real] = imported_body(D:\Karl_HighPower\flatwise_100kW.step)
  Box3 [silicon - Copy] = box(corner=(127.6mm, 239.49mm, 0mm), size=(-127.6mm, -278.29mm, -5mm))
  Rectangle1 [Al-Extruded, non-model] = rectangle(corner=(0mm, 100.345mm, -5mm), z_size=94mm, x_size=127.6mm)
  group flatwise_100kW = Body1, Body1_1..Body1_5, plate_1, plate_2, Ns1, Ns7, Ns4, Ns8, Ns2, Ns6, Ns5, Ns3, Np1, Np7, Np4, Np8, Np2, Np6, Np5, Np3
boundaries and excitations:
  Opening1: Opening Faces=Region.face(-y) Temperature=AmbientTemp External_Rad._Temperature=AmbientRadTemp Inlet_Type=Velocity Static_Pressure=AmbientPressure X_Velocity=0m_per_sec Y_Velocity=0m_per_sec Z_Velocity=0m_per_sec
  Opening2: Opening Faces=Region.face(+y) Temperature=AmbientTemp External_Rad._Temperature=AmbientRadTemp Inlet_Type=Pressure Total_Pressure=AmbientPressure
  EMLoss1: EM Loss Objects=[Body1, Body1_1..Body1_5, Ns1, Ns7, Ns4, Ns8, Ns2, Ns6, Ns5, Ns3, Np1, Np7, Np4, Np8, Np2, Np6, Np5, Np3] LinkID=899 Project="This Project*" Product=ElectronicsDesktop Design=Flatwise_100kW Params{freq_hz=28500Hz} ForceSourceToSolve PreservePartnerSoln PathRelativeTo=TargetProject Intrinsics(28.5kHz) LossMultiplier=1
  StationaryWall1: Stationary Wall Faces=Box3.face(-z) Thickness=0mm Solid_Material=Al-Extruded External_Condition=Temperature Heat_Flux=0irrad_W_per_m2 Temperature=20cel Heat_Transfer_Coefficient=0w_per_m2kel Reference_Temperature=AmbientTemp Heat_Transfer_Data{Heat_Transfer_Convection_Type="Forced Convection"} External_Material=Steel-oxidised-surface External_Radiation_Reference_Temperature=AmbientTemp External_Radiation_View_Factor=1
mesh:
  MeshRegions:  Global{MeshMethod=MesherHD ComputeGap MeshRegionResolution=5 MinGapX=1mm MinGapY=1mm MinGapZ=1mm Objects=Region FacetLevel=5 ProximitySizeFunction CurvatureSizeFunction OptimizePCBMesh}
  MeshOperations:
setups:
  Setup1: IcepakSteadyState Flow_Regime=Laminar Include_Temperature=true Include_Flow=true Include_Gravity Solution_Initialization_-_Z_Velocity=0.000980665m_per_sec Convergence_Criteria_-_Flow=0.001 Convergence_Criteria_-_Energy=1e-07 Convergence_Criteria_-_Discrete_Ordinates=1e-06 Radiation_Model="Discrete Ordinates Model" Flow_Iteration_Per_Radiation_Iteration=10 ThetaDivision=2 PhiDivision=2 ThetaPixels=2 PhiPixels=2 Under-relaxation_-_Pressure=0.7 Under-relaxation_-_Momentum=0.3 Under-relaxation_-_Temperature=1 Discretization_Scheme_-_Pressure=Standard Discretization_Scheme_-_Momentum=First Discretization_Scheme_-_Temperature=First Discretization_Scheme_-_Discrete_Ordinates=First Convergence_Criteria_-_Max_Iterations=1000
field plots:
  Temperature1: Temperature over Body1, Body1_1..Body1_5, plate_1, plate_2, Ns1, Ns7, Ns4, Ns8, Ns2, Ns6, Ns5, Ns3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 on Setup1 : SteadyState
  Temperature2: Temperature over a plane on Setup1 : SteadyState

design [Thermal]Edgewise_100kW2 (Icepak, SteadyState TemperatureAndFlow, model units mm)
options: Default_Fluid_Material=air Default_Solid_Material=Al-Extruded Default_Surface_Material=Steel-oxidised-surface AmbientTemperature=25cel AmbientPressure=0n_per_meter_sq AmbientRadiationTemperature=25cel Gravity_Vector_CS_ID=Global Gravity_Vector_Axis=Z Positive=false SherlockExportDirectory=C:/Users/karlr/Documents/Ansoft/1kW_Final.aedtexport/[Thermal]8turns_3D_CoreLoss_FullInterleaved_Flatwise/ Altitude=0meter
geometry:
  Region [air] = region(percentage_offset=1000 on all sides)
  Body1 [ferrite - real2] = imported_body(D:\Karl_HighPower\core_assembled_edgewise_100kW.step)
  Body1_1, Body1_2 [aluminum_real] = imported_body(D:\Karl_HighPower\core_assembled_edgewise_100kW.step)
  Body1_3 [ferrite - real2] = imported_body(D:\Karl_HighPower\core_assembled_edgewise_100kW.step)
  Body1_4, Body1_5 [aluminum_real] = imported_body(D:\Karl_HighPower\core_assembled_edgewise_100kW.step)
  plate1, plate2 [silicon_TIMreal] = imported_body(D:\Karl_HighPower\core_assembled_edgewise_100kW.step)
  Ns8, Ns4, Ns1, Ns5, Ns7, Ns3, Ns2, Ns6, Np8, Np4, Np1, Np5, Np7, Np3, Np2, Np6 [coppe_real] = imported_body(D:\Karl_HighPower\core_assembled_edgewise_100kW.step)
  Box1 [silicon - Copy] = box(corner=(178mm, -64mm, 0mm), size=(-178mm, 328.69mm, -5mm))
  Box3 [non-model] = box(corner=(12.5mm, -64mm, 49.3mm), size=(153mm, 328.69mm, 2mm))
  Box4 [non-model] = box(corner=(12.5mm, -64mm, 12.5mm), size=(153mm, 328.69mm, 2mm))
  Box5 [non-model] = box(corner=(12.5mm, -64mm, 12.5mm), size=(153mm, 328.69mm, 38.8mm))
  group core_assembled_edgewise_100kW = Body1, Body1_1..Body1_5, plate1, plate2, Ns8, Ns4, Ns1, Ns5, Ns7, Ns3, Ns2, Ns6, Np8, Np4, Np1, Np5, Np7, Np3, Np2, Np6
boundaries and excitations:
  Opening1: Opening Faces=Region.face(-y) Temperature=AmbientTemp External_Rad._Temperature=AmbientRadTemp Inlet_Type=Velocity Static_Pressure=AmbientPressure X_Velocity=0m_per_sec Y_Velocity=0m_per_sec Z_Velocity=0m_per_sec
  Opening2: Opening Faces=Region.face(+y) Temperature=AmbientTemp External_Rad._Temperature=AmbientRadTemp Inlet_Type=Pressure Total_Pressure=AmbientPressure
  EMLoss1: EM Loss Objects=[Body1, Body1_1..Body1_5, Ns8, Ns4, Ns1, Ns5, Ns7, Ns3, Ns2, Ns6, Np8, Np4, Np1, Np5, Np7, Np3, Np2, Np6] LinkID=873 Project="This Project*" Product=ElectronicsDesktop Design=Edgewise_100kW Params{freq_hz=28500Hz} ForceSourceToSolve PreservePartnerSoln PathRelativeTo=TargetProject Intrinsics(28.5kHz) LossMultiplier=1
  StationaryWall1: Stationary Wall Faces=Box1.face(-z) Thickness=0mm Solid_Material=Al-Extruded External_Condition=Temperature Heat_Flux=0irrad_W_per_m2 Temperature=20cel Heat_Transfer_Coefficient=0w_per_m2kel Reference_Temperature=AmbientTemp Heat_Transfer_Data{Heat_Transfer_Convection_Type="Forced Convection"} External_Material=Steel-oxidised-surface External_Radiation_Reference_Temperature=AmbientTemp External_Radiation_View_Factor=1
mesh:
  MeshRegions:  Global{MeshMethod=MesherHD ComputeGap MeshRegionResolution=5 MinGapX=1mm MinGapY=1mm MinGapZ=1mm Objects=Region FacetLevel=5 ProximitySizeFunction CurvatureSizeFunction OptimizePCBMesh} MeshRegion1{disabled MeshMethod=MesherHD UserSpecifiedSettings MaxElementSizeX=2mm MaxElementSizeY=5mm MaxElementSizeZ=0.06667mm MinElementsInGap=3 MinElementsOnEdge=2 MaxSizeRatio=2 EnableMLM EnforeMLMType=3D MaxLevels=0 BufferLayers=0 UniformMeshParametersType=Average 2DMLMType=2DMLM_None MinGapX=1mm MinGapY=1mm MinGapZ=1mm Objects=Box3 ProximitySizeFunction CurvatureSizeFunction OptimizePCBMesh} MeshRegion2{disabled MeshMethod=MesherHD UserSpecifiedSettings MaxElementSizeX=2mm MaxElementSizeY=5mm MaxElementSizeZ=0.06667mm MinElementsInGap=3 MinElementsOnEdge=2 MaxSizeRatio=2 EnableMLM EnforeMLMType=3D MaxLevels=0 BufferLayers=0 UniformMeshParametersType=Average 2DMLMType=2DMLM_None MinGapX=1mm MinGapY=1mm MinGapZ=1mm Objects=Box4 ProximitySizeFunction CurvatureSizeFunction OptimizePCBMesh} MeshRegion3{disabled MeshMethod=MesherHD MeshRegionResolution=5 MinGapX=1mm MinGapY=1mm MinGapZ=1mm Objects=Box5 ProximitySizeFunction CurvatureSizeFunction OptimizePCBMesh}
  MeshOperations:
setups:
  Setup1: IcepakSteadyState Flow_Regime=Laminar Include_Temperature=true Include_Flow=true Include_Gravity Solution_Initialization_-_Z_Velocity=0.000980665m_per_sec Convergence_Criteria_-_Flow=0.001 Convergence_Criteria_-_Energy=1e-07 Convergence_Criteria_-_Discrete_Ordinates=1e-06 Radiation_Model="Discrete Ordinates Model" Flow_Iteration_Per_Radiation_Iteration=10 ThetaDivision=2 PhiDivision=2 ThetaPixels=2 PhiPixels=2 Under-relaxation_-_Pressure=0.7 Under-relaxation_-_Momentum=0.3 Under-relaxation_-_Temperature=1 Discretization_Scheme_-_Pressure=Standard Discretization_Scheme_-_Momentum=First Discretization_Scheme_-_Temperature=First Discretization_Scheme_-_Discrete_Ordinates=First Convergence_Criteria_-_Max_Iterations=1000
field plots:
  Temperature1: Temperature on Setup1 : SteadyState

design [Thermal]Flatwise_100kW3 (Icepak, SteadyState TemperatureAndFlow, model units mm)
options: Default_Fluid_Material=air Default_Solid_Material=Al-Extruded Default_Surface_Material=Steel-oxidised-surface AmbientTemperature=25cel AmbientPressure=0n_per_meter_sq AmbientRadiationTemperature=25cel Gravity_Vector_CS_ID=Global Gravity_Vector_Axis=Z Positive=false SherlockExportDirectory=C:/Users/karlr/Documents/Ansoft/1kW_Final.aedtexport/[Thermal]8turns_3D_CoreLoss_FullInterleaved_Flatwise/ Altitude=0meter
geometry:
  Region [air] = region(percentage_offset=1000 on all sides)
  Body1, Body1_1 [aluminum_real] = imported_body(D:\Karl_HighPower\flatwise_100kW.step)
  Body1_2 [ferrite - real2] = imported_body(D:\Karl_HighPower\flatwise_100kW.step)
  Body1_3, Body1_4 [aluminum_real] = imported_body(D:\Karl_HighPower\flatwise_100kW.step)
  Body1_5 [ferrite - real2] = imported_body(D:\Karl_HighPower\flatwise_100kW.step)
  plate_1, plate_2 [silicon_TIMreal] = imported_body(D:\Karl_HighPower\flatwise_100kW.step)
  Ns1 [coppe_real] = imported_body(D:\Karl_HighPower\flatwise_100kW.step)
  Ns7 [coppe_real] = imported_body(D:\Karl_HighPower\flatwise_100kW.step)
  Ns4 [coppe_real] = imported_body(D:\Karl_HighPower\flatwise_100kW.step)
  Ns8 [coppe_real] = imported_body(D:\Karl_HighPower\flatwise_100kW.step)
  Ns2 [coppe_real] = imported_body(D:\Karl_HighPower\flatwise_100kW.step)
  Ns6 [coppe_real] = imported_body(D:\Karl_HighPower\flatwise_100kW.step)
  Ns5 [coppe_real] = imported_body(D:\Karl_HighPower\flatwise_100kW.step)
  Ns3 [coppe_real] = imported_body(D:\Karl_HighPower\flatwise_100kW.step)
  Np1 [coppe_real] = imported_body(D:\Karl_HighPower\flatwise_100kW.step)
  Np7 [coppe_real] = imported_body(D:\Karl_HighPower\flatwise_100kW.step)
  Np4 [coppe_real] = imported_body(D:\Karl_HighPower\flatwise_100kW.step)
  Np8 [coppe_real] = imported_body(D:\Karl_HighPower\flatwise_100kW.step)
  Np2 [coppe_real] = imported_body(D:\Karl_HighPower\flatwise_100kW.step)
  Np6 [coppe_real] = imported_body(D:\Karl_HighPower\flatwise_100kW.step)
  Np5 [coppe_real] = imported_body(D:\Karl_HighPower\flatwise_100kW.step)
  Np3 [coppe_real] = imported_body(D:\Karl_HighPower\flatwise_100kW.step)
  Box3 [silicon - Copy] = box(corner=(127.6mm, 239.49mm, 0mm), size=(-127.6mm, -278.29mm, -5mm))
  Box4 [non-model] = box(corner=(14.5mm, -36.8mm, 14.5mm), size=(98.6mm, 274.29mm, 60mm))
  group flatwise_100kW = Body1, Body1_1..Body1_5, plate_1, plate_2, Ns1, Ns7, Ns4, Ns8, Ns2, Ns6, Ns5, Ns3, Np1, Np7, Np4, Np8, Np2, Np6, Np5, Np3
boundaries and excitations:
  Opening1: Opening Faces=Region.face(-y) Temperature=AmbientTemp External_Rad._Temperature=AmbientRadTemp Inlet_Type=Velocity Static_Pressure=AmbientPressure X_Velocity=0m_per_sec Y_Velocity=0m_per_sec Z_Velocity=0m_per_sec
  Opening2: Opening Faces=Region.face(+y) Temperature=AmbientTemp External_Rad._Temperature=AmbientRadTemp Inlet_Type=Pressure Total_Pressure=AmbientPressure
  EMLoss1: EM Loss Objects=[Body1, Body1_1..Body1_5, Ns1, Ns7, Ns4, Ns8, Ns2, Ns6, Ns5, Ns3, Np1, Np7, Np4, Np8, Np2, Np6, Np5, Np3] LinkID=899 Project="This Project*" Product=ElectronicsDesktop Design=Flatwise_100kW Params{freq_hz=28500Hz} ForceSourceToSolve PreservePartnerSoln PathRelativeTo=TargetProject Intrinsics(28.5kHz) LossMultiplier=1
  StationaryWall1: Stationary Wall Faces=Box3.face(-z) Thickness=0mm Solid_Material=Al-Extruded External_Condition=Temperature Heat_Flux=0irrad_W_per_m2 Temperature=20cel Heat_Transfer_Coefficient=0w_per_m2kel Reference_Temperature=AmbientTemp Heat_Transfer_Data{Heat_Transfer_Convection_Type="Forced Convection"} External_Material=Steel-oxidised-surface External_Radiation_Reference_Temperature=AmbientTemp External_Radiation_View_Factor=1
mesh:
  MeshRegions:  Global{MeshMethod=MesherHD ComputeGap MeshRegionResolution=5 MinGapX=1mm MinGapY=1mm MinGapZ=1mm Objects=Region FacetLevel=5 ProximitySizeFunction CurvatureSizeFunction OptimizePCBMesh} MeshRegion1{MeshMethod=MesherHD MeshRegionResolution=3 MinGapX=1mm MinGapY=1mm MinGapZ=1mm Objects=Box4 ProximitySizeFunction CurvatureSizeFunction OptimizePCBMesh}
  MeshOperations:
setups:
  Setup1: IcepakSteadyState Flow_Regime=Laminar Include_Temperature=true Include_Flow=true Include_Gravity Solution_Initialization_-_Z_Velocity=0.000980665m_per_sec Convergence_Criteria_-_Flow=0.001 Convergence_Criteria_-_Energy=1e-07 Convergence_Criteria_-_Discrete_Ordinates=1e-06 Radiation_Model="Discrete Ordinates Model" Flow_Iteration_Per_Radiation_Iteration=10 ThetaDivision=2 PhiDivision=2 ThetaPixels=2 PhiPixels=2 Under-relaxation_-_Pressure=0.7 Under-relaxation_-_Momentum=0.3 Under-relaxation_-_Temperature=1 Discretization_Scheme_-_Pressure=Standard Discretization_Scheme_-_Momentum=First Discretization_Scheme_-_Temperature=First Discretization_Scheme_-_Discrete_Ordinates=First Convergence_Criteria_-_Max_Iterations=1000

design [Thermal]Flatwise_100kW=latest (Icepak, SteadyState TemperatureAndFlow, model units mm)
options: Default_Fluid_Material=air Default_Solid_Material=Al-Extruded Default_Surface_Material=Steel-oxidised-surface AmbientTemperature=25cel AmbientPressure=0n_per_meter_sq AmbientRadiationTemperature=25cel Gravity_Vector_CS_ID=Global Gravity_Vector_Axis=Z Positive=false SherlockExportDirectory=C:/Users/karlr/Documents/Ansoft/1kW_Final.aedtexport/[Thermal]8turns_3D_CoreLoss_FullInterleaved_Flatwise/ Altitude=0meter
geometry:
  Region [air] = region(percentage_offset=1000 on all sides)
  Body1, Body1_1 [aluminum_real] = imported_body(D:\Karl_HighPower\flatwise_100kW.step)
  Body1_2 [ferrite - real2] = imported_body(D:\Karl_HighPower\flatwise_100kW.step)
  Body1_3, Body1_4 [aluminum_real] = imported_body(D:\Karl_HighPower\flatwise_100kW.step)
  Body1_5 [ferrite - real2] = imported_body(D:\Karl_HighPower\flatwise_100kW.step)
  plate_1, plate_2 [silicon_TIMreal] = imported_body(D:\Karl_HighPower\flatwise_100kW.step)
  Box3 [silicon - Copy] = box(corner=(127.6mm, 239.49mm, 0mm), size=(-127.6mm, -278.29mm, -5mm))
  Rectangle1 [Al-Extruded, non-model] = rectangle(corner=(0mm, 100.345mm, -5mm), z_size=94mm, x_size=127.6mm)
  Box4 [non-model] = box(corner=(12.5mm, -38.8mm, 12.5mm), size=(102.6mm, 278.29mm, 64mm))
  Np1..Np8, Ns1..Ns8 [coppe_real] = imported_body()
  Box5 [non-model] = box(corner=(12.5mm, -38.8mm, 12.5mm), size=(102.6mm, 278.29mm, 64mm))
  group flatwise_100kW = Body1, Body1_1..Body1_5, plate_1, plate_2, Ns1, Ns7, Ns4, Ns8, Ns2, Ns6, Ns5, Ns3, Np1, Np7, Np4, Np8, Np2, Np6, Np5, Np3
boundaries and excitations:
  Opening1: Opening Faces=Region.face(-y) Temperature=AmbientTemp External_Rad._Temperature=AmbientRadTemp Inlet_Type=Velocity Static_Pressure=AmbientPressure X_Velocity=0m_per_sec Y_Velocity=0m_per_sec Z_Velocity=0m_per_sec
  Opening2: Opening Faces=Region.face(+y) Temperature=AmbientTemp External_Rad._Temperature=AmbientRadTemp Inlet_Type=Pressure Total_Pressure=AmbientPressure
  EMLoss1: EM Loss Objects=[Body1, Body1_1..Body1_5, Ns1, Ns7, Ns4, Ns8, Ns2, Ns6, Ns5, Ns3, Np1, Np7, Np4, Np8, Np2, Np6, Np5, Np3] LinkID=899 Project="This Project*" Product=ElectronicsDesktop Design=Flatwise_100kW Params{freq_hz=28500Hz} ForceSourceToSolve PreservePartnerSoln PathRelativeTo=TargetProject Intrinsics(28.5kHz) LossMultiplier=1
  StationaryWall1: Stationary Wall Faces=Box3.face(-z) Thickness=0mm Solid_Material=Al-Extruded External_Condition=Temperature Heat_Flux=0irrad_W_per_m2 Temperature=20cel Heat_Transfer_Coefficient=0w_per_m2kel Reference_Temperature=AmbientTemp Heat_Transfer_Data{Heat_Transfer_Convection_Type="Forced Convection"} External_Material=Steel-oxidised-surface External_Radiation_Reference_Temperature=AmbientTemp External_Radiation_View_Factor=1
mesh:
  MeshRegions:  Global{MeshMethod=MesherHD ComputeGap MeshRegionResolution=5 MinGapX=1mm MinGapY=1mm MinGapZ=1mm Objects=Region FacetLevel=5 ProximitySizeFunction CurvatureSizeFunction OptimizePCBMesh} MeshRegion1{MeshMethod=MesherHD UserSpecifiedSettings MaxElementSizeX=0.3mm MaxElementSizeY=0.3mm MaxElementSizeZ=1mm MinElementsInGap=3 MinElementsOnEdge=2 MaxSizeRatio=2 EnableMLM EnforeMLMType=3D MaxLevels=0 BufferLayers=0 UniformMeshParametersType=Average 2DMLMType=2DMLM_None MinGapX=0.3mm MinGapY=0.3mm MinGapZ=0.3mm Objects=Box5 ProximitySizeFunction CurvatureSizeFunction OptimizePCBMesh}
  MeshOperations:
setups:
  Setup1: IcepakSteadyState Flow_Regime=Laminar Include_Temperature=true Include_Flow=true Include_Gravity Solution_Initialization_-_Z_Velocity=0.000980665m_per_sec Convergence_Criteria_-_Flow=0.001 Convergence_Criteria_-_Energy=1e-07 Convergence_Criteria_-_Discrete_Ordinates=1e-06 Radiation_Model="Discrete Ordinates Model" Flow_Iteration_Per_Radiation_Iteration=10 ThetaDivision=2 PhiDivision=2 ThetaPixels=2 PhiPixels=2 Under-relaxation_-_Pressure=0.7 Under-relaxation_-_Momentum=0.3 Under-relaxation_-_Temperature=1 Discretization_Scheme_-_Pressure=Standard Discretization_Scheme_-_Momentum=First Discretization_Scheme_-_Temperature=First Discretization_Scheme_-_Discrete_Ordinates=First Convergence_Criteria_-_Max_Iterations=1000
field plots:
  Temperature1: Temperature over Body1, Body1_1..Body1_5, plate_1, plate_2, Ns1, Ns7, Ns4, Ns8, Ns2, Ns6, Ns5, Ns3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 on Setup1 : SteadyState
  Temperature2: Temperature over a plane on Setup1 : SteadyState

design [Thermal]Edgewise_100kW3 (Icepak, SteadyState TemperatureAndFlow, model units mm)
options: Default_Fluid_Material=air Default_Solid_Material=Al-Extruded Default_Surface_Material=Steel-oxidised-surface AmbientTemperature=25cel AmbientPressure=0n_per_meter_sq AmbientRadiationTemperature=25cel Gravity_Vector_CS_ID=Global Gravity_Vector_Axis=Z Positive=false SherlockExportDirectory=C:/Users/karlr/Documents/Ansoft/1kW_Final.aedtexport/[Thermal]8turns_3D_CoreLoss_FullInterleaved_Flatwise/ Altitude=0meter
geometry:
  Region [air] = region(percentage_offset=1000 on all sides)
  Body1 [ferrite - real2] = imported_body(D:\Karl_HighPower\core_assembled_edgewise_100kW.step)
  Body1_1, Body1_2 [aluminum_real] = imported_body(D:\Karl_HighPower\core_assembled_edgewise_100kW.step)
  Body1_3 [ferrite - real2] = imported_body(D:\Karl_HighPower\core_assembled_edgewise_100kW.step)
  Body1_4, Body1_5 [aluminum_real] = imported_body(D:\Karl_HighPower\core_assembled_edgewise_100kW.step)
  plate1, plate2 [silicon_TIMreal] = imported_body(D:\Karl_HighPower\core_assembled_edgewise_100kW.step)
  Ns8, Ns4, Ns1, Ns5, Ns7, Ns3, Ns2, Ns6, Np8, Np4, Np1, Np5, Np7, Np3, Np2, Np6 [coppe_real] = imported_body(D:\Karl_HighPower\core_assembled_edgewise_100kW.step)
  Box1 [silicon - Copy] = imported_body()
  Box3, Box4, Box5 [non-model] = imported_body()
  Rectangle1 [Al-Extruded, non-model] = rectangle(corner=(178mm, 100.345mm, 63.8mm), z_size=-68.8mm, x_size=-178mm)
  group core_assembled_edgewise_100kW = Body1, Body1_1..Body1_5, plate1, plate2, Ns8, Ns4, Ns1, Ns5, Ns7, Ns3, Ns2, Ns6, Np8, Np4, Np1, Np5, Np7, Np3, Np2, Np6
boundaries and excitations:
  Opening1: Opening Faces=Region.face(-y) Temperature=AmbientTemp External_Rad._Temperature=AmbientRadTemp Inlet_Type=Velocity Static_Pressure=AmbientPressure X_Velocity=0m_per_sec Y_Velocity=0m_per_sec Z_Velocity=0m_per_sec
  Opening2: Opening Faces=Region.face(+y) Temperature=AmbientTemp External_Rad._Temperature=AmbientRadTemp Inlet_Type=Pressure Total_Pressure=AmbientPressure
  EMLoss1: EM Loss Objects=[Body1, Body1_1..Body1_5, Ns8, Ns4, Ns1, Ns5, Ns7, Ns3, Ns2, Ns6, Np8, Np4, Np1, Np5, Np7, Np3, Np2, Np6] LinkID=873 Project="This Project*" Product=ElectronicsDesktop Design=Edgewise_100kW Params{freq_hz=28500Hz} ForceSourceToSolve PreservePartnerSoln PathRelativeTo=TargetProject Intrinsics(28.5kHz) LossMultiplier=1
  StationaryWall1: Stationary Wall Faces=Box1.face(at (89, 100.345, -5)) Thickness=0mm Solid_Material=Al-Extruded External_Condition=Temperature Heat_Flux=0irrad_W_per_m2 Temperature=20cel Heat_Transfer_Coefficient=0w_per_m2kel Reference_Temperature=AmbientTemp Heat_Transfer_Data{Heat_Transfer_Convection_Type="Forced Convection"} External_Material=Steel-oxidised-surface External_Radiation_Reference_Temperature=AmbientTemp External_Radiation_View_Factor=1
mesh:
  MeshRegions:  Global{MeshMethod=MesherHD ComputeGap MeshRegionResolution=5 MinGapX=1mm MinGapY=1mm MinGapZ=1mm Objects=Region FacetLevel=5 ProximitySizeFunction CurvatureSizeFunction OptimizePCBMesh} MeshRegion1{disabled MeshMethod=MesherHD UserSpecifiedSettings MaxElementSizeX=2mm MaxElementSizeY=5mm MaxElementSizeZ=0.06667mm MinElementsInGap=3 MinElementsOnEdge=2 MaxSizeRatio=2 EnableMLM EnforeMLMType=3D MaxLevels=0 BufferLayers=0 UniformMeshParametersType=Average 2DMLMType=2DMLM_None MinGapX=1mm MinGapY=1mm MinGapZ=1mm Objects=Box3 ProximitySizeFunction CurvatureSizeFunction OptimizePCBMesh} MeshRegion2{disabled MeshMethod=MesherHD UserSpecifiedSettings MaxElementSizeX=2mm MaxElementSizeY=5mm MaxElementSizeZ=0.06667mm MinElementsInGap=3 MinElementsOnEdge=2 MaxSizeRatio=2 EnableMLM EnforeMLMType=3D MaxLevels=0 BufferLayers=0 UniformMeshParametersType=Average 2DMLMType=2DMLM_None MinGapX=1mm MinGapY=1mm MinGapZ=1mm Objects=Box4 ProximitySizeFunction CurvatureSizeFunction OptimizePCBMesh} MeshRegion3{disabled MeshMethod=MesherHD MeshRegionResolution=5 MinGapX=1mm MinGapY=1mm MinGapZ=1mm Objects=Box5 ProximitySizeFunction CurvatureSizeFunction OptimizePCBMesh}
  MeshOperations:
setups:
  Setup1: IcepakSteadyState Flow_Regime=Laminar Include_Temperature=true Include_Flow=true Include_Gravity Solution_Initialization_-_Z_Velocity=0.000980665m_per_sec Convergence_Criteria_-_Flow=0.001 Convergence_Criteria_-_Energy=1e-07 Convergence_Criteria_-_Discrete_Ordinates=1e-06 Radiation_Model="Discrete Ordinates Model" Flow_Iteration_Per_Radiation_Iteration=10 ThetaDivision=2 PhiDivision=2 ThetaPixels=2 PhiPixels=2 Under-relaxation_-_Pressure=0.7 Under-relaxation_-_Momentum=0.3 Under-relaxation_-_Temperature=1 Discretization_Scheme_-_Pressure=Standard Discretization_Scheme_-_Momentum=First Discretization_Scheme_-_Temperature=First Discretization_Scheme_-_Discrete_Ordinates=First Convergence_Criteria_-_Max_Iterations=1000
field plots:
  Temperature1: Temperature on Setup1 : SteadyState
  Temperature2: Temperature over a plane on Setup1 : SteadyState

design [Thermal]Edgewise_100kW=650 (Icepak, SteadyState TemperatureAndFlow, model units mm)
options: Default_Fluid_Material=air Default_Solid_Material=Al-Extruded Default_Surface_Material=Steel-oxidised-surface AmbientTemperature=25cel AmbientPressure=0n_per_meter_sq AmbientRadiationTemperature=25cel Gravity_Vector_CS_ID=Global Gravity_Vector_Axis=Z Positive=false SherlockExportDirectory=C:/Users/karlr/Documents/Ansoft/1kW_Final.aedtexport/[Thermal]8turns_3D_CoreLoss_FullInterleaved_Flatwise/ Altitude=0meter
geometry:
  Region [air] = region(percentage_offset=1000 on all sides)
  Body1 [ferrite - real2] = imported_body(D:\Karl_HighPower\core_assembled_edgewise_100kW.step)
  Body1_1, Body1_2 [aluminum_real] = imported_body(D:\Karl_HighPower\core_assembled_edgewise_100kW.step)
  Body1_3 [ferrite - real2] = imported_body(D:\Karl_HighPower\core_assembled_edgewise_100kW.step)
  Body1_4, Body1_5 [aluminum_real] = imported_body(D:\Karl_HighPower\core_assembled_edgewise_100kW.step)
  plate1, plate2 [silicon_TIMreal] = imported_body(D:\Karl_HighPower\core_assembled_edgewise_100kW.step)
  Ns8, Ns4, Ns1, Ns5, Ns7, Ns3, Ns2, Ns6, Np8, Np4, Np1, Np5, Np7, Np3, Np2, Np6 [coppe_real] = imported_body(D:\Karl_HighPower\core_assembled_edgewise_100kW.step)
  Box1 [silicon - Copy] = imported_body()
  Box3, Box4, Box5 [non-model] = imported_body()
  Rectangle1 [Al-Extruded, non-model] = rectangle(corner=(178mm, 100.345mm, 63.8mm), z_size=-68.8mm, x_size=-178mm)
  Box6 [non-model] = box(corner=(14.5mm, -62mm, 14.5mm), size=(149mm, 324.69mm, 34.8mm))
  Box7 [non-model] = box(corner=(12.5mm, -64mm, 49.3mm), size=(153mm, 328.69mm, 2mm))
  Box8 [non-model] = box(corner=(12.5mm, -64mm, 12.5mm), size=(153mm, 328.69mm, 2mm))
  Box9 [non-model] = box(corner=(14.5mm, -62mm, 14.5mm), size=(149mm, 324.69mm, 0.3mm))
  Box10 [non-model] = box(corner=(14.5mm, -62mm, 19.1mm), size=(149mm, 324.69mm, 0.3mm))
  Box11 [non-model] = box(corner=(14.5mm, -62mm, 23.7mm), size=(149mm, 324.69mm, 0.3mm))
  Box12 [non-model] = box(corner=(14.5mm, -62mm, 28.3mm), size=(149mm, 324.69mm, 0.3mm))
  Box13 [non-model] = box(corner=(14.5mm, -62mm, 32.9mm), size=(149mm, 324.69mm, 0.3mm))
  Box14 [non-model] = box(corner=(14.5mm, -62mm, 37.5mm), size=(149mm, 324.69mm, 0.3mm))
  Box15 [non-model] = box(corner=(14.5mm, -62mm, 42.1mm), size=(149mm, 324.69mm, 0.3mm))
  Box16 [non-model] = box(corner=(14.5mm, -62mm, 46.7mm), size=(149mm, 324.69mm, 0.3mm))
  Box17 [non-model] = box(corner=(14.5mm, -62mm, 16.8mm), size=(149mm, 324.69mm, 0.3mm))
  Box18 [non-model] = box(corner=(14.5mm, -62mm, 21.4mm), size=(149mm, 324.69mm, 0.3mm))
  Box19 [non-model] = box(corner=(14.5mm, -62mm, 26mm), size=(149mm, 324.69mm, 0.3mm))
  Box20 [non-model] = box(corner=(14.5mm, -62mm, 30.6mm), size=(149mm, 324.69mm, 0.3mm))
  Box21 [non-model] = box(corner=(14.5mm, -62mm, 35.2mm), size=(149mm, 324.69mm, 0.3mm))
  Box22 [non-model] = box(corner=(14.5mm, -62mm, 39.8mm), size=(149mm, 324.69mm, 0.3mm))
  Box23 [non-model] = box(corner=(14.5mm, -62mm, 44.4mm), size=(149mm, 324.69mm, 0.3mm))
  Box24 [non-model] = box(corner=(14.5mm, -62mm, 49mm), size=(149mm, 324.69mm, 0.3mm))
  Box25 [non-model] = box(corner=(12.5mm, -64mm, 49.3mm), size=(153mm, 328.69mm, 2mm))
  Box26 [non-model] = box(corner=(12.5mm, -64mm, 12.5mm), size=(153mm, 328.69mm, 2mm))
  Box27 [non-model] = box(corner=(12.5mm, -64mm, 12.5mm), size=(153mm, 328.69mm, 38.8mm))
  group core_assembled_edgewise_100kW = Body1, Body1_1..Body1_5, plate1, plate2, Ns8, Ns4, Ns1, Ns5, Ns7, Ns3, Ns2, Ns6, Np8, Np4, Np1, Np5, Np7, Np3, Np2, Np6
boundaries and excitations:
  Opening1: Opening Faces=Region.face(-y) Temperature=AmbientTemp External_Rad._Temperature=AmbientRadTemp Inlet_Type=Velocity Static_Pressure=AmbientPressure X_Velocity=0m_per_sec Y_Velocity=0m_per_sec Z_Velocity=0m_per_sec
  Opening2: Opening Faces=Region.face(+y) Temperature=AmbientTemp External_Rad._Temperature=AmbientRadTemp Inlet_Type=Pressure Total_Pressure=AmbientPressure
  EMLoss1: EM Loss Objects=[Body1, Body1_1..Body1_5, Ns8, Ns4, Ns1, Ns5, Ns7, Ns3, Ns2, Ns6, Np8, Np4, Np1, Np5, Np7, Np3, Np2, Np6] LinkID=873 Project="This Project*" Product=ElectronicsDesktop Design=Edgewise_100kW Params{freq_hz=28500Hz} ForceSourceToSolve PreservePartnerSoln PathRelativeTo=TargetProject Intrinsics(28.5kHz) LossMultiplier=1
  StationaryWall1: Stationary Wall Faces=Box1.face(at (89, 100.345, -5)) Thickness=0mm Solid_Material=Al-Extruded External_Condition=Temperature Heat_Flux=0irrad_W_per_m2 Temperature=20cel Heat_Transfer_Coefficient=0w_per_m2kel Reference_Temperature=AmbientTemp Heat_Transfer_Data{Heat_Transfer_Convection_Type="Forced Convection"} External_Material=Steel-oxidised-surface External_Radiation_Reference_Temperature=AmbientTemp External_Radiation_View_Factor=1
mesh:
  MeshRegions:  Global{MeshMethod=MesherHD ComputeGap MeshRegionResolution=5 MinGapX=1mm MinGapY=1mm MinGapZ=1mm Objects=Region FacetLevel=5 ProximitySizeFunction CurvatureSizeFunction OptimizePCBMesh} MeshRegion1{disabled MeshMethod=MesherHD UserSpecifiedSettings MaxElementSizeX=0.3mm MaxElementSizeY=0.3mm MaxElementSizeZ=0.3mm MinElementsInGap=3 MinElementsOnEdge=2 MaxSizeRatio=2 EnableMLM EnforeMLMType=3D MaxLevels=0 BufferLayers=0 UniformMeshParametersType=Average 2DMLMType=2DMLM_None MinGapX=1mm MinGapY=1mm MinGapZ=1mm Objects=Box3 ProximitySizeFunction CurvatureSizeFunction OptimizePCBMesh} MeshRegion2{disabled MeshMethod=MesherHD UserSpecifiedSettings MaxElementSizeX=0.3mm MaxElementSizeY=0.3mm MaxElementSizeZ=0.3mm MinElementsInGap=3 MinElementsOnEdge=2 MaxSizeRatio=2 EnableMLM EnforeMLMType=3D MaxLevels=0 BufferLayers=0 UniformMeshParametersType=Average 2DMLMType=2DMLM_None MinGapX=1mm MinGapY=1mm MinGapZ=1mm Objects=Box4 ProximitySizeFunction CurvatureSizeFunction OptimizePCBMesh} MeshRegion3{disabled MeshMethod=MesherHD MeshRegionResolution=5 MinGapX=1mm MinGapY=1mm MinGapZ=1mm Objects=Box6 ProximitySizeFunction CurvatureSizeFunction OptimizePCBMesh} MeshRegion4{disabled MeshMethod=MesherHD MeshRegionResolution=5 MinGapX=1mm MinGapY=1mm MinGapZ=1mm Objects=Box7 ProximitySizeFunction CurvatureSizeFunction OptimizePCBMesh} MeshRegion5{disabled MeshMethod=MesherHD MeshRegionResolution=5 MinGapX=1mm MinGapY=1mm MinGapZ=1mm Objects=Box8 ProximitySizeFunction CurvatureSizeFunction OptimizePCBMesh} MeshRegion6{MeshMethod=MesherHD MeshRegionResolution=4 MinGapX=1mm MinGapY=1mm MinGapZ=1mm Objects=Box9 ProximitySizeFunction CurvatureSizeFunction OptimizePCBMesh} MeshRegion7{MeshMethod=MesherHD MeshRegionResolution=4 MinGapX=1mm MinGapY=1mm MinGapZ=1mm Objects=Box10 ProximitySizeFunction CurvatureSizeFunction OptimizePCBMesh} MeshRegion8{MeshMethod=MesherHD MeshRegionResolution=4 MinGapX=1mm MinGapY=1mm MinGapZ=1mm Objects=Box11 ProximitySizeFunction CurvatureSizeFunction OptimizePCBMesh} MeshRegion9{MeshMethod=MesherHD MeshRegionResolution=4 MinGapX=1mm MinGapY=1mm MinGapZ=1mm Objects=Box12 ProximitySizeFunction CurvatureSizeFunction OptimizePCBMesh} MeshRegion10{MeshMethod=MesherHD MeshRegionResolution=4 MinGapX=1mm MinGapY=1mm MinGapZ=1mm Objects=Box13 ProximitySizeFunction CurvatureSizeFunction OptimizePCBMesh} MeshRegion11{MeshMethod=MesherHD MeshRegionResolution=4 MinGapX=1mm MinGapY=1mm MinGapZ=1mm Objects=Box14 ProximitySizeFunction CurvatureSizeFunction OptimizePCBMesh} MeshRegion12{MeshMethod=MesherHD MeshRegionResolution=4 MinGapX=1mm MinGapY=1mm MinGapZ=1mm Objects=Box15 ProximitySizeFunction CurvatureSizeFunction OptimizePCBMesh} MeshRegion13{MeshMethod=MesherHD MeshRegionResolution=4 MinGapX=1mm MinGapY=1mm MinGapZ=1mm Objects=Box16 ProximitySizeFunction CurvatureSizeFunction OptimizePCBMesh} MeshRegion14{MeshMethod=MesherHD MeshRegionResolution=4 MinGapX=1mm MinGapY=1mm MinGapZ=1mm Objects=Box17 ProximitySizeFunction CurvatureSizeFunction OptimizePCBMesh} MeshRegion15{MeshMethod=MesherHD MeshRegionResolution=4 MinGapX=1mm MinGapY=1mm MinGapZ=1mm Objects=Box18 ProximitySizeFunction CurvatureSizeFunction OptimizePCBMesh} MeshRegion16{MeshMethod=MesherHD MeshRegionResolution=4 MinGapX=1mm MinGapY=1mm MinGapZ=1mm Objects=Box19 ProximitySizeFunction CurvatureSizeFunction OptimizePCBMesh} MeshRegion17{MeshMethod=MesherHD MeshRegionResolution=4 MinGapX=1mm MinGapY=1mm MinGapZ=1mm Objects=Box20 ProximitySizeFunction CurvatureSizeFunction OptimizePCBMesh} MeshRegion18{MeshMethod=MesherHD MeshRegionResolution=4 MinGapX=1mm MinGapY=1mm MinGapZ=1mm Objects=Box21 ProximitySizeFunction CurvatureSizeFunction OptimizePCBMesh} MeshRegion19{MeshMethod=MesherHD MeshRegionResolution=4 MinGapX=1mm MinGapY=1mm MinGapZ=1mm Objects=Box22 ProximitySizeFunction CurvatureSizeFunction OptimizePCBMesh} MeshRegion20{MeshMethod=MesherHD MeshRegionResolution=4 MinGapX=1mm MinGapY=1mm MinGapZ=1mm Objects=Box23 ProximitySizeFunction CurvatureSizeFunction OptimizePCBMesh} MeshRegion21{MeshMethod=MesherHD MeshRegionResolution=4 MinGapX=1mm MinGapY=1mm MinGapZ=1mm Objects=Box24 ProximitySizeFunction CurvatureSizeFunction OptimizePCBMesh} MeshRegion22{MeshMethod=MesherHD MeshRegionResolution=4 MinGapX=1mm MinGapY=1mm MinGapZ=1mm Objects=Box25 ProximitySizeFunction CurvatureSizeFunction OptimizePCBMesh} MeshRegion23{MeshMethod=MesherHD MeshRegionResolution=4 MinGapX=1mm MinGapY=1mm MinGapZ=1mm Objects=Box26 ProximitySizeFunction CurvatureSizeFunction OptimizePCBMesh} MeshRegion24{disabled MeshMethod=MesherHD MeshRegionResolution=4 MinGapX=1mm MinGapY=1mm MinGapZ=1mm Objects=Box27 ProximitySizeFunction CurvatureSizeFunction OptimizePCBMesh}
  MeshOperations:
setups:
  Setup1: IcepakSteadyState Flow_Regime=Laminar Include_Temperature=true Include_Flow=true Include_Gravity Solution_Initialization_-_Z_Velocity=0.000980665m_per_sec Convergence_Criteria_-_Flow=0.001 Convergence_Criteria_-_Energy=1e-07 Convergence_Criteria_-_Discrete_Ordinates=1e-06 Radiation_Model="Discrete Ordinates Model" Flow_Iteration_Per_Radiation_Iteration=10 ThetaDivision=2 PhiDivision=2 ThetaPixels=2 PhiPixels=2 Under-relaxation_-_Pressure=0.7 Under-relaxation_-_Momentum=0.3 Under-relaxation_-_Temperature=1 Discretization_Scheme_-_Pressure=Standard Discretization_Scheme_-_Momentum=First Discretization_Scheme_-_Temperature=First Discretization_Scheme_-_Discrete_Ordinates=First Convergence_Criteria_-_Max_Iterations=650
field plots:
  Temperature1: Temperature on Setup1 : SteadyState
  Temperature2: Temperature over a plane on Setup1 : SteadyState

design [Thermal]Flatwise_100kW=520 (Icepak, SteadyState TemperatureAndFlow, model units mm)
options: Default_Fluid_Material=air Default_Solid_Material=Al-Extruded Default_Surface_Material=Steel-oxidised-surface AmbientTemperature=25cel AmbientPressure=0n_per_meter_sq AmbientRadiationTemperature=25cel Gravity_Vector_CS_ID=Global Gravity_Vector_Axis=Z Positive=false SherlockExportDirectory=C:/Users/karlr/Documents/Ansoft/1kW_Final.aedtexport/[Thermal]8turns_3D_CoreLoss_FullInterleaved_Flatwise/ Altitude=0meter
geometry:
  Region [air] = region(percentage_offset=1000 on all sides)
  Body1, Body1_1 [aluminum_real] = imported_body(D:\Karl_HighPower\flatwise_100kW.step)
  Body1_2 [ferrite - real2] = imported_body(D:\Karl_HighPower\flatwise_100kW.step)
  Body1_3, Body1_4 [aluminum_real] = imported_body(D:\Karl_HighPower\flatwise_100kW.step)
  Body1_5 [ferrite - real2] = imported_body(D:\Karl_HighPower\flatwise_100kW.step)
  plate_1, plate_2 [silicon_TIMreal] = imported_body(D:\Karl_HighPower\flatwise_100kW.step)
  Box3 [silicon - Copy] = box(corner=(127.6mm, 239.49mm, 0mm), size=(-127.6mm, -278.29mm, -5mm))
  Rectangle1 [Al-Extruded, non-model] = rectangle(corner=(0mm, 100.345mm, -5mm), z_size=94mm, x_size=127.6mm)
  Box4 [non-model] = box(corner=(12.5mm, -38.8mm, 12.5mm), size=(102.6mm, 278.29mm, 64mm))
  Np1..Np8, Ns1..Ns8 [coppe_real] = imported_body()
  Box5 [non-model] = box(corner=(12.5mm, -38.8mm, 12.5mm), size=(102.6mm, 278.29mm, 64mm))
  group flatwise_100kW = Body1, Body1_1..Body1_5, plate_1, plate_2, Ns1, Ns7, Ns4, Ns8, Ns2, Ns6, Ns5, Ns3, Np1, Np7, Np4, Np8, Np2, Np6, Np5, Np3
boundaries and excitations:
  Opening1: Opening Faces=Region.face(-y) Temperature=AmbientTemp External_Rad._Temperature=AmbientRadTemp Inlet_Type=Velocity Static_Pressure=AmbientPressure X_Velocity=0m_per_sec Y_Velocity=0m_per_sec Z_Velocity=0m_per_sec
  Opening2: Opening Faces=Region.face(+y) Temperature=AmbientTemp External_Rad._Temperature=AmbientRadTemp Inlet_Type=Pressure Total_Pressure=AmbientPressure
  EMLoss1: EM Loss Objects=[Body1, Body1_1..Body1_5, Ns1, Ns7, Ns4, Ns8, Ns2, Ns6, Ns5, Ns3, Np1, Np7, Np4, Np8, Np2, Np6, Np5, Np3] LinkID=899 Project="This Project*" Product=ElectronicsDesktop Design=Flatwise_100kW Params{freq_hz=28500Hz} ForceSourceToSolve PreservePartnerSoln PathRelativeTo=TargetProject Intrinsics(28.5kHz) LossMultiplier=1
  StationaryWall1: Stationary Wall Faces=Box3.face(-z) Thickness=0mm Solid_Material=Al-Extruded External_Condition=Temperature Heat_Flux=0irrad_W_per_m2 Temperature=20cel Heat_Transfer_Coefficient=0w_per_m2kel Reference_Temperature=AmbientTemp Heat_Transfer_Data{Heat_Transfer_Convection_Type="Forced Convection"} External_Material=Steel-oxidised-surface External_Radiation_Reference_Temperature=AmbientTemp External_Radiation_View_Factor=1
mesh:
  MeshRegions:  Global{MeshMethod=MesherHD ComputeGap MeshRegionResolution=5 MinGapX=1mm MinGapY=1mm MinGapZ=1mm Objects=Region FacetLevel=5 ProximitySizeFunction CurvatureSizeFunction OptimizePCBMesh} MeshRegion1{MeshMethod=MesherHD MeshRegionResolution=4 MinGapX=1mm MinGapY=1mm MinGapZ=1mm Objects=Box5 ProximitySizeFunction CurvatureSizeFunction OptimizePCBMesh}
  MeshOperations:
setups:
  Setup1: IcepakSteadyState Flow_Regime=Laminar Include_Temperature=true Include_Flow=true Include_Gravity Solution_Initialization_-_Z_Velocity=0.000980665m_per_sec Convergence_Criteria_-_Flow=0.001 Convergence_Criteria_-_Energy=1e-07 Convergence_Criteria_-_Discrete_Ordinates=1e-06 Radiation_Model="Discrete Ordinates Model" Flow_Iteration_Per_Radiation_Iteration=10 ThetaDivision=2 PhiDivision=2 ThetaPixels=2 PhiPixels=2 Under-relaxation_-_Pressure=0.7 Under-relaxation_-_Momentum=0.3 Under-relaxation_-_Temperature=1 Discretization_Scheme_-_Pressure=Standard Discretization_Scheme_-_Momentum=First Discretization_Scheme_-_Temperature=First Discretization_Scheme_-_Discrete_Ordinates=First Convergence_Criteria_-_Max_Iterations=520
field plots:
  Temperature1: Temperature over Body1, Body1_1..Body1_5, plate_1, plate_2, Ns1, Ns7, Ns4, Ns8, Ns2, Ns6, Ns5, Ns3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 on Setup1 : SteadyState
  Temperature2: Temperature over a plane on Setup1 : SteadyState
  Temperature3: Temperature over Ns8 on Setup1 : SteadyState

design [Thermal]Flatwise_100kW_conv (Icepak, SteadyState TemperatureAndFlow, model units mm)
options: Default_Fluid_Material=air Default_Solid_Material=Al-Extruded Default_Surface_Material=Steel-oxidised-surface AmbientTemperature=25cel AmbientPressure=0n_per_meter_sq AmbientRadiationTemperature=25cel Gravity_Vector_CS_ID=Global Gravity_Vector_Axis=Z Positive=false SherlockExportDirectory=C:/Users/karlr/Documents/Ansoft/1kW_Final.aedtexport/[Thermal]8turns_3D_CoreLoss_FullInterleaved_Flatwise/ Altitude=0meter
geometry:
  Region [air] = region(percentage_offset=1000 on all sides)
  Body1, Body1_1 [aluminum_real] = imported_body(D:\Karl_HighPower\flatwise_100kW.step)
  Body1_2 [ferrite - real2] = imported_body(D:\Karl_HighPower\flatwise_100kW.step)
  Body1_3, Body1_4 [aluminum_real] = imported_body(D:\Karl_HighPower\flatwise_100kW.step)
  Body1_5 [ferrite - real2] = imported_body(D:\Karl_HighPower\flatwise_100kW.step)
  plate_1, plate_2 [silicon_TIMreal] = imported_body(D:\Karl_HighPower\flatwise_100kW.step)
  Ns1 [coppe_real] = imported_body(D:\Karl_HighPower\flatwise_100kW.step)
  Ns7 [coppe_real] = imported_body(D:\Karl_HighPower\flatwise_100kW.step)
  Ns4 [coppe_real] = imported_body(D:\Karl_HighPower\flatwise_100kW.step)
  Ns8 [coppe_real] = imported_body(D:\Karl_HighPower\flatwise_100kW.step)
  Ns2 [coppe_real] = imported_body(D:\Karl_HighPower\flatwise_100kW.step)
  Ns6 [coppe_real] = imported_body(D:\Karl_HighPower\flatwise_100kW.step)
  Ns5 [coppe_real] = imported_body(D:\Karl_HighPower\flatwise_100kW.step)
  Ns3 [coppe_real] = imported_body(D:\Karl_HighPower\flatwise_100kW.step)
  Np1 [coppe_real] = imported_body(D:\Karl_HighPower\flatwise_100kW.step)
  Np7 [coppe_real] = imported_body(D:\Karl_HighPower\flatwise_100kW.step)
  Np4 [coppe_real] = imported_body(D:\Karl_HighPower\flatwise_100kW.step)
  Np8 [coppe_real] = imported_body(D:\Karl_HighPower\flatwise_100kW.step)
  Np2 [coppe_real] = imported_body(D:\Karl_HighPower\flatwise_100kW.step)
  Np6 [coppe_real] = imported_body(D:\Karl_HighPower\flatwise_100kW.step)
  Np5 [coppe_real] = imported_body(D:\Karl_HighPower\flatwise_100kW.step)
  Np3 [coppe_real] = imported_body(D:\Karl_HighPower\flatwise_100kW.step)
  Box3 [silicon - Copy] = box(corner=(127.6mm, 239.49mm, 0mm), size=(-127.6mm, -278.29mm, -5mm))
  Box4 [non-model] = box(corner=(14.5mm, -36.8mm, 14.5mm), size=(98.6mm, 274.29mm, 60mm))
  group flatwise_100kW = Body1, Body1_1..Body1_5, plate_1, plate_2, Ns1, Ns7, Ns4, Ns8, Ns2, Ns6, Ns5, Ns3, Np1, Np7, Np4, Np8, Np2, Np6, Np5, Np3
boundaries and excitations:
  Opening1: Opening Faces=Region.face(-y) Temperature=AmbientTemp External_Rad._Temperature=AmbientRadTemp Inlet_Type=Velocity Static_Pressure=AmbientPressure X_Velocity=0m_per_sec Y_Velocity=0m_per_sec Z_Velocity=0m_per_sec
  Opening2: Opening Faces=Region.face(+y) Temperature=AmbientTemp External_Rad._Temperature=AmbientRadTemp Inlet_Type=Pressure Total_Pressure=AmbientPressure
  EMLoss1: EM Loss Objects=[Body1, Body1_1..Body1_5, Ns1, Ns7, Ns4, Ns8, Ns2, Ns6, Ns5, Ns3, Np1, Np7, Np4, Np8, Np2, Np6, Np5, Np3] LinkID=899 Project="This Project*" Product=ElectronicsDesktop Design=Flatwise_100kW Params{freq_hz=28500Hz} ForceSourceToSolve PreservePartnerSoln PathRelativeTo=TargetProject Intrinsics(28.5kHz) LossMultiplier=1
  StationaryWall1: Stationary Wall Faces=Box3.face(-z) Thickness=0mm Solid_Material=Al-Extruded External_Condition="Heat Transfer Coefficient" Heat_Flux=0irrad_W_per_m2 Temperature=20cel Heat_Transfer_Coefficient=5000w_per_m2kel Reference_Temperature=AmbientTemp Heat_Transfer_Data{Heat_Transfer_Convection_Type="Forced Convection"} External_Material=Steel-oxidised-surface External_Radiation_Reference_Temperature=AmbientTemp External_Radiation_View_Factor=1
mesh:
  MeshRegions:  Global{MeshMethod=MesherHD ComputeGap MeshRegionResolution=5 MinGapX=1mm MinGapY=1mm MinGapZ=1mm Objects=Region FacetLevel=5 ProximitySizeFunction CurvatureSizeFunction OptimizePCBMesh} MeshRegion1{MeshMethod=MesherHD MeshRegionResolution=3 MinGapX=1mm MinGapY=1mm MinGapZ=1mm Objects=Box4 ProximitySizeFunction CurvatureSizeFunction OptimizePCBMesh}
  MeshOperations:
setups:
  Setup1: IcepakSteadyState Flow_Regime=Laminar Include_Temperature=true Include_Flow=true Include_Gravity Solution_Initialization_-_Z_Velocity=0.000980665m_per_sec Convergence_Criteria_-_Flow=0.001 Convergence_Criteria_-_Energy=1e-07 Convergence_Criteria_-_Discrete_Ordinates=1e-06 Radiation_Model="Discrete Ordinates Model" Flow_Iteration_Per_Radiation_Iteration=10 ThetaDivision=2 PhiDivision=2 ThetaPixels=2 PhiPixels=2 Under-relaxation_-_Pressure=0.7 Under-relaxation_-_Momentum=0.3 Under-relaxation_-_Temperature=1 Discretization_Scheme_-_Pressure=Standard Discretization_Scheme_-_Momentum=First Discretization_Scheme_-_Temperature=First Discretization_Scheme_-_Discrete_Ordinates=First Convergence_Criteria_-_Max_Iterations=1500

design [Thermal]Edgewise_100kW_conv (Icepak, SteadyState TemperatureAndFlow, model units mm)
options: Default_Fluid_Material=air Default_Solid_Material=Al-Extruded Default_Surface_Material=Steel-oxidised-surface AmbientTemperature=25cel AmbientPressure=0n_per_meter_sq AmbientRadiationTemperature=25cel Gravity_Vector_CS_ID=Global Gravity_Vector_Axis=Z Positive=false SherlockExportDirectory=C:/Users/karlr/Documents/Ansoft/1kW_Final.aedtexport/[Thermal]8turns_3D_CoreLoss_FullInterleaved_Flatwise/ Altitude=0meter
geometry:
  Region [air] = region(percentage_offset=1000 on all sides)
  Body1 [ferrite - real2] = imported_body(D:\Karl_HighPower\core_assembled_edgewise_100kW.step)
  Body1_1, Body1_2 [aluminum_real] = imported_body(D:\Karl_HighPower\core_assembled_edgewise_100kW.step)
  Body1_3 [ferrite - real2] = imported_body(D:\Karl_HighPower\core_assembled_edgewise_100kW.step)
  Body1_4, Body1_5 [aluminum_real] = imported_body(D:\Karl_HighPower\core_assembled_edgewise_100kW.step)
  plate1, plate2 [silicon_TIMreal] = imported_body(D:\Karl_HighPower\core_assembled_edgewise_100kW.step)
  Ns8, Ns4, Ns1, Ns5, Ns7, Ns3, Ns2, Ns6, Np8, Np4, Np1, Np5, Np7, Np3, Np2, Np6 [coppe_real] = imported_body(D:\Karl_HighPower\core_assembled_edgewise_100kW.step)
  Box1 [silicon - Copy] = imported_body()
  Box3, Box4, Box5 [non-model] = imported_body()
  Rectangle1 [Al-Extruded, non-model] = rectangle(corner=(178mm, 100.345mm, 63.8mm), z_size=-68.8mm, x_size=-178mm)
  group core_assembled_edgewise_100kW = Body1, Body1_1..Body1_5, plate1, plate2, Ns8, Ns4, Ns1, Ns5, Ns7, Ns3, Ns2, Ns6, Np8, Np4, Np1, Np5, Np7, Np3, Np2, Np6
boundaries and excitations:
  Opening1: Opening Faces=Region.face(-y) Temperature=AmbientTemp External_Rad._Temperature=AmbientRadTemp Inlet_Type=Velocity Static_Pressure=AmbientPressure X_Velocity=0m_per_sec Y_Velocity=0m_per_sec Z_Velocity=0m_per_sec
  Opening2: Opening Faces=Region.face(+y) Temperature=AmbientTemp External_Rad._Temperature=AmbientRadTemp Inlet_Type=Pressure Total_Pressure=AmbientPressure
  EMLoss1: EM Loss Objects=[Body1, Body1_1..Body1_5, Ns8, Ns4, Ns1, Ns5, Ns7, Ns3, Ns2, Ns6, Np8, Np4, Np1, Np5, Np7, Np3, Np2, Np6] LinkID=873 Project="This Project*" Product=ElectronicsDesktop Design=Edgewise_100kW Params{freq_hz=28500Hz} ForceSourceToSolve PreservePartnerSoln PathRelativeTo=TargetProject Intrinsics(28.5kHz) LossMultiplier=1
  StationaryWall1: Stationary Wall Faces=Box1.face(at (89, 100.345, -5)) Thickness=0mm Solid_Material=Al-Extruded External_Condition="Heat Transfer Coefficient" Heat_Flux=0irrad_W_per_m2 Temperature=20cel Heat_Transfer_Coefficient=5000w_per_m2kel Reference_Temperature=AmbientTemp Heat_Transfer_Data{Heat_Transfer_Convection_Type="Forced Convection"} External_Material=Steel-oxidised-surface External_Radiation_Reference_Temperature=AmbientTemp External_Radiation_View_Factor=1
mesh:
  MeshRegions:  Global{MeshMethod=MesherHD ComputeGap MeshRegionResolution=5 MinGapX=1mm MinGapY=1mm MinGapZ=1mm Objects=Region FacetLevel=5 ProximitySizeFunction CurvatureSizeFunction OptimizePCBMesh} MeshRegion1{disabled MeshMethod=MesherHD UserSpecifiedSettings MaxElementSizeX=2mm MaxElementSizeY=5mm MaxElementSizeZ=0.06667mm MinElementsInGap=3 MinElementsOnEdge=2 MaxSizeRatio=2 EnableMLM EnforeMLMType=3D MaxLevels=0 BufferLayers=0 UniformMeshParametersType=Average 2DMLMType=2DMLM_None MinGapX=1mm MinGapY=1mm MinGapZ=1mm Objects=Box3 ProximitySizeFunction CurvatureSizeFunction OptimizePCBMesh} MeshRegion2{disabled MeshMethod=MesherHD UserSpecifiedSettings MaxElementSizeX=2mm MaxElementSizeY=5mm MaxElementSizeZ=0.06667mm MinElementsInGap=3 MinElementsOnEdge=2 MaxSizeRatio=2 EnableMLM EnforeMLMType=3D MaxLevels=0 BufferLayers=0 UniformMeshParametersType=Average 2DMLMType=2DMLM_None MinGapX=1mm MinGapY=1mm MinGapZ=1mm Objects=Box4 ProximitySizeFunction CurvatureSizeFunction OptimizePCBMesh} MeshRegion3{disabled MeshMethod=MesherHD MeshRegionResolution=5 MinGapX=1mm MinGapY=1mm MinGapZ=1mm Objects=Box5 ProximitySizeFunction CurvatureSizeFunction OptimizePCBMesh}
  MeshOperations:
setups:
  Setup1: IcepakSteadyState Flow_Regime=Laminar Include_Temperature=true Include_Flow=true Include_Gravity Solution_Initialization_-_Z_Velocity=0.000980665m_per_sec Convergence_Criteria_-_Flow=0.001 Convergence_Criteria_-_Energy=1e-07 Convergence_Criteria_-_Discrete_Ordinates=1e-06 Radiation_Model="Discrete Ordinates Model" Flow_Iteration_Per_Radiation_Iteration=10 ThetaDivision=2 PhiDivision=2 ThetaPixels=2 PhiPixels=2 Under-relaxation_-_Pressure=0.7 Under-relaxation_-_Momentum=0.3 Under-relaxation_-_Temperature=1 Discretization_Scheme_-_Pressure=Standard Discretization_Scheme_-_Momentum=First Discretization_Scheme_-_Temperature=First Discretization_Scheme_-_Discrete_Ordinates=First Convergence_Criteria_-_Max_Iterations=1500
field plots:
  Temperature1: Temperature on Setup1 : SteadyState
  Temperature2: Temperature over a plane on Setup1 : SteadyState

design [Thermal]Flatwise_100kW=latest1 (Icepak, SteadyState TemperatureAndFlow, model units mm)
options: Default_Fluid_Material=air Default_Solid_Material=Al-Extruded Default_Surface_Material=Steel-oxidised-surface AmbientTemperature=25cel AmbientPressure=0n_per_meter_sq AmbientRadiationTemperature=25cel Gravity_Vector_CS_ID=Global Gravity_Vector_Axis=Z Positive=false SherlockExportDirectory=C:/Users/karlr/Documents/Ansoft/1kW_Final.aedtexport/[Thermal]8turns_3D_CoreLoss_FullInterleaved_Flatwise/ Altitude=0meter
geometry:
  Region [air] = region(percentage_offset=1000 on all sides)
  Body1, Body1_1 [aluminum_real] = imported_body(D:\Karl_HighPower\flatwise_100kW.step)
  Body1_2 [ferrite - real2] = imported_body(D:\Karl_HighPower\flatwise_100kW.step)
  Body1_3, Body1_4 [aluminum_real] = imported_body(D:\Karl_HighPower\flatwise_100kW.step)
  Body1_5 [ferrite - real2] = imported_body(D:\Karl_HighPower\flatwise_100kW.step)
  plate_1, plate_2 [silicon_TIMreal] = imported_body(D:\Karl_HighPower\flatwise_100kW.step)
  Box3 [silicon - Copy] = box(corner=(127.6mm, 239.49mm, 0mm), size=(-127.6mm, -278.29mm, -5mm))
  Rectangle1 [Al-Extruded, non-model] = rectangle(corner=(0mm, 100.345mm, -5mm), z_size=94mm, x_size=127.6mm)
  Box4 [non-model] = box(corner=(12.5mm, -38.8mm, 12.5mm), size=(102.6mm, 278.29mm, 64mm))
  Np1..Np8, Ns1..Ns8 [coppe_real] = imported_body()
  Box5 [non-model] = box(corner=(12.5mm, -38.8mm, 12.5mm), size=(102.6mm, 278.29mm, 64mm))
  group flatwise_100kW = Body1, Body1_1..Body1_5, plate_1, plate_2, Ns1, Ns7, Ns4, Ns8, Ns2, Ns6, Ns5, Ns3, Np1, Np7, Np4, Np8, Np2, Np6, Np5, Np3
boundaries and excitations:
  Opening1: Opening Faces=Region.face(-y) Temperature=AmbientTemp External_Rad._Temperature=AmbientRadTemp Inlet_Type=Velocity Static_Pressure=AmbientPressure X_Velocity=0m_per_sec Y_Velocity=0m_per_sec Z_Velocity=0m_per_sec
  Opening2: Opening Faces=Region.face(+y) Temperature=AmbientTemp External_Rad._Temperature=AmbientRadTemp Inlet_Type=Pressure Total_Pressure=AmbientPressure
  EMLoss1: EM Loss Objects=[Body1, Body1_1..Body1_5, Ns1, Ns7, Ns4, Ns8, Ns2, Ns6, Ns5, Ns3, Np1, Np7, Np4, Np8, Np2, Np6, Np5, Np3] LinkID=899 Project="This Project*" Product=ElectronicsDesktop Design=Flatwise_100kW Params{freq_hz=28500Hz} ForceSourceToSolve PreservePartnerSoln PathRelativeTo=TargetProject Intrinsics(28.5kHz) LossMultiplier=1
  StationaryWall1: Stationary Wall Faces=Box3.face(-z) Thickness=0mm Solid_Material=Al-Extruded External_Condition=Temperature Heat_Flux=0irrad_W_per_m2 Temperature=20cel Heat_Transfer_Coefficient=0w_per_m2kel Reference_Temperature=AmbientTemp Heat_Transfer_Data{Heat_Transfer_Convection_Type="Forced Convection"} External_Material=Steel-oxidised-surface External_Radiation_Reference_Temperature=AmbientTemp External_Radiation_View_Factor=1
mesh:
  MeshRegions:  Global{MeshMethod=MesherHD ComputeGap MeshRegionResolution=5 MinGapX=1mm MinGapY=1mm MinGapZ=1mm Objects=Region FacetLevel=5 ProximitySizeFunction CurvatureSizeFunction OptimizePCBMesh} MeshRegion1{MeshMethod=MesherHD UserSpecifiedSettings MaxElementSizeX=0.3mm MaxElementSizeY=0.3mm MaxElementSizeZ=1mm MinElementsInGap=3 MinElementsOnEdge=2 MaxSizeRatio=2 EnableMLM EnforeMLMType=3D MaxLevels=0 BufferLayers=0 UniformMeshParametersType=Average 2DMLMType=2DMLM_None MinGapX=0.3mm MinGapY=0.3mm MinGapZ=0.3mm Objects=Box5 ProximitySizeFunction CurvatureSizeFunction OptimizePCBMesh}
  MeshOperations:
setups:
  Setup1: IcepakSteadyState Flow_Regime=Laminar Include_Temperature=true Include_Flow=true Include_Gravity Solution_Initialization_-_Z_Velocity=0.000980665m_per_sec Convergence_Criteria_-_Flow=0.001 Convergence_Criteria_-_Energy=1e-07 Convergence_Criteria_-_Discrete_Ordinates=1e-06 Radiation_Model="Discrete Ordinates Model" Flow_Iteration_Per_Radiation_Iteration=10 ThetaDivision=2 PhiDivision=2 ThetaPixels=2 PhiPixels=2 Under-relaxation_-_Pressure=0.7 Under-relaxation_-_Momentum=0.3 Under-relaxation_-_Temperature=1 Discretization_Scheme_-_Pressure=Standard Discretization_Scheme_-_Momentum=First Discretization_Scheme_-_Temperature=First Discretization_Scheme_-_Discrete_Ordinates=First Convergence_Criteria_-_Max_Iterations=800
field plots:
  Temperature1: Temperature over Body1, Body1_1..Body1_5, plate_1, plate_2, Ns1, Ns7, Ns4, Ns8, Ns2, Ns6, Ns5, Ns3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 on Setup1 : SteadyState
  Temperature2: Temperature over a plane on Setup1 : SteadyState

design [Thermal]Edgewise_100kW_Latest (Icepak, SteadyState TemperatureAndFlow, model units mm)
options: Default_Fluid_Material=air Default_Solid_Material=Al-Extruded Default_Surface_Material=Steel-oxidised-surface AmbientTemperature=25cel AmbientPressure=0n_per_meter_sq AmbientRadiationTemperature=25cel Gravity_Vector_CS_ID=Global Gravity_Vector_Axis=Z Positive=false SherlockExportDirectory=C:/Users/karlr/Documents/Ansoft/1kW_Final.aedtexport/[Thermal]8turns_3D_CoreLoss_FullInterleaved_Flatwise/ Altitude=0meter
geometry:
  Region [air] = region(percentage_offset=1000 on all sides)
  Body1 [ferrite - real2] = imported_body(D:\Karl_HighPower\core_assembled_edgewise_100kW.step)
  Body1_1, Body1_2 [aluminum_real] = imported_body(D:\Karl_HighPower\core_assembled_edgewise_100kW.step)
  Body1_3 [ferrite - real2] = imported_body(D:\Karl_HighPower\core_assembled_edgewise_100kW.step)
  Body1_4, Body1_5 [aluminum_real] = imported_body(D:\Karl_HighPower\core_assembled_edgewise_100kW.step)
  plate1, plate2 [silicon_TIMreal] = imported_body(D:\Karl_HighPower\core_assembled_edgewise_100kW.step)
  Ns8, Ns4, Ns1, Ns5, Ns7, Ns3, Ns2, Ns6, Np8, Np4, Np1, Np5, Np7, Np3, Np2, Np6 [coppe_real] = imported_body(D:\Karl_HighPower\core_assembled_edgewise_100kW.step)
  Box1 [silicon - Copy] = imported_body()
  Rectangle1 [Al-Extruded, non-model] = rectangle(corner=(178mm, 100.345mm, 63.8mm), z_size=-68.8mm, x_size=-178mm)
  Box2 [non-model] = box(corner=(-7.327472e-12mm, -64mm, -5mm), size=(178mm, 328.69mm, 68.8mm))
  group core_assembled_edgewise_100kW = Body1, Body1_1..Body1_5, plate1, plate2, Ns8, Ns4, Ns1, Ns5, Ns7, Ns3, Ns2, Ns6, Np8, Np4, Np1, Np5, Np7, Np3, Np2, Np6
boundaries and excitations:
  Opening1: Opening Faces=Region.face(-y) Temperature=AmbientTemp External_Rad._Temperature=AmbientRadTemp Inlet_Type=Velocity Static_Pressure=AmbientPressure X_Velocity=0m_per_sec Y_Velocity=0m_per_sec Z_Velocity=0m_per_sec
  Opening2: Opening Faces=Region.face(+y) Temperature=AmbientTemp External_Rad._Temperature=AmbientRadTemp Inlet_Type=Pressure Total_Pressure=AmbientPressure
  EMLoss1: EM Loss Objects=[Body1, Body1_1..Body1_5, Ns8, Ns4, Ns1, Ns5, Ns7, Ns3, Ns2, Ns6, Np8, Np4, Np1, Np5, Np7, Np3, Np2, Np6] LinkID=873 Project="This Project*" Product=ElectronicsDesktop Design=Edgewise_100kW Params{freq_hz=28500Hz} ForceSourceToSolve PreservePartnerSoln PathRelativeTo=TargetProject Intrinsics(28.5kHz) LossMultiplier=1
  StationaryWall1: Stationary Wall Faces=Box1.face(at (89, 100.345, -5)) Thickness=0mm Solid_Material=Al-Extruded External_Condition=Temperature Heat_Flux=0irrad_W_per_m2 Temperature=20cel Heat_Transfer_Coefficient=0w_per_m2kel Reference_Temperature=AmbientTemp Heat_Transfer_Data{Heat_Transfer_Convection_Type="Forced Convection"} External_Material=Steel-oxidised-surface External_Radiation_Reference_Temperature=AmbientTemp External_Radiation_View_Factor=1
mesh:
  MeshRegions:  Global{MeshMethod=MesherHD ComputeGap MeshRegionResolution=3 MinGapX=1mm MinGapY=1mm MinGapZ=1mm Objects=Region FacetLevel=5 ProximitySizeFunction CurvatureSizeFunction OptimizePCBMesh} MeshRegion1{MeshMethod=MesherHD UserSpecifiedSettings MaxElementSizeX=1mm MaxElementSizeY=1mm MaxElementSizeZ=0.3mm MinElementsInGap=3 MinElementsOnEdge=2 MaxSizeRatio=2 EnableMLM EnforeMLMType=3D MaxLevels=0 BufferLayers=0 UniformMeshParametersType=Average 2DMLMType=2DMLM_None MinGapX=0.3mm MinGapY=0.3mm MinGapZ=0.3mm Objects=Box2 ProximitySizeFunction CurvatureSizeFunction OptimizePCBMesh}
  MeshOperations:
setups:
  Setup1: IcepakSteadyState Flow_Regime=Laminar Include_Temperature=true Include_Flow=true Include_Gravity Solution_Initialization_-_Z_Velocity=0.000980665m_per_sec Convergence_Criteria_-_Flow=0.001 Convergence_Criteria_-_Energy=1e-07 Convergence_Criteria_-_Discrete_Ordinates=1e-06 Radiation_Model="Discrete Ordinates Model" Flow_Iteration_Per_Radiation_Iteration=10 ThetaDivision=2 PhiDivision=2 ThetaPixels=2 PhiPixels=2 Under-relaxation_-_Pressure=0.7 Under-relaxation_-_Momentum=0.3 Under-relaxation_-_Temperature=1 Discretization_Scheme_-_Pressure=Standard Discretization_Scheme_-_Momentum=First Discretization_Scheme_-_Temperature=First Discretization_Scheme_-_Discrete_Ordinates=First Convergence_Criteria_-_Max_Iterations=650
field plots:
  Temperature1: Temperature over Body1, Body1_1..Body1_5, plate1, plate2, Ns8, Ns4, Ns1, Ns5, Ns7, Ns3, Ns2, Ns6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 on Setup1 : SteadyState
  Temperature2: Temperature over a plane on Setup1 : SteadyState

design [Thermal]Edgewise_100kW_Latest2 (Icepak, SteadyState TemperatureAndFlow, model units mm)
options: Default_Fluid_Material=air Default_Solid_Material=Al-Extruded Default_Surface_Material=Steel-oxidised-surface AmbientTemperature=25cel AmbientPressure=0n_per_meter_sq AmbientRadiationTemperature=25cel Gravity_Vector_CS_ID=Global Gravity_Vector_Axis=Z Positive=false SherlockExportDirectory=C:/Users/karlr/Documents/Ansoft/1kW_Final.aedtexport/[Thermal]8turns_3D_CoreLoss_FullInterleaved_Flatwise/ Altitude=0meter
geometry:
  Region [air] = region(percentage_offset=1000 on all sides)
  Body1 [ferrite - real2] = imported_body(D:\Karl_HighPower\core_assembled_edgewise_100kW.step)
  Body1_1, Body1_2 [aluminum_real] = imported_body(D:\Karl_HighPower\core_assembled_edgewise_100kW.step)
  Body1_3 [ferrite - real2] = imported_body(D:\Karl_HighPower\core_assembled_edgewise_100kW.step)
  Body1_4, Body1_5 [aluminum_real] = imported_body(D:\Karl_HighPower\core_assembled_edgewise_100kW.step)
  plate1, plate2 [silicon_TIMreal] = imported_body(D:\Karl_HighPower\core_assembled_edgewise_100kW.step)
  Ns8, Ns4, Ns1, Ns5, Ns7, Ns3, Ns2, Ns6, Np8, Np4, Np1, Np5, Np7, Np3, Np2, Np6 [coppe_real] = imported_body(D:\Karl_HighPower\core_assembled_edgewise_100kW.step)
  Box1 [silicon - Copy] = imported_body()
  Box3, Box4, Box5 [non-model] = imported_body()
  Rectangle1 [Al-Extruded, non-model] = rectangle(corner=(178mm, 100.345mm, 63.8mm), z_size=-68.8mm, x_size=-178mm)
  Box6 [non-model] = box(corner=(14.5mm, -62mm, 14.5mm), size=(149mm, 324.69mm, 34.8mm))
  Box7 [non-model] = box(corner=(12.5mm, -64mm, 49.3mm), size=(153mm, 328.69mm, 2mm))
  Box8 [non-model] = box(corner=(12.5mm, -64mm, 12.5mm), size=(153mm, 328.69mm, 2mm))
  Box9 [non-model] = box(corner=(14.5mm, -62mm, 14.5mm), size=(149mm, 324.69mm, 0.3mm))
  Box10 [non-model] = box(corner=(14.5mm, -62mm, 19.1mm), size=(149mm, 324.69mm, 0.3mm))
  Box11 [non-model] = box(corner=(14.5mm, -62mm, 23.7mm), size=(149mm, 324.69mm, 0.3mm))
  Box12 [non-model] = box(corner=(14.5mm, -62mm, 28.3mm), size=(149mm, 324.69mm, 0.3mm))
  Box13 [non-model] = box(corner=(14.5mm, -62mm, 32.9mm), size=(149mm, 324.69mm, 0.3mm))
  Box14 [non-model] = box(corner=(14.5mm, -62mm, 37.5mm), size=(149mm, 324.69mm, 0.3mm))
  Box15 [non-model] = box(corner=(14.5mm, -62mm, 42.1mm), size=(149mm, 324.69mm, 0.3mm))
  Box16 [non-model] = box(corner=(14.5mm, -62mm, 46.7mm), size=(149mm, 324.69mm, 0.3mm))
  Box17 [non-model] = box(corner=(14.5mm, -62mm, 16.8mm), size=(149mm, 324.69mm, 0.3mm))
  Box18 [non-model] = box(corner=(14.5mm, -62mm, 21.4mm), size=(149mm, 324.69mm, 0.3mm))
  Box19 [non-model] = box(corner=(14.5mm, -62mm, 26mm), size=(149mm, 324.69mm, 0.3mm))
  Box20 [non-model] = box(corner=(14.5mm, -62mm, 30.6mm), size=(149mm, 324.69mm, 0.3mm))
  Box21 [non-model] = box(corner=(14.5mm, -62mm, 35.2mm), size=(149mm, 324.69mm, 0.3mm))
  Box22 [non-model] = box(corner=(14.5mm, -62mm, 39.8mm), size=(149mm, 324.69mm, 0.3mm))
  Box23 [non-model] = box(corner=(14.5mm, -62mm, 44.4mm), size=(149mm, 324.69mm, 0.3mm))
  Box24 [non-model] = box(corner=(14.5mm, -62mm, 49mm), size=(149mm, 324.69mm, 0.3mm))
  Box25 [non-model] = box(corner=(12.5mm, -64mm, 49.3mm), size=(153mm, 328.69mm, 2mm))
  Box26 [non-model] = box(corner=(12.5mm, -64mm, 12.5mm), size=(153mm, 328.69mm, 2mm))
  Box27 [non-model] = box(corner=(12.5mm, -64mm, 12.5mm), size=(153mm, 328.69mm, 38.8mm))
  group core_assembled_edgewise_100kW = Body1, Body1_1..Body1_5, plate1, plate2, Ns8, Ns4, Ns1, Ns5, Ns7, Ns3, Ns2, Ns6, Np8, Np4, Np1, Np5, Np7, Np3, Np2, Np6
boundaries and excitations:
  Opening1: Opening Faces=Region.face(-y) Temperature=AmbientTemp External_Rad._Temperature=AmbientRadTemp Inlet_Type=Velocity Static_Pressure=AmbientPressure X_Velocity=0m_per_sec Y_Velocity=0m_per_sec Z_Velocity=0m_per_sec
  Opening2: Opening Faces=Region.face(+y) Temperature=AmbientTemp External_Rad._Temperature=AmbientRadTemp Inlet_Type=Pressure Total_Pressure=AmbientPressure
  EMLoss1: EM Loss Objects=[Body1, Body1_1..Body1_5, Ns8, Ns4, Ns1, Ns5, Ns7, Ns3, Ns2, Ns6, Np8, Np4, Np1, Np5, Np7, Np3, Np2, Np6] LinkID=873 Project="This Project*" Product=ElectronicsDesktop Design=Edgewise_100kW Params{freq_hz=28500Hz} ForceSourceToSolve PreservePartnerSoln PathRelativeTo=TargetProject Intrinsics(28.5kHz) LossMultiplier=1
  StationaryWall1: Stationary Wall Faces=Box1.face(at (89, 100.345, -5)) Thickness=0mm Solid_Material=Al-Extruded External_Condition=Temperature Heat_Flux=0irrad_W_per_m2 Temperature=20cel Heat_Transfer_Coefficient=0w_per_m2kel Reference_Temperature=AmbientTemp Heat_Transfer_Data{Heat_Transfer_Convection_Type="Forced Convection"} External_Material=Steel-oxidised-surface External_Radiation_Reference_Temperature=AmbientTemp External_Radiation_View_Factor=1
mesh:
  MeshRegions:  Global{MeshMethod=MesherHD ComputeGap MeshRegionResolution=5 MinGapX=1mm MinGapY=1mm MinGapZ=1mm Objects=Region FacetLevel=5 ProximitySizeFunction CurvatureSizeFunction OptimizePCBMesh} MeshRegion1{MeshMethod=MesherHD UserSpecifiedSettings MaxElementSizeX=0.3mm MaxElementSizeY=0.3mm MaxElementSizeZ=0.3mm MinElementsInGap=3 MinElementsOnEdge=2 MaxSizeRatio=2 EnableMLM EnforeMLMType=3D MaxLevels=0 BufferLayers=0 UniformMeshParametersType=Average 2DMLMType=2DMLM_None MinGapX=0.3mm MinGapY=0.3mm MinGapZ=0.3mm Objects=Box3 ProximitySizeFunction CurvatureSizeFunction OptimizePCBMesh} MeshRegion2{MeshMethod=MesherHD UserSpecifiedSettings MaxElementSizeX=0.3mm MaxElementSizeY=0.3mm MaxElementSizeZ=0.3mm MinElementsInGap=3 MinElementsOnEdge=2 MaxSizeRatio=2 EnableMLM EnforeMLMType=3D MaxLevels=0 BufferLayers=0 UniformMeshParametersType=Average 2DMLMType=2DMLM_None MinGapX=0.3mm MinGapY=0.3mm MinGapZ=0.3mm Objects=Box4 ProximitySizeFunction CurvatureSizeFunction OptimizePCBMesh} MeshRegion3{MeshMethod=MesherHD UserSpecifiedSettings MaxElementSizeX=0.3mm MaxElementSizeY=0.3mm MaxElementSizeZ=0.3mm MinElementsInGap=3 MinElementsOnEdge=2 MaxSizeRatio=2 EnableMLM EnforeMLMType=3D MaxLevels=0 BufferLayers=0 UniformMeshParametersType=Average 2DMLMType=2DMLM_None MinGapX=0.3mm MinGapY=0.3mm MinGapZ=0.3mm Objects=Box6 ProximitySizeFunction CurvatureSizeFunction OptimizePCBMesh}
  MeshOperations:
setups:
  Setup1: IcepakSteadyState Flow_Regime=Laminar Include_Temperature=true Include_Flow=true Include_Gravity Solution_Initialization_-_Z_Velocity=0.000980665m_per_sec Convergence_Criteria_-_Flow=0.001 Convergence_Criteria_-_Energy=1e-07 Convergence_Criteria_-_Discrete_Ordinates=1e-06 Radiation_Model="Discrete Ordinates Model" Flow_Iteration_Per_Radiation_Iteration=10 ThetaDivision=2 PhiDivision=2 ThetaPixels=2 PhiPixels=2 Under-relaxation_-_Pressure=0.7 Under-relaxation_-_Momentum=0.3 Under-relaxation_-_Temperature=1 Discretization_Scheme_-_Pressure=Standard Discretization_Scheme_-_Momentum=First Discretization_Scheme_-_Temperature=First Discretization_Scheme_-_Discrete_Ordinates=First Convergence_Criteria_-_Max_Iterations=650
field plots:
  Temperature1: Temperature on Setup1 : SteadyState
  Temperature2: Temperature over a plane on Setup1 : SteadyState

design [Thermal]Edgewise_100kW_Latest3 (Icepak, SteadyState TemperatureAndFlow, model units mm)
options: Default_Fluid_Material=air Default_Solid_Material=Al-Extruded Default_Surface_Material=Steel-oxidised-surface AmbientTemperature=25cel AmbientPressure=0n_per_meter_sq AmbientRadiationTemperature=25cel Gravity_Vector_CS_ID=Global Gravity_Vector_Axis=Z Positive=false SherlockExportDirectory=C:/Users/karlr/Documents/Ansoft/1kW_Final.aedtexport/[Thermal]8turns_3D_CoreLoss_FullInterleaved_Flatwise/ Altitude=0meter
geometry:
  Region [air] = region(percentage_offset=1000 on all sides)
  Body1 [ferrite - real2] = imported_body(D:\Karl_HighPower\core_assembled_edgewise_100kW.step)
  Body1_1, Body1_2 [aluminum_real] = imported_body(D:\Karl_HighPower\core_assembled_edgewise_100kW.step)
  Body1_3 [ferrite - real2] = imported_body(D:\Karl_HighPower\core_assembled_edgewise_100kW.step)
  Body1_4, Body1_5 [aluminum_real] = imported_body(D:\Karl_HighPower\core_assembled_edgewise_100kW.step)
  plate1, plate2 [silicon_TIMreal] = imported_body(D:\Karl_HighPower\core_assembled_edgewise_100kW.step)
  Ns8, Ns4, Ns1, Ns5, Ns7, Ns3, Ns2, Ns6, Np8, Np4, Np1, Np5, Np7, Np3, Np2, Np6 [coppe_real] = imported_body(D:\Karl_HighPower\core_assembled_edgewise_100kW.step)
  Box1 [silicon - Copy] = imported_body()
  Box3, Box4, Box5 [non-model] = imported_body()
  Rectangle1 [Al-Extruded, non-model] = rectangle(corner=(178mm, 100.345mm, 63.8mm), z_size=-68.8mm, x_size=-178mm)
  Box6 [non-model] = box(corner=(14.5mm, -62mm, 14.5mm), size=(149mm, 324.69mm, 34.8mm))
  Box7 [non-model] = box(corner=(12.5mm, -64mm, 49.3mm), size=(153mm, 328.69mm, 2mm))
  Box8 [non-model] = box(corner=(12.5mm, -64mm, 12.5mm), size=(153mm, 328.69mm, 2mm))
  Box9 [non-model] = box(corner=(14.5mm, -62mm, 14.5mm), size=(149mm, 324.69mm, 0.3mm))
  Box10 [non-model] = box(corner=(14.5mm, -62mm, 19.1mm), size=(149mm, 324.69mm, 0.3mm))
  Box11 [non-model] = box(corner=(14.5mm, -62mm, 23.7mm), size=(149mm, 324.69mm, 0.3mm))
  Box12 [non-model] = box(corner=(14.5mm, -62mm, 28.3mm), size=(149mm, 324.69mm, 0.3mm))
  Box13 [non-model] = box(corner=(14.5mm, -62mm, 32.9mm), size=(149mm, 324.69mm, 0.3mm))
  Box14 [non-model] = box(corner=(14.5mm, -62mm, 37.5mm), size=(149mm, 324.69mm, 0.3mm))
  Box15 [non-model] = box(corner=(14.5mm, -62mm, 42.1mm), size=(149mm, 324.69mm, 0.3mm))
  Box16 [non-model] = box(corner=(14.5mm, -62mm, 46.7mm), size=(149mm, 324.69mm, 0.3mm))
  Box17 [non-model] = box(corner=(14.5mm, -62mm, 16.8mm), size=(149mm, 324.69mm, 0.3mm))
  Box18 [non-model] = box(corner=(14.5mm, -62mm, 21.4mm), size=(149mm, 324.69mm, 0.3mm))
  Box19 [non-model] = box(corner=(14.5mm, -62mm, 26mm), size=(149mm, 324.69mm, 0.3mm))
  Box20 [non-model] = box(corner=(14.5mm, -62mm, 30.6mm), size=(149mm, 324.69mm, 0.3mm))
  Box21 [non-model] = box(corner=(14.5mm, -62mm, 35.2mm), size=(149mm, 324.69mm, 0.3mm))
  Box22 [non-model] = box(corner=(14.5mm, -62mm, 39.8mm), size=(149mm, 324.69mm, 0.3mm))
  Box23 [non-model] = box(corner=(14.5mm, -62mm, 44.4mm), size=(149mm, 324.69mm, 0.3mm))
  Box24 [non-model] = box(corner=(14.5mm, -62mm, 49mm), size=(149mm, 324.69mm, 0.3mm))
  Box25 [non-model] = box(corner=(12.5mm, -64mm, 49.3mm), size=(153mm, 328.69mm, 2mm))
  Box26 [non-model] = box(corner=(12.5mm, -64mm, 12.5mm), size=(153mm, 328.69mm, 2mm))
  Box27 [non-model] = box(corner=(12.5mm, -64mm, 12.5mm), size=(153mm, 328.69mm, 38.8mm))
  group core_assembled_edgewise_100kW = Body1, Body1_1..Body1_5, plate1, plate2, Ns8, Ns4, Ns1, Ns5, Ns7, Ns3, Ns2, Ns6, Np8, Np4, Np1, Np5, Np7, Np3, Np2, Np6
boundaries and excitations:
  Opening1: Opening Faces=Region.face(-y) Temperature=AmbientTemp External_Rad._Temperature=AmbientRadTemp Inlet_Type=Velocity Static_Pressure=AmbientPressure X_Velocity=0m_per_sec Y_Velocity=0m_per_sec Z_Velocity=0m_per_sec
  Opening2: Opening Faces=Region.face(+y) Temperature=AmbientTemp External_Rad._Temperature=AmbientRadTemp Inlet_Type=Pressure Total_Pressure=AmbientPressure
  EMLoss1: EM Loss Objects=[Body1, Body1_1..Body1_5, Ns8, Ns4, Ns1, Ns5, Ns7, Ns3, Ns2, Ns6, Np8, Np4, Np1, Np5, Np7, Np3, Np2, Np6] LinkID=873 Project="This Project*" Product=ElectronicsDesktop Design=Edgewise_100kW Params{freq_hz=28500Hz} ForceSourceToSolve PreservePartnerSoln PathRelativeTo=TargetProject Intrinsics(28.5kHz) LossMultiplier=1
  StationaryWall1: Stationary Wall Faces=Box1.face(at (89, 100.345, -5)) Thickness=0mm Solid_Material=Al-Extruded External_Condition=Temperature Heat_Flux=0irrad_W_per_m2 Temperature=20cel Heat_Transfer_Coefficient=0w_per_m2kel Reference_Temperature=AmbientTemp Heat_Transfer_Data{Heat_Transfer_Convection_Type="Forced Convection"} External_Material=Steel-oxidised-surface External_Radiation_Reference_Temperature=AmbientTemp External_Radiation_View_Factor=1
mesh:
  MeshRegions:  Global{MeshMethod=MesherHD ComputeGap MeshRegionResolution=5 MinGapX=1mm MinGapY=1mm MinGapZ=1mm Objects=Region FacetLevel=5 ProximitySizeFunction CurvatureSizeFunction OptimizePCBMesh} MeshRegion1{MeshMethod=MesherHD MeshRegionResolution=4 MinGapX=0.3mm MinGapY=0.3mm MinGapZ=0.3mm Objects=Box3 ProximitySizeFunction CurvatureSizeFunction OptimizePCBMesh} MeshRegion2{MeshMethod=MesherHD MeshRegionResolution=4 MinGapX=0.3mm MinGapY=0.3mm MinGapZ=0.3mm Objects=Box4 ProximitySizeFunction CurvatureSizeFunction OptimizePCBMesh} MeshRegion3{MeshMethod=MesherHD UserSpecifiedSettings MaxElementSizeX=1mm MaxElementSizeY=1mm MaxElementSizeZ=0.3mm MinElementsInGap=3 MinElementsOnEdge=2 MaxSizeRatio=2 EnableMLM EnforeMLMType=3D MaxLevels=0 BufferLayers=0 UniformMeshParametersType=Average 2DMLMType=2DMLM_None MinGapX=0.3mm MinGapY=0.3mm MinGapZ=0.3mm Objects=Box6 ProximitySizeFunction CurvatureSizeFunction OptimizePCBMesh}
  MeshOperations:
setups:
  Setup1: IcepakSteadyState Flow_Regime=Laminar Include_Temperature=true Include_Flow=true Include_Gravity Solution_Initialization_-_Z_Velocity=0.000980665m_per_sec Convergence_Criteria_-_Flow=0.001 Convergence_Criteria_-_Energy=1e-07 Convergence_Criteria_-_Discrete_Ordinates=1e-06 Radiation_Model="Discrete Ordinates Model" Flow_Iteration_Per_Radiation_Iteration=10 ThetaDivision=2 PhiDivision=2 ThetaPixels=2 PhiPixels=2 Under-relaxation_-_Pressure=0.7 Under-relaxation_-_Momentum=0.3 Under-relaxation_-_Temperature=1 Discretization_Scheme_-_Pressure=Standard Discretization_Scheme_-_Momentum=First Discretization_Scheme_-_Temperature=First Discretization_Scheme_-_Discrete_Ordinates=First Convergence_Criteria_-_Max_Iterations=1000
field plots:
  Temperature1: Temperature on Setup1 : SteadyState
  Temperature2: Temperature over a plane on Setup1 : SteadyState
