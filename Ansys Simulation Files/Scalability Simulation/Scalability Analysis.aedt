# Ansys Electronics Desktop project, version 2023.1
materials:
  aluminum: permeability=1.000021 conductivity=38000000 thermal_conductivity=237.5 mass_density=2689 specific_heat=951 youngs_modulus=69000000000 poissons_ratio=0.31 thermal_expansion_coefficient=2.33e-05
  copper: permeability=0.999991 conductivity=58000000 thermal_conductivity=400 mass_density=8933 specific_heat=385 youngs_modulus=120000000000 poissons_ratio=0.38 thermal_expansion_coefficient=1.77e-05
  ferrite - Copy (2): core_loss_curve{25kHz (0, 0) (0.050633, 1) (0.0590114, 1.50406) (0.0691674, 2.34392) (0.0792528, 3.65275) (0.088772, 5.02746) (0.0939521, 6.11121) (0.1, 7.16954) (0.109499, 8.56175) (0.121957, 11.5767) (0.138164, 16.5092) (0.153013, 23.1293) (0.173347, 32.9841) (0.195272, 44.5991) (0.21382, 61.3838) (0.235462, 78.6962) (0.259294, 104.536) (0.280722, 138.862) (0.295422, 151.746)} core_loss_curve{100kHz (0, 0) (0.0263744, 1.03613) (0.0293752, 1.42608) (0.0332788, 2.03369) (0.0396755, 3.1693) (0.0449479, 4.44016) (0.0523856, 6.91954) (0.0628101, 11.373) (0.0753091, 20.068) (0.0882699, 32.4039) (0.103461, 49.6099) (0.118547, 74.6161) (0.142138, 118.363) (0.165658, 191.122) (0.184506, 245.025) (0.1975, 325.48) (0.215037, 409.937) (0.242235, 554.291) (0.26827, 762.898) (0.287163, 911.04)} core_loss_curve{200kHz (0, 0) (0.0153013, 1.07357) (0.0196383, 2.03369) (0.0260769, 4.28533) (0.0305648, 7.42858) (0.0396755, 14.0722) (0.0481134, 22.7224) (0.059347, 38.6962) (0.0757374, 74.6161) (0.0994345, 162.909) (0.110748, 216.401) (0.130546, 319.755) (0.147894, 472.47) (0.164721, 605.722) (0.183462, 848.612) (0.194168, 1013.4) (0.210213, 1167.99) (0.235462, 1607.55) (0.252045, 2024.69) (0.274425, 2333.54) (0.290439, 2939.06)} core_loss_curve{500kHz (0, 0) (0.0101716, 5.89811) (0.01199, 8.71505) (0.0149581, 13.5815) (0.0170423, 18.6929) (0.0202031, 30.1834) (0.0235462, 38.6962) (0.0266752, 55.1837) (0.0309135, 72.0142) (0.0356225, 99.1166) (0.0401281, 129.346) (0.0465037, 187.76) (0.0515018, 236.481) (0.0580159, 319.755) (0.067616, 447.974) (0.0761681, 574.318) (0.0892769, 776.557) (0.101141, 1068.81) (0.1199, 1524.21) (0.142138, 2292.49) (0.174333, 3327.81) (0.199753, 5186.04) (0.22248, 6531.74) (0.249202, 8373.92)} permittivity=12 permeability=3400 conductivity=0.25 thermal_conductivity=4 core_loss_type="Power Ferrite" core_loss_cm=0.062032234 core_loss_x=1.7066326 core_loss_y=2.5354555 mass_density=4800 specific_heat=750 youngs_modulus=119000000000 thermal_expansion_coefficient=1e-05 core_loss_equiv_cut_depth=0.001meter
  silicon - Copy: permittivity=9 thermal_conductivity=10 mass_density=3700 specific_heat=712 youngs_modulus=135000000000 poissons_ratio=0.25 thermal_expansion_coefficient=2.54e-06
  vacuum: permittivity=1
  Al-Extruded: thermal_conductivity=205 mass_density=2800 specific_heat=900 youngs_modulus=69000000000 poissons_ratio=0.33 thermal_expansion_coefficient=2.277e-06 thermal_material_type=Solid
  air: permittivity=1.0006 permeability=1.0000004 thermal_conductivity=0.0261 mass_density=1.1614 specific_heat=1005 thermal_expansion_coefficient=0.00333 thermal_material_type=Fluid diffusivity=2.88e-05 molecular_mass=0.028966 viscosity=1.84e-05 material_refractive_index=1.000293
surface materials:
  Steel-oxidised-surface: surface_emissivity=0.8

design Flatwise_10kW (Maxwell 3D, EddyCurrent, model units mm)
variables:
  freq_hz = 28500Hz
  volt_ac = 141/28500*Freq*3.16227766017
geometry:
  Region [vacuum] = region(percentage_offset=0 on all sides)
  Body1 [ferrite - Copy (2)] = imported_body(C:\Users\karlr\Documents\flatwise_10kW.step)
  Body1_1, Body1_2 [aluminum] = imported_body(C:\Users\karlr\Documents\flatwise_10kW.step)
  Body1_3 [ferrite - Copy (2)] = imported_body(C:\Users\karlr\Documents\flatwise_10kW.step)
  Body1_4, Body1_5 [aluminum] = imported_body(C:\Users\karlr\Documents\flatwise_10kW.step)
  plate_2, plate_1 [silicon - Copy] = imported_body(C:\Users\karlr\Documents\flatwise_10kW.step)
  Ns1, Ns7, Ns4, Ns8, Ns2, Ns6, Ns5, Ns3, Np1, Np7, Np4, Np8, Np2, Np6, Np5, Np3 [copper] = imported_body(C:\Users\karlr\Documents\flatwise_10kW.step)
  Np1_Section1 [copper] = Np1.section(plane=ZX)
  Np2_Section1 [copper] = Np2.section(plane=ZX)
  Np3_Section1 [copper] = Np3.section(plane=ZX)
  Np4_Section1 [copper] = Np4.section(plane=ZX)
  Np5_Section1 [copper] = Np5.section(plane=ZX)
  Np6_Section1 [copper] = Np6.section(plane=ZX)
  Np7_Section1 [copper] = Np7.section(plane=ZX)
  Np8_Section1 [copper] = Np8.section(plane=ZX)
  Ns1_Section1 [copper] = Ns1.section(plane=ZX)
  Ns2_Section1 [copper] = Ns2.section(plane=ZX)
  Ns3_Section1 [copper] = Ns3.section(plane=ZX)
  Ns4_Section1 [copper] = Ns4.section(plane=ZX)
  Ns5_Section1 [copper] = Ns5.section(plane=ZX)
  Ns6_Section1 [copper] = Ns6.section(plane=ZX)
  Ns7_Section1 [copper] = Ns7.section(plane=ZX)
  Ns8_Section1 [copper] = Ns8.section(plane=ZX)
  Np1_Section1.separate_bodies()
  Np2_Section1.separate_bodies()
  Np3_Section1.separate_bodies()
  Np4_Section1.separate_bodies()
  Np5_Section1.separate_bodies()
  Np6_Section1.separate_bodies()
  Np7_Section1.separate_bodies()
  Np8_Section1.separate_bodies()
  Ns1_Section1.separate_bodies()
  Ns2_Section1.separate_bodies()
  Ns3_Section1.separate_bodies()
  Ns4_Section1.separate_bodies()
  Ns5_Section1.separate_bodies()
  Ns6_Section1.separate_bodies()
  Ns7_Section1.separate_bodies()
  Ns8_Section1.separate_bodies()
  Rectangle1 [non-model] = rectangle(corner=(0mm, 45.221645mm, 0mm), z_size=33.194549mm, x_size=65.085026mm)
  group flatwise_10kW = Body1, Body1_1..Body1_5, plate_2, plate_1, Ns1, Ns7, Ns4, Ns8, Ns2, Ns6, Ns5, Ns3, Np1, Np7, Np4, Np8, Np2, Np6, Np5, Np3, Np1_Section1, Np2_Section1, Np3_Section1, Np4_Section1, Np5_Section1, Np6_Section1, Np7_Section1, Np8_Section1, Ns1_Section1, Ns2_Section1, Ns3_Section1, Ns4_Section1, Ns5_Section1, Ns6_Section1, Ns7_Section1, Ns8_Section1
boundaries and excitations:
  Np_1: Coil Terminal Objects=Np1_Section1 Conductor_number=1 Winding=Np Point_out_of_terminal=false
  Np_2: Coil Terminal Objects=Np2_Section1 Conductor_number=1 Winding=Np Point_out_of_terminal=false
  Np_3: Coil Terminal Objects=Np3_Section1 Conductor_number=1 Winding=Np Point_out_of_terminal=false
  Np_4: Coil Terminal Objects=Np4_Section1 Conductor_number=1 Winding=Np Point_out_of_terminal=false
  Np_5: Coil Terminal Objects=Np5_Section1 Conductor_number=1 Winding=Np Point_out_of_terminal=false
  Np_6: Coil Terminal Objects=Np6_Section1 Conductor_number=1 Winding=Np Point_out_of_terminal=false
  Np_7: Coil Terminal Objects=Np7_Section1 Conductor_number=1 Winding=Np Point_out_of_terminal=false
  Np_8: Coil Terminal Objects=Np8_Section1 Conductor_number=1 Winding=Np Point_out_of_terminal=false
  Ns_1: Coil Terminal Objects=Ns1_Section1 Conductor_number=1 Winding=Ns Point_out_of_terminal=true
  Ns_2: Coil Terminal Objects=Ns2_Section1 Conductor_number=1 Winding=Ns Point_out_of_terminal=true
  Ns_3: Coil Terminal Objects=Ns3_Section1 Conductor_number=1 Winding=Ns Point_out_of_terminal=true
  Ns_4: Coil Terminal Objects=Ns4_Section1 Conductor_number=1 Winding=Ns Point_out_of_terminal=true
  Ns_5: Coil Terminal Objects=Ns5_Section1 Conductor_number=1 Winding=Ns Point_out_of_terminal=true
  Ns_6: Coil Terminal Objects=Ns6_Section1 Conductor_number=1 Winding=Ns Point_out_of_terminal=true
  Ns_7: Coil Terminal Objects=Ns7_Section1 Conductor_number=1 Winding=Ns Point_out_of_terminal=true
  Ns_8: Coil Terminal Objects=Ns8_Section1 Conductor_number=1 Winding=Ns Point_out_of_terminal=true
  Np: Winding Group Type=Voltage IsSolid=true Current=0A Resistance=0ohm Inductance=0nH Voltage="(100*3.16227766017*1.414) V" ParallelBranchesNum=1 Phase=0rad
  Ns: Winding Group Type=Current IsSolid=true Current=10*3.16227766017*1.414 ParallelBranchesNum=1 Phase=0.1522rad
  eddy effects on: Body1_1, Body1_2, Body1_4, Body1_5, Ns1, Ns7, Ns4, Ns8, Ns2, Ns6, Ns5, Ns3, Np1, Np7, Np4, Np8, Np2, Np6, Np5, Np3
  core loss on: Body1, Body1_3
parameters:
  Matrix1: Matrix Np, Ns:
mesh:
  Wire: LengthBased Objects=[Np1..Np8, Ns1..Ns8] MaxLength=3mm
  Length1: LengthBased Objects=[Body1_1, Body1_2, Body1_4, Body1_5, Body1, Body1_3, plate_1, plate_2] MaxLength=7mm
  initial mesh: GlobalSurfApproximation{CurvedSurfaceApproxChoice=UseSlider SliderMeshSettings=9} GlobalCurvilinear{Apply}
setups:
  Setup1: EddyCurrent MaximumPasses=20 MinimumPasses=5 MinimumConvergedPasses=1 PercentRefinement=30 PercentError=1 NonLinearResidual=0.0001 SmoothBHCurve Frequency=28.5kHz
field plots:
  Mesh1: MeshPlots in Np1..Np8, Ns1..Ns8 on Setup1 : LastAdaptive at Freq=28.5kHz Phase=0deg
  Mesh2: MeshPlots over a plane on Setup1 : LastAdaptive at Freq=28.5kHz Phase=0deg
  Mag_B1: B over a plane on Setup1 : LastAdaptive at Freq=28.5kHz Phase=45deg
reports:
  L Table 1: Matrix1.L(Np,Np), Matrix1.L(Ns,Np), Matrix1.L(Np,Ns), Matrix1.L(Ns,Ns), Matrix1.R(Np,Np), Matrix1.R(Ns,Np), Matrix1.R(Np,Ns), Matrix1.R(Ns,Ns) vs Freq on Setup1 : LastAdaptive

design Edgewise_10kW (Maxwell 3D, EddyCurrent, model units mm)
variables:
  freq_hz = 28500Hz
  volt_ac = 141/28500*Freq*3.16227766017
geometry:
  Region [vacuum] = region(percentage_offset=0 on all sides)
  Body1 [ferrite - Copy (2)] = imported_body(C:\Users\karlr\Documents\edgewise_10kW.step)
  Body1_1, Body1_2 [aluminum] = imported_body(C:\Users\karlr\Documents\edgewise_10kW.step)
  Body1_3 [ferrite - Copy (2)] = imported_body(C:\Users\karlr\Documents\edgewise_10kW.step)
  Body1_4, Body1_5 [aluminum] = imported_body(C:\Users\karlr\Documents\edgewise_10kW.step)
  plate1, plate2 [silicon - Copy] = imported_body(C:\Users\karlr\Documents\edgewise_10kW.step)
  Ns8, Ns4, Ns1, Ns5, Ns7, Ns3, Ns2, Ns6, Np8, Np4, Np1, Np5, Np7, Np3, Np2, Np6 [copper] = imported_body(C:\Users\karlr\Documents\edgewise_10kW.step)
  Np1_Section1 [copper] = Np1.section(plane=ZX)
  Np2_Section1 [copper] = Np2.section(plane=ZX)
  Np3_Section1 [copper] = Np3.section(plane=ZX)
  Np4_Section1 [copper] = Np4.section(plane=ZX)
  Np5_Section1 [copper] = Np5.section(plane=ZX)
  Np6_Section1 [copper] = Np6.section(plane=ZX)
  Np7_Section1 [copper] = Np7.section(plane=ZX)
  Np8_Section1 [copper] = Np8.section(plane=ZX)
  Ns1_Section1 [copper] = Ns1.section(plane=ZX)
  Ns2_Section1 [copper] = Ns2.section(plane=ZX)
  Ns3_Section1 [copper] = Ns3.section(plane=ZX)
  Ns4_Section1 [copper] = Ns4.section(plane=ZX)
  Ns5_Section1 [copper] = Ns5.section(plane=ZX)
  Ns6_Section1 [copper] = Ns6.section(plane=ZX)
  Ns7_Section1 [copper] = Ns7.section(plane=ZX)
  Ns8_Section1 [copper] = Ns8.section(plane=ZX)
  Np1_Section1.separate_bodies()
  Np2_Section1.separate_bodies()
  Np3_Section1.separate_bodies()
  Np4_Section1.separate_bodies()
  Np5_Section1.separate_bodies()
  Np6_Section1.separate_bodies()
  Np7_Section1.separate_bodies()
  Np8_Section1.separate_bodies()
  Ns1_Section1.separate_bodies()
  Ns2_Section1.separate_bodies()
  Ns3_Section1.separate_bodies()
  Ns4_Section1.separate_bodies()
  Ns5_Section1.separate_bodies()
  Ns6_Section1.separate_bodies()
  Ns7_Section1.separate_bodies()
  Ns8_Section1.separate_bodies()
  group edgewise_10kW = Body1, Body1_1..Body1_5, plate1, plate2, Ns8, Ns4, Ns1, Ns5, Ns7, Ns3, Ns2, Ns6, Np8, Np4, Np1, Np5, Np7, Np3, Np2, Np6, Np1_Section1, Np2_Section1, Np3_Section1, Np4_Section1, Np5_Section1, Np6_Section1, Np7_Section1, Np8_Section1, Ns1_Section1, Ns2_Section1, Ns3_Section1, Ns4_Section1, Ns5_Section1, Ns6_Section1, Ns7_Section1, Ns8_Section1
boundaries and excitations:
  Np_1: Coil Terminal Objects=Np1_Section1 Conductor_number=1 Winding=Np Point_out_of_terminal=false
  Np_2: Coil Terminal Objects=Np2_Section1 Conductor_number=1 Winding=Np Point_out_of_terminal=false
  Np_3: Coil Terminal Objects=Np3_Section1 Conductor_number=1 Winding=Np Point_out_of_terminal=false
  Np_4: Coil Terminal Objects=Np4_Section1 Conductor_number=1 Winding=Np Point_out_of_terminal=false
  Np_5: Coil Terminal Objects=Np5_Section1 Conductor_number=1 Winding=Np Point_out_of_terminal=false
  Np_6: Coil Terminal Objects=Np6_Section1 Conductor_number=1 Winding=Np Point_out_of_terminal=false
  Np_7: Coil Terminal Objects=Np7_Section1 Conductor_number=1 Winding=Np Point_out_of_terminal=false
  Np_8: Coil Terminal Objects=Np8_Section1 Conductor_number=1 Winding=Np Point_out_of_terminal=false
  Ns_1: Coil Terminal Objects=Ns1_Section1 Conductor_number=1 Winding=Ns Point_out_of_terminal=true
  Ns_2: Coil Terminal Objects=Ns2_Section1 Conductor_number=1 Winding=Ns Point_out_of_terminal=true
  Ns_3: Coil Terminal Objects=Ns3_Section1 Conductor_number=1 Winding=Ns Point_out_of_terminal=true
  Ns_4: Coil Terminal Objects=Ns4_Section1 Conductor_number=1 Winding=Ns Point_out_of_terminal=true
  Ns_5: Coil Terminal Objects=Ns5_Section1 Conductor_number=1 Winding=Ns Point_out_of_terminal=true
  Ns_6: Coil Terminal Objects=Ns6_Section1 Conductor_number=1 Winding=Ns Point_out_of_terminal=true
  Ns_7: Coil Terminal Objects=Ns7_Section1 Conductor_number=1 Winding=Ns Point_out_of_terminal=true
  Ns_8: Coil Terminal Objects=Ns8_Section1 Conductor_number=1 Winding=Ns Point_out_of_terminal=true
  Np: Winding Group Type=Voltage IsSolid=true Current=0A Resistance=0ohm Inductance=0nH Voltage="(100*3.16227766017*1.414) V" ParallelBranchesNum=1 Phase=0rad
  Ns: Winding Group Type=Current IsSolid=true Current=10*3.16227766017*1.414 ParallelBranchesNum=1 Phase=0.1522rad
  eddy effects on: Body1_1, Body1_2, Body1_4, Body1_5, Ns8, Ns4, Ns1, Ns5, Ns7, Ns3, Ns2, Ns6, Np8, Np4, Np1, Np5, Np7, Np3, Np2, Np6
  core loss on: Body1, Body1_3
parameters:
  Matrix1: Matrix Np, Ns:
mesh:
  Length1: LengthBased Objects=[Np1..Np8, Ns1..Ns8] MaxLength=3mm
  Length2: LengthBased Objects=[plate1, plate2, Body1, Body1_3, Body1_1, Body1_2, Body1_4, Body1_5] MaxLength=7mm
  initial mesh: GlobalSurfApproximation{CurvedSurfaceApproxChoice=UseSlider SliderMeshSettings=9} GlobalCurvilinear{Apply}
setups:
  Setup1: EddyCurrent MaximumPasses=20 MinimumPasses=5 MinimumConvergedPasses=1 PercentRefinement=30 PercentError=1 NonLinearResidual=0.0001 SmoothBHCurve Frequency=28.5kHz
reports:
  L Table 1: Matrix1.L(Np,Np), Matrix1.L(Ns,Np), Matrix1.L(Np,Ns), Matrix1.L(Ns,Ns), Matrix1.R(Np,Np), Matrix1.R(Ns,Np), Matrix1.R(Np,Ns), Matrix1.R(Ns,Ns) vs Freq on Setup1 : LastAdaptive

design Edgewise_100kW (Maxwell 3D, EddyCurrent, model units mm)
variables:
  freq_hz = 28500Hz
  volt_ac = 141/28500*Freq*3.16227766017
geometry:
  Region [vacuum] = region(percentage_offset=0 on all sides)
  Body1 [ferrite - Copy (2)] = imported_body(C:\Users\karlr\Documents\edgewise_100kW.step)
  Body1_1, Body1_2 [aluminum] = imported_body(C:\Users\karlr\Documents\edgewise_100kW.step)
  Body1_3 [ferrite - Copy (2)] = imported_body(C:\Users\karlr\Documents\edgewise_100kW.step)
  Body1_4, Body1_5 [aluminum] = imported_body(C:\Users\karlr\Documents\edgewise_100kW.step)
  plate1, plate2 [silicon - Copy] = imported_body(C:\Users\karlr\Documents\edgewise_100kW.step)
  Ns8, Ns4, Ns1, Ns5, Ns7, Ns3, Ns2, Ns6, Np8, Np4, Np1, Np5, Np7, Np3, Np2, Np6 [copper] = imported_body(C:\Users\karlr\Documents\edgewise_100kW.step)
  Np1_Section1 [copper] = Np1.section(plane=ZX)
  Np2_Section1 [copper] = Np2.section(plane=ZX)
  Np3_Section1 [copper] = Np3.section(plane=ZX)
  Np4_Section1 [copper] = Np4.section(plane=ZX)
  Np5_Section1 [copper] = Np5.section(plane=ZX)
  Np6_Section1 [copper] = Np6.section(plane=ZX)
  Np7_Section1 [copper] = Np7.section(plane=ZX)
  Np8_Section1 [copper] = Np8.section(plane=ZX)
  Ns1_Section1 [copper] = Ns1.section(plane=ZX)
  Ns2_Section1 [copper] = Ns2.section(plane=ZX)
  Ns3_Section1 [copper] = Ns3.section(plane=ZX)
  Ns4_Section1 [copper] = Ns4.section(plane=ZX)
  Ns5_Section1 [copper] = Ns5.section(plane=ZX)
  Ns6_Section1 [copper] = Ns6.section(plane=ZX)
  Ns7_Section1 [copper] = Ns7.section(plane=ZX)
  Ns8_Section1 [copper] = Ns8.section(plane=ZX)
  Np1_Section1.separate_bodies()
  Np2_Section1.separate_bodies()
  Np3_Section1.separate_bodies()
  Np4_Section1.separate_bodies()
  Np5_Section1.separate_bodies()
  Np6_Section1.separate_bodies()
  Np7_Section1.separate_bodies()
  Np8_Section1.separate_bodies()
  Ns1_Section1.separate_bodies()
  Ns2_Section1.separate_bodies()
  Ns3_Section1.separate_bodies()
  Ns4_Section1.separate_bodies()
  Ns5_Section1.separate_bodies()
  Ns6_Section1.separate_bodies()
  Ns7_Section1.separate_bodies()
  Ns8_Section1.separate_bodies()
  group edgewise_100kW = Body1, Body1_1..Body1_5, plate1, plate2, Ns8, Ns4, Ns1, Ns5, Ns7, Ns3, Ns2, Ns6, Np8, Np4, Np1, Np5, Np7, Np3, Np2, Np6, Np1_Section1, Np2_Section1, Np3_Section1, Np4_Section1, Np5_Section1, Np6_Section1, Np7_Section1, Np8_Section1, Ns1_Section1, Ns2_Section1, Ns3_Section1, Ns4_Section1, Ns5_Section1, Ns6_Section1, Ns7_Section1, Ns8_Section1
boundaries and excitations:
  Np_1: Coil Terminal Objects=Np1_Section1 Conductor_number=1 Winding=Np Point_out_of_terminal=false
  Np_2: Coil Terminal Objects=Np2_Section1 Conductor_number=1 Winding=Np Point_out_of_terminal=false
  Np_3: Coil Terminal Objects=Np3_Section1 Conductor_number=1 Winding=Np Point_out_of_terminal=false
  Np_4: Coil Terminal Objects=Np4_Section1 Conductor_number=1 Winding=Np Point_out_of_terminal=false
  Np_5: Coil Terminal Objects=Np5_Section1 Conductor_number=1 Winding=Np Point_out_of_terminal=false
  Np_6: Coil Terminal Objects=Np6_Section1 Conductor_number=1 Winding=Np Point_out_of_terminal=false
  Np_7: Coil Terminal Objects=Np7_Section1 Conductor_number=1 Winding=Np Point_out_of_terminal=false
  Np_8: Coil Terminal Objects=Np8_Section1 Conductor_number=1 Winding=Np Point_out_of_terminal=false
  Ns_1: Coil Terminal Objects=Ns1_Section1 Conductor_number=1 Winding=Ns Point_out_of_terminal=true
  Ns_2: Coil Terminal Objects=Ns2_Section1 Conductor_number=1 Winding=Ns Point_out_of_terminal=true
  Ns_3: Coil Terminal Objects=Ns3_Section1 Conductor_number=1 Winding=Ns Point_out_of_terminal=true
  Ns_4: Coil Terminal Objects=Ns4_Section1 Conductor_number=1 Winding=Ns Point_out_of_terminal=true
  Ns_5: Coil Terminal Objects=Ns5_Section1 Conductor_number=1 Winding=Ns Point_out_of_terminal=true
  Ns_6: Coil Terminal Objects=Ns6_Section1 Conductor_number=1 Winding=Ns Point_out_of_terminal=true
  Ns_7: Coil Terminal Objects=Ns7_Section1 Conductor_number=1 Winding=Ns Point_out_of_terminal=true
  Ns_8: Coil Terminal Objects=Ns8_Section1 Conductor_number=1 Winding=Ns Point_out_of_terminal=true
  Np: Winding Group Type=Voltage IsSolid=true Current=0A Resistance=0ohm Inductance=0nH Voltage="(100*10*1.414) V" ParallelBranchesNum=1 Phase=0rad
  Ns: Winding Group Type=Current IsSolid=true Current=10*10*1.414 ParallelBranchesNum=1 Phase=0.1522rad
  eddy effects on: Body1_1, Body1_2, Body1_4, Body1_5, Ns8, Ns4, Ns1, Ns5, Ns7, Ns3, Ns2, Ns6, Np8, Np4, Np1, Np5, Np7, Np3, Np2, Np6
  core loss on: Body1, Body1_3
parameters:
  Matrix1: Matrix Np, Ns:
mesh:
  Length1: LengthBased Objects=[Np1..Np8, Ns1..Ns8] MaxLength=5mm
  Length2: LengthBased Objects=[plate1, plate2, Body1, Body1_3, Body1_1, Body1_2, Body1_4, Body1_5] MaxLength=10mm
  initial mesh: GlobalSurfApproximation{CurvedSurfaceApproxChoice=UseSlider SliderMeshSettings=9} GlobalCurvilinear{Apply}
setups:
  Setup1: EddyCurrent MaximumPasses=20 MinimumPasses=5 MinimumConvergedPasses=1 PercentRefinement=30 PercentError=1 NonLinearResidual=0.0001 SmoothBHCurve Frequency=28.5kHz
reports:
  L Table 1: Matrix1.L(Np,Np), Matrix1.L(Ns,Np), Matrix1.L(Np,Ns), Matrix1.L(Ns,Ns), Matrix1.R(Np,Np), Matrix1.R(Ns,Np), Matrix1.R(Np,Ns), Matrix1.R(Ns,Ns) vs Freq on Setup1 : LastAdaptive

design Flatwise_100kW (Maxwell 3D, EddyCurrent, model units mm)
variables:
  freq_hz = 28500Hz
  volt_ac = 141/28500*Freq*3.16227766017
geometry:
  Body1 [ferrite - Copy (2)] = imported_body(C:\Users\karlr\Documents\flatwise_100kW.step)
  Body1_1..Body1_4 [aluminum] = imported_body(C:\Users\karlr\Documents\flatwise_100kW.step)
  Body1_5 [ferrite - Copy (2)] = imported_body(C:\Users\karlr\Documents\flatwise_100kW.step)
  plate_2, plate_1 [silicon - Copy] = imported_body(C:\Users\karlr\Documents\flatwise_100kW.step)
  Ns1, Ns7, Ns4, Ns8, Ns2, Ns6, Ns5, Ns3, Np1, Np7, Np4, Np8, Np2, Np6, Np5, Np3 [copper] = imported_body(C:\Users\karlr\Documents\flatwise_100kW.step)
  Np1_Section1 [copper] = Np1.section(plane=ZX)
  Np2_Section1 [copper] = Np2.section(plane=ZX)
  Np3_Section1 [copper] = Np3.section(plane=ZX)
  Np4_Section1 [copper] = Np4.section(plane=ZX)
  Np5_Section1 [copper] = Np5.section(plane=ZX)
  Np6_Section1 [copper] = Np6.section(plane=ZX)
  Np7_Section1 [copper] = Np7.section(plane=ZX)
  Np8_Section1 [copper] = Np8.section(plane=ZX)
  Ns1_Section1 [copper] = Ns1.section(plane=ZX)
  Ns2_Section1 [copper] = Ns2.section(plane=ZX)
  Ns3_Section1 [copper] = Ns3.section(plane=ZX)
  Ns4_Section1 [copper] = Ns4.section(plane=ZX)
  Ns5_Section1 [copper] = Ns5.section(plane=ZX)
  Ns6_Section1 [copper] = Ns6.section(plane=ZX)
  Ns7_Section1 [copper] = Ns7.section(plane=ZX)
  Ns8_Section1 [copper] = Ns8.section(plane=ZX)
  Np1_Section1.separate_bodies()
  Np2_Section1.separate_bodies()
  Np3_Section1.separate_bodies()
  Np4_Section1.separate_bodies()
  Np5_Section1.separate_bodies()
  Np6_Section1.separate_bodies()
  Np7_Section1.separate_bodies()
  Np8_Section1.separate_bodies()
  Ns1_Section1.separate_bodies()
  Ns2_Section1.separate_bodies()
  Ns3_Section1.separate_bodies()
  Ns4_Section1.separate_bodies()
  Ns5_Section1.separate_bodies()
  Ns6_Section1.separate_bodies()
  Ns7_Section1.separate_bodies()
  Ns8_Section1.separate_bodies()
  Region [vacuum] = region(percentage_offset=0 on all sides)
  group flatwise_100kW = Body1, Body1_1..Body1_5, plate_2, plate_1, Ns1, Ns7, Ns4, Ns8, Ns2, Ns6, Ns5, Ns3, Np1, Np7, Np4, Np8, Np2, Np6, Np5, Np3, Np1_Section1, Np2_Section1, Np3_Section1, Np4_Section1, Np5_Section1, Np6_Section1, Np7_Section1, Np8_Section1, Ns1_Section1, Ns2_Section1, Ns3_Section1, Ns4_Section1, Ns5_Section1, Ns6_Section1, Ns7_Section1, Ns8_Section1
boundaries and excitations:
  Np_1: Coil Terminal Objects=Np8_Section1 Conductor_number=1 Winding=Np Point_out_of_terminal=false
  Np_2: Coil Terminal Objects=Np1_Section1 Conductor_number=1 Winding=Np Point_out_of_terminal=false
  Np_3: Coil Terminal Objects=Np2_Section1 Conductor_number=1 Winding=Np Point_out_of_terminal=false
  Np_4: Coil Terminal Objects=Np3_Section1 Conductor_number=1 Winding=Np Point_out_of_terminal=false
  Np_5: Coil Terminal Objects=Np4_Section1 Conductor_number=1 Winding=Np Point_out_of_terminal=false
  Np_6: Coil Terminal Objects=Np5_Section1 Conductor_number=1 Winding=Np Point_out_of_terminal=false
  Np_7: Coil Terminal Objects=Np6_Section1 Conductor_number=1 Winding=Np Point_out_of_terminal=false
  Np_8: Coil Terminal Objects=Np7_Section1 Conductor_number=1 Winding=Np Point_out_of_terminal=false
  Ns_1: Coil Terminal Objects=Ns1_Section1 Conductor_number=1 Winding=Ns Point_out_of_terminal=true
  Ns_2: Coil Terminal Objects=Ns2_Section1 Conductor_number=1 Winding=Ns Point_out_of_terminal=true
  Ns_3: Coil Terminal Objects=Ns3_Section1 Conductor_number=1 Winding=Ns Point_out_of_terminal=true
  Ns_4: Coil Terminal Objects=Ns4_Section1 Conductor_number=1 Winding=Ns Point_out_of_terminal=true
  Ns_5: Coil Terminal Objects=Ns5_Section1 Conductor_number=1 Winding=Ns Point_out_of_terminal=true
  Ns_6: Coil Terminal Objects=Ns6_Section1 Conductor_number=1 Winding=Ns Point_out_of_terminal=true
  Ns_7: Coil Terminal Objects=Ns7_Section1 Conductor_number=1 Winding=Ns Point_out_of_terminal=true
  Ns_8: Coil Terminal Objects=Ns8_Section1 Conductor_number=1 Winding=Ns Point_out_of_terminal=true
  Np: Winding Group Type=Voltage IsSolid=true Current=0A Resistance=0ohm Inductance=0nH Voltage="(100*10*1.414) V" ParallelBranchesNum=1 Phase=0rad
  Ns: Winding Group Type=Current IsSolid=true Current=10*10*1.414 ParallelBranchesNum=1 Phase=0.1522rad
  eddy effects on: Body1_1..Body1_4, Ns1, Ns7, Ns4, Ns8, Ns2, Ns6, Ns5, Ns3, Np1, Np7, Np4, Np8, Np2, Np6, Np5, Np3
  core loss on: Body1, Body1_5
parameters:
  Matrix1: Matrix Np, Ns:
mesh:
  Length1: LengthBased Objects=[Np1..Np8, Ns1..Ns8] MaxLength=5mm
  Length2: LengthBased Objects=[Body1, Body1_5, plate_1, plate_2, Body1_1..Body1_4] MaxLength=10mm
  initial mesh: GlobalSurfApproximation{CurvedSurfaceApproxChoice=UseSlider SliderMeshSettings=9} GlobalCurvilinear{Apply}
setups:
  Setup1: EddyCurrent MaximumPasses=20 MinimumPasses=5 MinimumConvergedPasses=1 PercentRefinement=30 PercentError=1 NonLinearResidual=0.0001 SmoothBHCurve Frequency=28.5kHz
reports:
  L Table 1: Matrix1.L(Np,Np), Matrix1.L(Ns,Np), Matrix1.L(Np,Ns), Matrix1.L(Ns,Ns), Matrix1.R(Np,Np), Matrix1.R(Ns,Np), Matrix1.R(Np,Ns), Matrix1.R(Ns,Ns) vs Freq on Setup1 : LastAdaptive

design Edgewise_0.3_interleaved_full (Maxwell 3D, EddyCurrent, model units mm)
variables:
  freq_hz = 28500Hz
  volt_ac = 141/28500*Freq
geometry:
  Region [vacuum] = region(percentage_offset=0 on all sides)
  Np1..Np8, Ns1..Ns8 [copper] = imported_body(C:\Users\karlr\Documents\ICMaSS_sweeping\edgewise_0.1_0.3.step)
  plate1, plate2 [silicon - Copy] = imported_body(C:\Users\karlr\Documents\ICMaSS_sweeping\edgewise_0.1_0.3.step)
  Body1 [ferrite - Copy (2)] = imported_body(C:\Users\karlr\Documents\ICMaSS_sweeping\edgewise_0.1_0.3.step)
  Body1_1, Body1_2 [aluminum] = imported_body(C:\Users\karlr\Documents\ICMaSS_sweeping\edgewise_0.1_0.3.step)
  Body1_3 [ferrite - Copy (2)] = imported_body(C:\Users\karlr\Documents\ICMaSS_sweeping\edgewise_0.1_0.3.step)
  Body1_4, Body1_5 [aluminum] = imported_body(C:\Users\karlr\Documents\ICMaSS_sweeping\edgewise_0.1_0.3.step)
  Np1_Section1 = Np1.section(plane=ZX)
  Np2_Section1 [copper] = Np2.section(plane=ZX)
  Np3_Section1 [copper] = Np3.section(plane=ZX)
  Np4_Section1 [copper] = Np4.section(plane=ZX)
  Np5_Section1 [copper] = Np5.section(plane=ZX)
  Np6_Section1 [copper] = Np6.section(plane=ZX)
  Np7_Section1 [copper] = Np7.section(plane=ZX)
  Np8_Section1 [copper] = Np8.section(plane=ZX)
  Ns1_Section1 [copper] = Ns1.section(plane=ZX)
  Ns2_Section1 [copper] = Ns2.section(plane=ZX)
  Ns3_Section1 [copper] = Ns3.section(plane=ZX)
  Ns4_Section1 [copper] = Ns4.section(plane=ZX)
  Ns5_Section1 [copper] = Ns5.section(plane=ZX)
  Ns6_Section1 [copper] = Ns6.section(plane=ZX)
  Ns7_Section1 [copper] = Ns7.section(plane=ZX)
  Ns8_Section1 = Ns8.section(plane=ZX)
  Np1_Section1_Separate1 [copper] = Np1_Section1.separate_bodies()
  Np1_Section1.delete()
  Np2_Section1.separate_bodies()
  Np3_Section1.separate_bodies()
  Np4_Section1.separate_bodies()
  Np5_Section1.separate_bodies()
  Np6_Section1.separate_bodies()
  Np7_Section1.separate_bodies()
  Np8_Section1.separate_bodies()
  Ns1_Section1.separate_bodies()
  Ns2_Section1.separate_bodies()
  Ns3_Section1.separate_bodies()
  Ns4_Section1.separate_bodies()
  Ns5_Section1.separate_bodies()
  Ns6_Section1.separate_bodies()
  Ns7_Section1.separate_bodies()
  Ns8_Section1_Separate1 [copper] = Ns8_Section1.separate_bodies()
  Ns8_Section1.delete()
  [Np1..Np8, Ns1..Ns8, plate1, plate2, Body1, Body1_1..Body1_5, Np2_Section1, Np3_Section1, Np4_Section1, Np5_Section1, Np6_Section1, Np7_Section1, Np8_Section1, Ns1_Section1, Ns2_Section1, Ns3_Section1, Ns4_Section1, Ns5_Section1, Ns6_Section1, Ns7_Section1, Np1_Section1_Separate1, Ns8_Section1_Separate1].move(-18.666667mm, -25.43mm, -1.6666613e-08mm)
  Rectangle1 [non-model] = rectangle(corner=(-18.666667mm, 0mm, 0mm), z_size=18.3mm, x_size=37.333333mm)
  group core_assembled_edgewise2 = Np1..Np8, Ns1..Ns8, plate1, plate2, Np2_Section1, Np3_Section1, Np4_Section1, Np5_Section1, Np6_Section1, Np7_Section1, Np8_Section1, Ns1_Section1, Ns2_Section1, Ns3_Section1, Ns4_Section1, Ns5_Section1, Ns6_Section1, Ns7_Section1, Np1_Section1_Separate1, Ns8_Section1_Separate1
  group core_together_3 = Body1, Body1_1, Body1_2
  group core_together2 = Body1_3, Body1_4, Body1_5
boundaries and excitations:
  Ns_1: Coil Terminal Objects=Ns8_Section1_Separate1 Conductor_number=1 Winding=Ns Point_out_of_terminal=true
  Ns_2: Coil Terminal Objects=Ns1_Section1 Conductor_number=1 Winding=Ns Point_out_of_terminal=true
  Ns_3: Coil Terminal Objects=Ns2_Section1 Conductor_number=1 Winding=Ns Point_out_of_terminal=true
  Ns_4: Coil Terminal Objects=Ns3_Section1 Conductor_number=1 Winding=Ns Point_out_of_terminal=true
  Ns_5: Coil Terminal Objects=Ns4_Section1 Conductor_number=1 Winding=Ns Point_out_of_terminal=true
  Ns_6: Coil Terminal Objects=Ns5_Section1 Conductor_number=1 Winding=Ns Point_out_of_terminal=true
  Ns_7: Coil Terminal Objects=Ns6_Section1 Conductor_number=1 Winding=Ns Point_out_of_terminal=true
  Ns_8: Coil Terminal Objects=Ns7_Section1 Conductor_number=1 Winding=Ns Point_out_of_terminal=true
  Np_1: Coil Terminal Objects=Np1_Section1_Separate1 Conductor_number=1 Winding=Np Point_out_of_terminal=false
  Np_2: Coil Terminal Objects=Np2_Section1 Conductor_number=1 Winding=Np Point_out_of_terminal=false
  Np_3: Coil Terminal Objects=Np3_Section1 Conductor_number=1 Winding=Np Point_out_of_terminal=false
  Np_4: Coil Terminal Objects=Np4_Section1 Conductor_number=1 Winding=Np Point_out_of_terminal=false
  Np_5: Coil Terminal Objects=Np5_Section1 Conductor_number=1 Winding=Np Point_out_of_terminal=false
  Np_6: Coil Terminal Objects=Np6_Section1 Conductor_number=1 Winding=Np Point_out_of_terminal=false
  Np_7: Coil Terminal Objects=Np7_Section1 Conductor_number=1 Winding=Np Point_out_of_terminal=false
  Np_8: Coil Terminal Objects=Np8_Section1 Conductor_number=1 Winding=Np Point_out_of_terminal=false
  Np: Winding Group Type=Voltage IsSolid=true Current=16.36A Resistance=0ohm Inductance=0nH Voltage=volt_ac ParallelBranchesNum=1 Phase=0rad
  Ns: Winding Group Type=Current IsSolid=true Current=1000*1.41/volt_ac*1.414 ParallelBranchesNum=1 Phase=0.1522rad
  core loss on: Body1, Body1_3
parameters:
  Matrix1: Matrix Np, Ns:
mesh:
  Length1: LengthBased Objects=[Np1..Np8, Ns1..Ns8, plate1, plate2] MaxLength=5mm
  Length2: LengthBased Objects=[Np1..Np8, Ns1..Ns8, plate1, plate2] MaxLength=1.5mm
  initial mesh: GlobalSurfApproximation{CurvedSurfaceApproxChoice=UseSlider SliderMeshSettings=9} GlobalCurvilinear{Apply}
setups:
  Setup1: EddyCurrent MaximumPasses=20 MinimumPasses=2 MinimumConvergedPasses=1 PercentRefinement=30 PercentError=1 NonLinearResidual=0.0001 SmoothBHCurve Frequency=28.5kHz
field plots:
  Mag_J1: J over Np1..Np8, Ns1..Ns8 on Setup1 : LastAdaptive at Freq=28.5kHz Phase=45deg
  Mag_B1: B over Body1, Body1_3 on Setup1 : LastAdaptive at Freq=28.5kHz Phase=45deg
  Mag_J2: J over Np1_Section1_Separate1.face Np2_Section1.face(at (9.33333, -25.43, 6.95)) Np3_Section1.face(at (9.33333, -25.43, 7.75)) Np4_Section1.face(at (9.33333, -25.43, 8.55)) Np5_Section1.face(at (9.33333, -25.43, 9.35)) Np6_Section1.face(at (9.33333, -25.43, 10.15)) Np7_Section1.face(at (9.33333, -25.43, 10.95)) Np8_Section1.face(at (9.33333, -25.43, 11.75)) Ns1_Section1.face(at (9.33333, -25.43, 6.55)) Ns2_Section1.face(at (9.33333, -25.43, 7.35)) Ns3_Section1.face(at (9.33333, -25.43, 8.15)) Ns4_Section1.face(at (9.33333, -25.43, 8.95)) Ns5_Section1.face(at (9.33333, -25.43, 9.75)) Ns6_Section1.face(at (9.33333, -25.43, 10.55)) Ns7_Section1.face(at (9.33333, -25.43, 11.35)) Ns8_Section1_Separate1.face on Setup1 : LastAdaptive at Freq=28.5kHz Phase=45deg
  Mag_B2: B over a plane on Setup1 : LastAdaptive at Freq=28.5kHz Phase=45deg
  EM_Loss1: EM-Loss in Np1..Np8, Ns1..Ns8 on Setup1 : LastAdaptive at Freq=28.5kHz Phase=45deg
  Ohmic_Loss1: Ohmic-Loss in Np1..Np8, Ns1..Ns8 on Setup1 : LastAdaptive at Freq=28.5kHz Phase=0deg
  Ohmic_Loss2: Ohmic-Loss over Np1..Np8, Ns1..Ns8 on Setup1 : LastAdaptive at Freq=28.5kHz Phase=0deg
reports:
  L Table 1: Matrix1.L(Np,Np), Matrix1.L(Ns,Np), Matrix1.L(Np,Ns), Matrix1.L(Ns,Ns), Matrix1.R(Np,Np), Matrix1.R(Ns,Np), Matrix1.R(Np,Ns), Matrix1.R(Ns,Ns) vs Freq on Setup1 : LastAdaptive

design [Thermal]Flatwise_10kW (Icepak, SteadyState TemperatureAndFlow, model units mm)
options: Default_Fluid_Material=air Default_Solid_Material=Al-Extruded Default_Surface_Material=Steel-oxidised-surface AmbientTemperature=25cel AmbientPressure=0n_per_meter_sq AmbientRadiationTemperature=25cel Gravity_Vector_CS_ID=Global Gravity_Vector_Axis=Z Positive=false SherlockExportDirectory=C:/Users/karlr/Documents/Ansoft/1kW_Final.aedtexport/[Thermal]8turns_3D_CoreLoss_FullInterleaved_Flatwise/ Altitude=0meter
geometry:
  Region [air] = region(percentage_offset: +X=1000, -X=1000, +Y=1000, -Y=1000, +Z=1000, -Z=0)
  Box2 [aluminum] = box(corner=(70mm, -50mm, -1mm), size=(-100 * sqrt(10) mm, 150 * sqrt(10) mm, -5mm))
  Body1 [ferrite - Copy (2)] = imported_body(C:\Users\karlr\Documents\flatwise_10kW.step)
  Body1_1, Body1_2 [aluminum] = imported_body(C:\Users\karlr\Documents\flatwise_10kW.step)
  Body1_3 [ferrite - Copy (2)] = imported_body(C:\Users\karlr\Documents\flatwise_10kW.step)
  Body1_4, Body1_5 [aluminum] = imported_body(C:\Users\karlr\Documents\flatwise_10kW.step)
  plate_2, plate_1 [silicon - Copy] = imported_body(C:\Users\karlr\Documents\flatwise_10kW.step)
  Ns1, Ns7, Ns4, Ns8, Ns2, Ns6, Ns5, Ns3, Np1, Np7, Np4, Np8, Np2, Np6, Np5, Np3 [copper] = imported_body(C:\Users\karlr\Documents\flatwise_10kW.step)
  Rectangle1 [non-model] = rectangle(corner=(0mm, 45.221645mm, 0mm), z_size=33.194549mm, x_size=65.085026mm)
  [Rectangle1, Body1, Body1_1..Body1_5, plate_2, plate_1, Ns1, Ns7, Ns4, Ns8, Ns2, Ns6, Ns5, Ns3, Np1, Np7, Np4, Np8, Np2, Np6, Np5, Np3].move(65.085026mm, -45.221645mm, -4.9737992e-14mm)
  Box3 [silicon - Copy] = box(corner=(130.17005mm, 59.981365mm, 0mm), size=(-65.085026mm, -119.96273mm, -1mm))
  [Body1, Body1_1..Body1_5, plate_2, plate_1, Ns1, Ns7, Ns4, Ns8, Ns2, Ns6, Ns5, Ns3, Np1, Np7, Np4, Np8, Np2, Np6, Np5, Np3, Rectangle1, Box3].move(-185.74142mm, 187.17082mm, -4.4408921e-16mm)
  Box4 [non-model] = box(corner=(-120.6564mm, 127.18946mm, -1mm), size=(65.085026mm, 119.96273mm, 34.194549mm))
  Box5 [non-model] = box(corner=(-246.22777mm, -50mm, -6mm), size=(316.22777mm, 474.34165mm, 5mm))
  group flatwise_10kW = Body1, Body1_1..Body1_5, plate_2, plate_1, Ns1, Ns7, Ns4, Ns8, Ns2, Ns6, Ns5, Ns3, Np1, Np7, Np4, Np8, Np2, Np6, Np5, Np3
boundaries and excitations:
  Opening1: Opening Faces=Region.face(-y) Temperature=AmbientTemp External_Rad._Temperature=AmbientRadTemp Inlet_Type=Pressure Total_Pressure=AmbientPressure
  Opening2: Opening Faces=Region.face(+y) Temperature=AmbientTemp External_Rad._Temperature=AmbientRadTemp Inlet_Type=Velocity Static_Pressure=AmbientPressure X_Velocity=0m_per_sec Y_Velocity=0m_per_sec Z_Velocity=0m_per_sec
  StationaryWall1: Stationary Wall Faces=Box2.face(-z) Thickness=0mm Solid_Material=Al-Extruded External_Condition="Heat Transfer Coefficient" Heat_Flux=0irrad_W_per_m2 Temperature=AmbientTemp Heat_Transfer_Coefficient=50w_per_m2kel Reference_Temperature=AmbientTemp Heat_Transfer_Data{Heat_Transfer_Convection_Type="Forced Convection"} External_Material=Steel-oxidised-surface External_Radiation_Reference_Temperature=AmbientTemp External_Radiation_View_Factor=1
  EMLoss1: EM Loss Objects=[Body1, Body1_1..Body1_5, Ns1, Ns7, Ns4, Ns8, Ns2, Ns6, Ns5, Ns3, Np1, Np7, Np4, Np8, Np2, Np6, Np5, Np3] LinkID=557 Project="This Project*" Product=ElectronicsDesktop Design=Flatwise_10kW Params{freq_hz=28500Hz} ForceSourceToSolve PreservePartnerSoln PathRelativeTo=TargetProject Intrinsics(28.5kHz) LossMultiplier=1
mesh:
  MeshRegions:  Global{MeshMethod=MesherHD ComputeGap MeshRegionResolution=5 MinGapX=1mm MinGapY=1mm MinGapZ=1mm Objects=Region FacetLevel=5 ProximitySizeFunction CurvatureSizeFunction OptimizePCBMesh} MeshRegion1{MeshMethod=MesherHD MeshRegionResolution=5 MinGapX=0.5mm MinGapY=0.5mm MinGapZ=0.5mm Objects=Box4 ProximitySizeFunction CurvatureSizeFunction OptimizePCBMesh} MeshRegion2{MeshMethod=MesherHD MeshRegionResolution=3 MinGapX=1mm MinGapY=1mm MinGapZ=1mm Objects=Box5 ProximitySizeFunction CurvatureSizeFunction OptimizePCBMesh}
  MeshOperations:
setups:
  Setup1: IcepakSteadyState Flow_Regime=Laminar Include_Temperature=true Include_Flow=true Include_Gravity Solution_Initialization_-_Z_Velocity=0.000980665m_per_sec Convergence_Criteria_-_Flow=0.001 Convergence_Criteria_-_Energy=1e-07 Convergence_Criteria_-_Discrete_Ordinates=1e-06 Radiation_Model="Discrete Ordinates Model" Flow_Iteration_Per_Radiation_Iteration=10 ThetaDivision=2 PhiDivision=2 ThetaPixels=2 PhiPixels=2 Under-relaxation_-_Pressure=0.7 Under-relaxation_-_Momentum=0.3 Under-relaxation_-_Temperature=1 Discretization_Scheme_-_Pressure=Standard Discretization_Scheme_-_Momentum=First Discretization_Scheme_-_Temperature=First Discretization_Scheme_-_Discrete_Ordinates=First Convergence_Criteria_-_Max_Iterations=10000

design [Thermal]Edgewise_10kW (Icepak, SteadyState TemperatureAndFlow, model units mm)
options: Default_Fluid_Material=air Default_Solid_Material=Al-Extruded Default_Surface_Material=Steel-oxidised-surface AmbientTemperature=25cel AmbientPressure=0n_per_meter_sq AmbientRadiationTemperature=25cel Gravity_Vector_CS_ID=Global Gravity_Vector_Axis=Z Positive=false SherlockExportDirectory=C:/Users/karlr/Documents/Ansoft/1kW_Final.aedtexport/[Thermal]8turns_3D_CoreLoss_FullInterleaved_Flatwise/ Altitude=0meter
geometry:
  Region [air] = region(percentage_offset: +X=1000, -X=1000, +Y=1000, -Y=1000, +Z=1000, -Z=0)
  Box2 [aluminum] = box(corner=(70mm, -50mm, -1mm), size=(-100 * sqrt(10) mm, 150 * sqrt(10) mm, -5mm))
  Body1 [ferrite - Copy (2)] = imported_body(C:\Users\karlr\Documents\edgewise_10kW.step)
  Body1_1, Body1_2 [aluminum] = imported_body(C:\Users\karlr\Documents\edgewise_10kW.step)
  Body1_3 [ferrite - Copy (2)] = imported_body(C:\Users\karlr\Documents\edgewise_10kW.step)
  Body1_4, Body1_5 [aluminum] = imported_body(C:\Users\karlr\Documents\edgewise_10kW.step)
  plate1, plate2 [silicon - Copy] = imported_body(C:\Users\karlr\Documents\edgewise_10kW.step)
  Ns8, Ns4, Ns1, Ns5, Ns7, Ns3, Ns2, Ns6, Np8, Np4, Np1, Np5, Np7, Np3, Np2, Np6 [copper] = imported_body(C:\Users\karlr\Documents\edgewise_10kW.step)
  [Body1, Body1_1..Body1_5, plate1, plate2, Ns8, Ns4, Ns1, Ns5, Ns7, Ns3, Ns2, Ns6, Np8, Np4, Np1, Np5, Np7, Np3, Np2, Np6].move(77.914054mm, -65.221645mm, -3.6511162mm)
  Box3 [silicon - Copy] = box(corner=(77.914054mm, 40.6334mm, -3.6511162mm), size=(66.389098mm, -121.2668mm, -1mm))
  [Body1, Body1_1..Body1_5, plate1, plate2, Ns8, Ns4, Ns1, Ns5, Ns7, Ns3, Ns2, Ns6, Np8, Np4, Np1, Np5, Np7, Np3, Np2, Np6, Box3].move(-199.22249mm, 207.17082mm, 3.6511162mm)
  Box4 [non-model] = box(corner=(-121.30843mm, 126.53742mm, -9.15934e-14mm), size=(66.389098mm, 121.2668mm, 32.542513mm))
  Box5 [non-model] = box(corner=(-246.22777mm, -50mm, -6mm), size=(316.22777mm, 474.34165mm, 5mm))
  group edgewise_10kW = Body1, Body1_1..Body1_5, plate1, plate2, Ns8, Ns4, Ns1, Ns5, Ns7, Ns3, Ns2, Ns6, Np8, Np4, Np1, Np5, Np7, Np3, Np2, Np6
boundaries and excitations:
  Opening1: Opening Faces=Region.face(-y) Temperature=AmbientTemp External_Rad._Temperature=AmbientRadTemp Inlet_Type=Pressure Total_Pressure=AmbientPressure
  Opening2: Opening Faces=Region.face(+y) Temperature=AmbientTemp External_Rad._Temperature=AmbientRadTemp Inlet_Type=Velocity Static_Pressure=AmbientPressure X_Velocity=0m_per_sec Y_Velocity=0m_per_sec Z_Velocity=0m_per_sec
  StationaryWall1: Stationary Wall Faces=Box2.face(-z) Thickness=0mm Solid_Material=Al-Extruded External_Condition="Heat Transfer Coefficient" Heat_Flux=0irrad_W_per_m2 Temperature=AmbientTemp Heat_Transfer_Coefficient=50w_per_m2kel Reference_Temperature=AmbientTemp Heat_Transfer_Data{Heat_Transfer_Convection_Type="Forced Convection"} External_Material=Steel-oxidised-surface External_Radiation_Reference_Temperature=AmbientTemp External_Radiation_View_Factor=1
  EMLoss1: EM Loss Objects=[Body1, Body1_3, Np1..Np8, Ns1..Ns8, Body1_1, Body1_2, Body1_4, Body1_5] LinkID=530 Project="This Project*" Product=ElectronicsDesktop Design=Edgewise_10kW Params{freq_hz=28500Hz} ForceSourceToSolve PreservePartnerSoln PathRelativeTo=TargetProject Intrinsics(28.5kHz) LossMultiplier=1
mesh:
  MeshRegions:  Global{MeshMethod=MesherHD ComputeGap MeshRegionResolution=5 MinGapX=1mm MinGapY=1mm MinGapZ=1mm Objects=Region FacetLevel=5 ProximitySizeFunction CurvatureSizeFunction OptimizePCBMesh} MeshRegion1{MeshMethod=MesherHD MeshRegionResolution=5 MinGapX=1mm MinGapY=1mm MinGapZ=1mm Objects=Box4 ProximitySizeFunction CurvatureSizeFunction OptimizePCBMesh} MeshRegion2{MeshMethod=MesherHD MeshRegionResolution=3 MinGapX=1mm MinGapY=1mm MinGapZ=1mm Objects=Box5 ProximitySizeFunction CurvatureSizeFunction OptimizePCBMesh}
  MeshOperations:
setups:
  Setup1: IcepakSteadyState Flow_Regime=Laminar Include_Temperature=true Include_Flow=true Include_Gravity Solution_Initialization_-_Z_Velocity=0.000980665m_per_sec Convergence_Criteria_-_Flow=0.001 Convergence_Criteria_-_Energy=1e-07 Convergence_Criteria_-_Discrete_Ordinates=1e-06 Radiation_Model="Discrete Ordinates Model" Flow_Iteration_Per_Radiation_Iteration=10 ThetaDivision=2 PhiDivision=2 ThetaPixels=2 PhiPixels=2 Under-relaxation_-_Pressure=0.7 Under-relaxation_-_Momentum=0.3 Under-relaxation_-_Temperature=1 Discretization_Scheme_-_Pressure=Standard Discretization_Scheme_-_Momentum=First Discretization_Scheme_-_Temperature=First Discretization_Scheme_-_Discrete_Ordinates=First Convergence_Criteria_-_Max_Iterations=10000

design [Thermal]Flatwise_10kW1 (Icepak, SteadyState TemperatureAndFlow, model units mm)
options: Default_Fluid_Material=air Default_Solid_Material=Al-Extruded Default_Surface_Material=Steel-oxidised-surface AmbientTemperature=25cel AmbientPressure=0n_per_meter_sq AmbientRadiationTemperature=25cel Gravity_Vector_CS_ID=Global Gravity_Vector_Axis=Z Positive=false SherlockExportDirectory=C:/Users/karlr/Documents/Ansoft/1kW_Final.aedtexport/[Thermal]8turns_3D_CoreLoss_FullInterleaved_Flatwise/ Altitude=0meter
geometry:
  Region [air] = region(percentage_offset: +X=1000, -X=1000, +Y=1000, -Y=1000, +Z=1000, -Z=0)
  Box2 [aluminum] = box(corner=(70mm, -50mm, -1mm), size=(-100 * sqrt(10) mm, 150 * sqrt(10) mm, -5mm))
  Box2.move(120.6564mm, -141.94918mm, 0mm)
  Box3 [silicon - Copy] = box(corner=(130.17005mm, 59.981365mm, 0mm), size=(-65.085026mm, -119.96273mm, -1mm))
  Box3.move(-185.74142mm, 187.17082mm, -4.4408921e-16mm)
  Box3.move(120.6564mm, -141.94918mm, 0mm)
  Body1 [ferrite - Copy (2)] = imported_body(C:\Users\karlr\Documents\flatwise_10kW.step)
  Body1_1, Body1_2 [aluminum] = imported_body(C:\Users\karlr\Documents\flatwise_10kW.step)
  Body1_3 [ferrite - Copy (2)] = imported_body(C:\Users\karlr\Documents\flatwise_10kW.step)
  Body1_4, Body1_5 [aluminum] = imported_body(C:\Users\karlr\Documents\flatwise_10kW.step)
  plate_2, plate_1 [silicon - Copy] = imported_body(C:\Users\karlr\Documents\flatwise_10kW.step)
  Ns1, Ns7, Ns4, Ns8, Ns2, Ns6, Ns5, Ns3, Np1, Np7, Np4, Np8, Np2, Np6, Np5, Np3 [copper] = imported_body(C:\Users\karlr\Documents\flatwise_10kW.step)
  Box4 [non-model] = box(corner=(-8.2156504e-13mm, -14.759719mm, -1mm), size=(65.085026mm, 119.96273mm, 34.194549mm))
  Box5 [non-model] = box(corner=(-125.57137mm, -191.94918mm, -6mm), size=(316.22777mm, 474.34165mm, 5mm))
  Rectangle1 [Al-Extruded, non-model] = rectangle(corner=(0mm, 45.221645mm, 0mm), z_size=33.194549mm, x_size=65.085026mm)
  group flatwise_10kW = Body1, Body1_1..Body1_5, plate_2, plate_1, Ns1, Ns7, Ns4, Ns8, Ns2, Ns6, Ns5, Ns3, Np1, Np7, Np4, Np8, Np2, Np6, Np5, Np3
boundaries and excitations:
  Opening1: Opening Faces=Region.face(-y) Temperature=AmbientTemp External_Rad._Temperature=AmbientRadTemp Inlet_Type=Pressure Total_Pressure=AmbientPressure
  Opening2: Opening Faces=Region.face(+y) Temperature=AmbientTemp External_Rad._Temperature=AmbientRadTemp Inlet_Type=Velocity Static_Pressure=AmbientPressure X_Velocity=0m_per_sec Y_Velocity=0m_per_sec Z_Velocity=0m_per_sec
  StationaryWall1: Stationary Wall Faces=Box2.face(-z) Thickness=0mm Solid_Material=Al-Extruded External_Condition="Heat Transfer Coefficient" Heat_Flux=0irrad_W_per_m2 Temperature=AmbientTemp Heat_Transfer_Coefficient=50w_per_m2kel Reference_Temperature=AmbientTemp Heat_Transfer_Data{Heat_Transfer_Convection_Type="Forced Convection"} External_Material=Steel-oxidised-surface External_Radiation_Reference_Temperature=AmbientTemp External_Radiation_View_Factor=1
  EMLoss1: EM Loss Objects=[Body1_1, Body1_2, Body1_4, Body1_5, Np1..Np8, Ns1..Ns8, Body1, Body1_3] LinkID=572 Project="This Project*" Product=ElectronicsDesktop Design=Flatwise_10kW Params{freq_hz=28500Hz} ForceSourceToSolve PreservePartnerSoln PathRelativeTo=TargetProject Intrinsics(28.5kHz) LossMultiplier=1
mesh:
  MeshRegions:  Global{MeshMethod=MesherHD ComputeGap MeshRegionResolution=5 MinGapX=1mm MinGapY=1mm MinGapZ=1mm Objects=Region FacetLevel=5 ProximitySizeFunction CurvatureSizeFunction OptimizePCBMesh} MeshRegion1{MeshMethod=MesherHD MeshRegionResolution=5 MinGapX=1mm MinGapY=1mm MinGapZ=1mm Objects=Box4 ProximitySizeFunction CurvatureSizeFunction OptimizePCBMesh} MeshRegion2{MeshMethod=MesherHD MeshRegionResolution=3 MinGapX=1mm MinGapY=1mm MinGapZ=1mm Objects=Box5 ProximitySizeFunction CurvatureSizeFunction OptimizePCBMesh}
  MeshOperations:
setups:
  Setup1: IcepakSteadyState Flow_Regime=Laminar Include_Temperature=true Include_Flow=true Include_Gravity Solution_Initialization_-_Z_Velocity=0.000980665m_per_sec Convergence_Criteria_-_Flow=0.001 Convergence_Criteria_-_Energy=1e-07 Convergence_Criteria_-_Discrete_Ordinates=1e-06 Radiation_Model="Discrete Ordinates Model" Flow_Iteration_Per_Radiation_Iteration=10 ThetaDivision=2 PhiDivision=2 ThetaPixels=2 PhiPixels=2 Under-relaxation_-_Pressure=0.7 Under-relaxation_-_Momentum=0.3 Under-relaxation_-_Temperature=1 Discretization_Scheme_-_Pressure=Standard Discretization_Scheme_-_Momentum=First Discretization_Scheme_-_Temperature=First Discretization_Scheme_-_Discrete_Ordinates=First Convergence_Criteria_-_Max_Iterations=10000
field plots:
  Temperature1: Temperature over Body1, Body1_1..Body1_5, plate_2, plate_1, Ns1, Ns7, Ns4, Ns8, Ns2, Ns6, Ns5, Ns3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 on Setup1 : SteadyState
  Temperature2: Temperature over a plane on Setup1 : SteadyState

design [Thermal]Edgewise_10kW1 (Icepak, SteadyState TemperatureAndFlow, model units mm)
options: Default_Fluid_Material=air Default_Solid_Material=Al-Extruded Default_Surface_Material=Steel-oxidised-surface AmbientTemperature=25cel AmbientPressure=0n_per_meter_sq AmbientRadiationTemperature=25cel Gravity_Vector_CS_ID=Global Gravity_Vector_Axis=Z Positive=false SherlockExportDirectory=C:/Users/karlr/Documents/Ansoft/1kW_Final.aedtexport/[Thermal]8turns_3D_CoreLoss_FullInterleaved_Flatwise/ Altitude=0meter
geometry:
  Region [air] = region(percentage_offset: +X=1000, -X=1000, +Y=1000, -Y=1000, +Z=1000, -Z=0)
  Box2 [aluminum] = box(corner=(70mm, -50mm, -1mm), size=(-100 * sqrt(10) mm, 150 * sqrt(10) mm, -5mm))
  Box3 [silicon - Copy] = box(corner=(77.914054mm, 40.6334mm, -3.6511162mm), size=(66.389098mm, -121.2668mm, -1mm))
  Box3.move(-199.22249mm, 207.17082mm, 3.6511162mm)
  Body1 [ferrite - Copy (2)] = imported_body(C:\Users\karlr\Documents\edgewise_10kW.step)
  Body1_1, Body1_2 [aluminum] = imported_body(C:\Users\karlr\Documents\edgewise_10kW.step)
  Body1_3 [ferrite - Copy (2)] = imported_body(C:\Users\karlr\Documents\edgewise_10kW.step)
  Body1_4, Body1_5 [aluminum] = imported_body(C:\Users\karlr\Documents\edgewise_10kW.step)
  plate1, plate2 [silicon - Copy] = imported_body(C:\Users\karlr\Documents\edgewise_10kW.step)
  Ns8, Ns4, Ns1, Ns5, Ns7, Ns3, Ns2, Ns6, Np8, Np4, Np1, Np5, Np7, Np3, Np2, Np6 [copper] = imported_body(C:\Users\karlr\Documents\edgewise_10kW.step)
  [Box3, Box2].move(121.30843mm, -141.94918mm, 0mm)
  Box4 [non-model] = box(corner=(-7.7715612e-12mm, -15.411755mm, -1mm), size=(66.389098mm, 121.2668mm, 33.542513mm))
  Box5 [non-model] = box(corner=(-124.91933mm, -191.94918mm, -6mm), size=(316.22777mm, 474.34165mm, 5mm))
  group edgewise_10kW = Body1, Body1_1..Body1_5, plate1, plate2, Ns8, Ns4, Ns1, Ns5, Ns7, Ns3, Ns2, Ns6, Np8, Np4, Np1, Np5, Np7, Np3, Np2, Np6
boundaries and excitations:
  Opening1: Opening Faces=Region.face(-y) Temperature=AmbientTemp External_Rad._Temperature=AmbientRadTemp Inlet_Type=Pressure Total_Pressure=AmbientPressure
  Opening2: Opening Faces=Region.face(+y) Temperature=AmbientTemp External_Rad._Temperature=AmbientRadTemp Inlet_Type=Velocity Static_Pressure=AmbientPressure X_Velocity=0m_per_sec Y_Velocity=0m_per_sec Z_Velocity=0m_per_sec
  StationaryWall1: Stationary Wall Faces=Box2.face(-z) Thickness=0mm Solid_Material=Al-Extruded External_Condition="Heat Transfer Coefficient" Heat_Flux=0irrad_W_per_m2 Temperature=AmbientTemp Heat_Transfer_Coefficient=50w_per_m2kel Reference_Temperature=AmbientTemp Heat_Transfer_Data{Heat_Transfer_Convection_Type="Forced Convection"} External_Material=Steel-oxidised-surface External_Radiation_Reference_Temperature=AmbientTemp External_Radiation_View_Factor=1
mesh:
  MeshRegions:  Global{MeshMethod=MesherHD ComputeGap MeshRegionResolution=5 MinGapX=1mm MinGapY=1mm MinGapZ=1mm Objects=Region FacetLevel=5 ProximitySizeFunction CurvatureSizeFunction OptimizePCBMesh} MeshRegion1{MeshMethod=MesherHD MeshRegionResolution=5 MinGapX=1mm MinGapY=1mm MinGapZ=1mm Objects=Box4 ProximitySizeFunction CurvatureSizeFunction OptimizePCBMesh} MeshRegion2{MeshMethod=MesherHD MeshRegionResolution=3 MinGapX=1mm MinGapY=1mm MinGapZ=1mm Objects=Box5 ProximitySizeFunction CurvatureSizeFunction OptimizePCBMesh}
  MeshOperations:
setups:
  Setup1: IcepakSteadyState Flow_Regime=Laminar Include_Temperature=true Include_Flow=true Include_Gravity Solution_Initialization_-_Z_Velocity=0.000980665m_per_sec Convergence_Criteria_-_Flow=0.001 Convergence_Criteria_-_Energy=1e-07 Convergence_Criteria_-_Discrete_Ordinates=1e-06 Radiation_Model="Discrete Ordinates Model" Flow_Iteration_Per_Radiation_Iteration=10 ThetaDivision=2 PhiDivision=2 ThetaPixels=2 PhiPixels=2 Under-relaxation_-_Pressure=0.7 Under-relaxation_-_Momentum=0.3 Under-relaxation_-_Temperature=1 Discretization_Scheme_-_Pressure=Standard Discretization_Scheme_-_Momentum=First Discretization_Scheme_-_Temperature=First Discretization_Scheme_-_Discrete_Ordinates=First Convergence_Criteria_-_Max_Iterations=10000
field plots:
  Temperature1: Temperature over Body1_1, Body1_2, Body1_4, Body1_5, plate1, plate2, Body1, Body1_3, Np1..Np8, Ns1..Ns8 on Setup1 : SteadyState

design [Thermal]Flatwise_10kW_coldplate (Icepak, SteadyState TemperatureAndFlow, model units mm)
options: Default_Fluid_Material=air Default_Solid_Material=Al-Extruded Default_Surface_Material=Steel-oxidised-surface AmbientTemperature=25cel AmbientPressure=0n_per_meter_sq AmbientRadiationTemperature=25cel Gravity_Vector_CS_ID=Global Gravity_Vector_Axis=Z Positive=false SherlockExportDirectory=C:/Users/karlr/Documents/Ansoft/1kW_Final.aedtexport/[Thermal]8turns_3D_CoreLoss_FullInterleaved_Flatwise/ Altitude=0meter
geometry:
  Region [air] = region(percentage_offset: +X=1000, -X=1000, +Y=1000, -Y=1000, +Z=1000, -Z=0)
  Box3 [silicon - Copy] = box(corner=(130.17005mm, 59.981365mm, 0mm), size=(-65.085026mm, -119.96273mm, -1mm))
  Box3.move(-185.74142mm, 187.17082mm, -4.4408921e-16mm)
  Box3.move(120.6564mm, -141.94918mm, 0mm)
  Body1 [ferrite - Copy (2)] = imported_body(C:\Users\karlr\Documents\flatwise_10kW.step)
  Body1_1, Body1_2 [aluminum] = imported_body(C:\Users\karlr\Documents\flatwise_10kW.step)
  Body1_3 [ferrite - Copy (2)] = imported_body(C:\Users\karlr\Documents\flatwise_10kW.step)
  Body1_4, Body1_5 [aluminum] = imported_body(C:\Users\karlr\Documents\flatwise_10kW.step)
  plate_2, plate_1 [silicon - Copy] = imported_body(C:\Users\karlr\Documents\flatwise_10kW.step)
  Ns1, Ns7, Ns4, Ns8, Ns2, Ns6, Ns5, Ns3, Np1, Np7, Np4, Np8, Np2, Np6, Np5, Np3 [copper] = imported_body(C:\Users\karlr\Documents\flatwise_10kW.step)
  Box4 [non-model] = box(corner=(-8.2156504e-13mm, -14.759719mm, -1mm), size=(65.085026mm, 119.96273mm, 34.194549mm))
  Rectangle1 [Al-Extruded, non-model] = rectangle(corner=(0mm, 45.221645mm, 0mm), z_size=33.194549mm, x_size=65.085026mm)
  group flatwise_10kW = Body1, Body1_1..Body1_5, plate_2, plate_1, Ns1, Ns7, Ns4, Ns8, Ns2, Ns6, Ns5, Ns3, Np1, Np7, Np4, Np8, Np2, Np6, Np5, Np3
boundaries and excitations:
  Opening1: Opening Faces=Region.face(-y) Temperature=AmbientTemp External_Rad._Temperature=AmbientRadTemp Inlet_Type=Pressure Total_Pressure=AmbientPressure
  Opening2: Opening Faces=Region.face(+y) Temperature=AmbientTemp External_Rad._Temperature=AmbientRadTemp Inlet_Type=Velocity Static_Pressure=AmbientPressure X_Velocity=0m_per_sec Y_Velocity=0m_per_sec Z_Velocity=0m_per_sec
  EMLoss1: EM Loss Objects=[Body1_1, Body1_2, Body1_4, Body1_5, Np1..Np8, Ns1..Ns8, Body1, Body1_3] LinkID=572 Project="This Project*" Product=ElectronicsDesktop Design=Flatwise_10kW Params{freq_hz=28500Hz} ForceSourceToSolve PreservePartnerSoln PathRelativeTo=TargetProject Intrinsics(28.5kHz) LossMultiplier=1
  StationaryWall1: Stationary Wall Faces=Box3.face(-z) Thickness=0mm Solid_Material=Al-Extruded External_Condition=Temperature Heat_Flux=0irrad_W_per_m2 Temperature=20cel Heat_Transfer_Coefficient=0w_per_m2kel Reference_Temperature=AmbientTemp Heat_Transfer_Data{Heat_Transfer_Convection_Type="Forced Convection"} External_Material=Steel-oxidised-surface External_Radiation_Reference_Temperature=AmbientTemp External_Radiation_View_Factor=1
mesh:
  MeshRegions:  Global{MeshMethod=MesherHD ComputeGap MeshRegionResolution=5 MinGapX=1mm MinGapY=1mm MinGapZ=1mm Objects=Region FacetLevel=5 ProximitySizeFunction CurvatureSizeFunction OptimizePCBMesh} MeshRegion1{MeshMethod=MesherHD MeshRegionResolution=5 MinGapX=0.3mm MinGapY=0.3mm MinGapZ=0.3mm Objects=Box4 ProximitySizeFunction CurvatureSizeFunction OptimizePCBMesh}
  MeshOperations:
setups:
  Setup1: IcepakSteadyState Flow_Regime=Laminar Include_Temperature=true Include_Flow=true Include_Gravity Solution_Initialization_-_Z_Velocity=0.000980665m_per_sec Convergence_Criteria_-_Flow=0.001 Convergence_Criteria_-_Energy=1e-07 Convergence_Criteria_-_Discrete_Ordinates=1e-06 Radiation_Model="Discrete Ordinates Model" Flow_Iteration_Per_Radiation_Iteration=10 ThetaDivision=2 PhiDivision=2 ThetaPixels=2 PhiPixels=2 Under-relaxation_-_Pressure=0.7 Under-relaxation_-_Momentum=0.3 Under-relaxation_-_Temperature=1 Discretization_Scheme_-_Pressure=Standard Discretization_Scheme_-_Momentum=First Discretization_Scheme_-_Temperature=First Discretization_Scheme_-_Discrete_Ordinates=First Convergence_Criteria_-_Max_Iterations=1000
field plots:
  Temperature1: Temperature over Body1, Body1_1..Body1_5, plate_2, plate_1, Ns1, Ns7, Ns4, Ns8, Ns2, Ns6, Ns5, Ns3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 on Setup1 : SteadyState
  Temperature2: Temperature over a plane on Setup1 : SteadyState

design [Thermal]Edgewise_10kW_coldplate (Icepak, SteadyState TemperatureAndFlow, model units mm)
options: Default_Fluid_Material=air Default_Solid_Material=Al-Extruded Default_Surface_Material=Steel-oxidised-surface AmbientTemperature=25cel AmbientPressure=0n_per_meter_sq AmbientRadiationTemperature=25cel Gravity_Vector_CS_ID=Global Gravity_Vector_Axis=Z Positive=false SherlockExportDirectory=C:/Users/karlr/Documents/Ansoft/1kW_Final.aedtexport/[Thermal]8turns_3D_CoreLoss_FullInterleaved_Flatwise/ Altitude=0meter
geometry:
  Region [air] = region(percentage_offset: +X=1000, -X=1000, +Y=1000, -Y=1000, +Z=1000, -Z=0)
  Box3 [silicon - Copy] = box(corner=(77.914054mm, 40.6334mm, -3.6511162mm), size=(66.389098mm, -121.2668mm, -1mm))
  Box3.move(-199.22249mm, 207.17082mm, 3.6511162mm)
  Body1 [ferrite - Copy (2)] = imported_body(C:\Users\karlr\Documents\edgewise_10kW.step)
  Body1_1, Body1_2 [aluminum] = imported_body(C:\Users\karlr\Documents\edgewise_10kW.step)
  Body1_3 [ferrite - Copy (2)] = imported_body(C:\Users\karlr\Documents\edgewise_10kW.step)
  Body1_4, Body1_5 [aluminum] = imported_body(C:\Users\karlr\Documents\edgewise_10kW.step)
  plate1, plate2 [silicon - Copy] = imported_body(C:\Users\karlr\Documents\edgewise_10kW.step)
  Ns8, Ns4, Ns1, Ns5, Ns7, Ns3, Ns2, Ns6, Np8, Np4, Np1, Np5, Np7, Np3, Np2, Np6 [copper] = imported_body(C:\Users\karlr\Documents\edgewise_10kW.step)
  Box3.move(121.30843mm, -141.94918mm, 0mm)
  Box4 [non-model] = box(corner=(-7.7715612e-12mm, -15.411755mm, -1mm), size=(66.389098mm, 121.2668mm, 33.542513mm))
  Rectangle1 [Al-Extruded, non-model] = rectangle(corner=(0mm, 45.221645mm, 0mm), z_size=32.542513mm, x_size=66.389098mm)
  group edgewise_10kW = Body1, Body1_1..Body1_5, plate1, plate2, Ns8, Ns4, Ns1, Ns5, Ns7, Ns3, Ns2, Ns6, Np8, Np4, Np1, Np5, Np7, Np3, Np2, Np6
boundaries and excitations:
  Opening1: Opening Faces=Region.face(-y) Temperature=AmbientTemp External_Rad._Temperature=AmbientRadTemp Inlet_Type=Pressure Total_Pressure=AmbientPressure
  Opening2: Opening Faces=Region.face(+y) Temperature=AmbientTemp External_Rad._Temperature=AmbientRadTemp Inlet_Type=Velocity Static_Pressure=AmbientPressure X_Velocity=0m_per_sec Y_Velocity=0m_per_sec Z_Velocity=0m_per_sec
  StationaryWall1: Stationary Wall Faces=Box3.face(-z) Thickness=0mm Solid_Material=Al-Extruded External_Condition=Temperature Heat_Flux=0irrad_W_per_m2 Temperature=20cel Heat_Transfer_Coefficient=0w_per_m2kel Reference_Temperature=AmbientTemp Heat_Transfer_Data{Heat_Transfer_Convection_Type="Forced Convection"} External_Material=Steel-oxidised-surface External_Radiation_Reference_Temperature=AmbientTemp External_Radiation_View_Factor=1
  EMLoss1: EM Loss Objects=[Body1_1, Body1_2, Body1_4, Body1_5, Np1..Np8, Ns1..Ns8, Body1, Body1_3] LinkID=621 Project="This Project*" Product=ElectronicsDesktop Design=Edgewise_10kW Params{freq_hz=28500Hz} ForceSourceToSolve PreservePartnerSoln PathRelativeTo=TargetProject Intrinsics(28.5kHz) LossMultiplier=1
mesh:
  MeshRegions:  Global{MeshMethod=MesherHD ComputeGap MeshRegionResolution=5 MinGapX=1mm MinGapY=1mm MinGapZ=1mm Objects=Region FacetLevel=5 ProximitySizeFunction CurvatureSizeFunction OptimizePCBMesh} MeshRegion1{MeshMethod=MesherHD UserSpecifiedSettings MaxElementSizeX=0.3mm MaxElementSizeY=0.3mm MaxElementSizeZ=0.3mm MinElementsInGap=3 MinElementsOnEdge=2 MaxSizeRatio=2 EnableMLM EnforeMLMType=3D MaxLevels=0 BufferLayers=0 UniformMeshParametersType=Average 2DMLMType=2DMLM_None MinGapX=0.3mm MinGapY=0.3mm MinGapZ=0.3mm Objects=Box4 ProximitySizeFunction CurvatureSizeFunction OptimizePCBMesh}
  MeshOperations:
setups:
  Setup1: IcepakSteadyState Flow_Regime=Laminar Include_Temperature=true Include_Flow=true Include_Gravity Solution_Initialization_-_Z_Velocity=0.000980665m_per_sec Convergence_Criteria_-_Flow=0.001 Convergence_Criteria_-_Energy=1e-07 Convergence_Criteria_-_Discrete_Ordinates=1e-06 Radiation_Model="Discrete Ordinates Model" Flow_Iteration_Per_Radiation_Iteration=10 ThetaDivision=2 PhiDivision=2 ThetaPixels=2 PhiPixels=2 Under-relaxation_-_Pressure=0.7 Under-relaxation_-_Momentum=0.3 Under-relaxation_-_Temperature=1 Discretization_Scheme_-_Pressure=Standard Discretization_Scheme_-_Momentum=First Discretization_Scheme_-_Temperature=First Discretization_Scheme_-_Discrete_Ordinates=First Convergence_Criteria_-_Max_Iterations=1000
field plots:
  Temperature1: Temperature over Body1_1, Body1_2, Body1_4, Body1_5, plate1, plate2, Body1, Body1_3, Np1..Np8, Ns1..Ns8 on Setup1 : SteadyState
  Temperature2: Temperature over a plane on Setup1 : SteadyState

design [Thermal]Flatwise_10kW_coldplate1 (Icepak, SteadyState TemperatureAndFlow, model units mm)
options: Default_Fluid_Material=air Default_Solid_Material=Al-Extruded Default_Surface_Material=Steel-oxidised-surface AmbientTemperature=25cel AmbientPressure=0n_per_meter_sq AmbientRadiationTemperature=25cel Gravity_Vector_CS_ID=Global Gravity_Vector_Axis=Z Positive=false SherlockExportDirectory=C:/Users/karlr/Documents/Ansoft/1kW_Final.aedtexport/[Thermal]8turns_3D_CoreLoss_FullInterleaved_Flatwise/ Altitude=0meter
geometry:
  Region [air] = region(percentage_offset: +X=1000, -X=1000, +Y=1000, -Y=1000, +Z=1000, -Z=0)
  Box3 [silicon - Copy] = box(corner=(130.17005mm, 59.981365mm, 0mm), size=(-65.085026mm, -119.96273mm, -1mm))
  Box3.move(-185.74142mm, 187.17082mm, -4.4408921e-16mm)
  Box3.move(120.6564mm, -141.94918mm, 0mm)
  Body1 [ferrite - Copy (2)] = imported_body(C:\Users\karlr\Documents\flatwise_10kW.step)
  Body1_1, Body1_2 [aluminum] = imported_body(C:\Users\karlr\Documents\flatwise_10kW.step)
  Body1_3 [ferrite - Copy (2)] = imported_body(C:\Users\karlr\Documents\flatwise_10kW.step)
  Body1_4, Body1_5 [aluminum] = imported_body(C:\Users\karlr\Documents\flatwise_10kW.step)
  plate_2, plate_1 [silicon - Copy] = imported_body(C:\Users\karlr\Documents\flatwise_10kW.step)
  Ns1, Ns7, Ns4, Ns8, Ns2, Ns6, Ns5, Ns3, Np1, Np7, Np4, Np8, Np2, Np6, Np5, Np3 [copper] = imported_body(C:\Users\karlr\Documents\flatwise_10kW.step)
  Box4 [non-model] = box(corner=(-8.2156504e-13mm, -14.759719mm, -1mm), size=(65.085026mm, 119.96273mm, 34.194549mm))
  Rectangle1 [Al-Extruded, non-model] = rectangle(corner=(0mm, 45.221645mm, 0mm), z_size=33.194549mm, x_size=65.085026mm)
  group flatwise_10kW = Body1, Body1_1..Body1_5, plate_2, plate_1, Ns1, Ns7, Ns4, Ns8, Ns2, Ns6, Ns5, Ns3, Np1, Np7, Np4, Np8, Np2, Np6, Np5, Np3
boundaries and excitations:
  Opening1: Opening Faces=Region.face(-y) Temperature=AmbientTemp External_Rad._Temperature=AmbientRadTemp Inlet_Type=Pressure Total_Pressure=AmbientPressure
  Opening2: Opening Faces=Region.face(+y) Temperature=AmbientTemp External_Rad._Temperature=AmbientRadTemp Inlet_Type=Velocity Static_Pressure=AmbientPressure X_Velocity=0m_per_sec Y_Velocity=0m_per_sec Z_Velocity=0m_per_sec
  EMLoss1: EM Loss Objects=[Body1_1, Body1_2, Body1_4, Body1_5, Np1..Np8, Ns1..Ns8, Body1, Body1_3] LinkID=572 Project="This Project*" Product=ElectronicsDesktop Design=Flatwise_10kW Params{freq_hz=28500Hz} ForceSourceToSolve PreservePartnerSoln PathRelativeTo=TargetProject Intrinsics(28.5kHz) LossMultiplier=1
  StationaryWall2: Stationary Wall Faces=Box3.face(-z) Thickness=0mm Solid_Material=Al-Extruded External_Condition=Temperature Heat_Flux=0irrad_W_per_m2 Temperature=20cel Heat_Transfer_Coefficient=0w_per_m2kel Reference_Temperature=AmbientTemp Heat_Transfer_Data{Heat_Transfer_Convection_Type="Forced Convection"} External_Material=Steel-oxidised-surface External_Radiation_Reference_Temperature=AmbientTemp External_Radiation_View_Factor=1
mesh:
  MeshRegions:  Global{MeshMethod=MesherHD ComputeGap MeshRegionResolution=5 MinGapX=1mm MinGapY=1mm MinGapZ=1mm Objects=Region FacetLevel=5 ProximitySizeFunction CurvatureSizeFunction OptimizePCBMesh} MeshRegion1{MeshMethod=MesherHD MeshRegionResolution=5 MinGapX=1mm MinGapY=1mm MinGapZ=1mm Objects=Box4 ProximitySizeFunction CurvatureSizeFunction OptimizePCBMesh}
  MeshOperations:
setups:
  Setup1: IcepakSteadyState Flow_Regime=Laminar Include_Temperature=true Include_Flow=true Include_Gravity Solution_Initialization_-_Z_Velocity=0.000980665m_per_sec Convergence_Criteria_-_Flow=0.001 Convergence_Criteria_-_Energy=1e-07 Convergence_Criteria_-_Discrete_Ordinates=1e-06 Radiation_Model="Discrete Ordinates Model" Flow_Iteration_Per_Radiation_Iteration=10 ThetaDivision=2 PhiDivision=2 ThetaPixels=2 PhiPixels=2 Under-relaxation_-_Pressure=0.7 Under-relaxation_-_Momentum=0.3 Under-relaxation_-_Temperature=1 Discretization_Scheme_-_Pressure=Standard Discretization_Scheme_-_Momentum=First Discretization_Scheme_-_Temperature=First Discretization_Scheme_-_Discrete_Ordinates=First Convergence_Criteria_-_Max_Iterations=1000
field plots:
  Temperature1: Temperature over Body1, Body1_1..Body1_5, plate_2, plate_1, Ns1, Ns7, Ns4, Ns8, Ns2, Ns6, Ns5, Ns3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 on Setup1 : SteadyState
  Temperature2: Temperature over a plane on Setup1 : SteadyState

design [Thermal]Flatwise_10kW_coldplate2 (Icepak, SteadyState TemperatureAndFlow, model units mm)
options: Default_Fluid_Material=air Default_Solid_Material=Al-Extruded Default_Surface_Material=Steel-oxidised-surface AmbientTemperature=25cel AmbientPressure=0n_per_meter_sq AmbientRadiationTemperature=25cel Gravity_Vector_CS_ID=Global Gravity_Vector_Axis=Z Positive=false SherlockExportDirectory=C:/Users/karlr/Documents/Ansoft/1kW_Final.aedtexport/[Thermal]8turns_3D_CoreLoss_FullInterleaved_Flatwise/ Altitude=0meter
geometry:
  Region [air] = region(percentage_offset: +X=1000, -X=1000, +Y=1000, -Y=1000, +Z=1000, -Z=0)
  Box3 [silicon - Copy] = box(corner=(130.17005mm, 59.981365mm, 0mm), size=(-65.085026mm, -119.96273mm, -1mm))
  Box3.move(-185.74142mm, 187.17082mm, -4.4408921e-16mm)
  Box3.move(120.6564mm, -141.94918mm, 0mm)
  Box4 [non-model] = box(corner=(-8.2156504e-13mm, -14.759719mm, -1mm), size=(65.085026mm, 119.96273mm, 34.194549mm))
  Rectangle1 [Al-Extruded, non-model] = rectangle(corner=(0mm, 45.221645mm, 0mm), z_size=33.194549mm, x_size=65.085026mm)
  Body1 [ferrite - Copy (2)] = imported_body(C:\Users\karlr\Documents\flatwise_10kW.step)
  Body1_1, Body1_2 [aluminum] = imported_body(C:\Users\karlr\Documents\flatwise_10kW.step)
  Body1_3 [ferrite - Copy (2)] = imported_body(C:\Users\karlr\Documents\flatwise_10kW.step)
  Body1_4, Body1_5 [aluminum] = imported_body(C:\Users\karlr\Documents\flatwise_10kW.step)
  plate_2, plate_1 [silicon - Copy] = imported_body(C:\Users\karlr\Documents\flatwise_10kW.step)
  Ns1, Ns7, Ns4, Ns8, Ns2, Ns6, Ns5, Ns3, Np1, Np7, Np4, Np8, Np2, Np6, Np5, Np3 [copper] = imported_body(C:\Users\karlr\Documents\flatwise_10kW.step)
  group flatwise_10kW = Body1, Body1_1..Body1_5, plate_2, plate_1, Ns1, Ns7, Ns4, Ns8, Ns2, Ns6, Ns5, Ns3, Np1, Np7, Np4, Np8, Np2, Np6, Np5, Np3
boundaries and excitations:
  Opening1: Opening Faces=Region.face(-y) Temperature=AmbientTemp External_Rad._Temperature=AmbientRadTemp Inlet_Type=Pressure Total_Pressure=AmbientPressure
  Opening2: Opening Faces=Region.face(+y) Temperature=AmbientTemp External_Rad._Temperature=AmbientRadTemp Inlet_Type=Velocity Static_Pressure=AmbientPressure X_Velocity=0m_per_sec Y_Velocity=0m_per_sec Z_Velocity=0m_per_sec
  StationaryWall2: Stationary Wall Faces=Box3.face(-z) Thickness=0mm Solid_Material=Al-Extruded External_Condition=Temperature Heat_Flux=0irrad_W_per_m2 Temperature=20cel Heat_Transfer_Coefficient=0w_per_m2kel Reference_Temperature=AmbientTemp Heat_Transfer_Data{Heat_Transfer_Convection_Type="Forced Convection"} External_Material=Steel-oxidised-surface External_Radiation_Reference_Temperature=AmbientTemp External_Radiation_View_Factor=1
  EMLoss1: EM Loss Objects=[Body1_1, Body1_2, Body1_4, Body1_5, Np1..Np8, Ns1..Ns8, Body1, Body1_3] LinkID=685 Project="This Project*" Product=ElectronicsDesktop Design=Flatwise_10kW Params{freq_hz=28500Hz} ForceSourceToSolve PreservePartnerSoln PathRelativeTo=TargetProject Intrinsics(28.5kHz) LossMultiplier=1
mesh:
  MeshRegions:  Global{MeshMethod=MesherHD ComputeGap MeshRegionResolution=5 MinGapX=1mm MinGapY=1mm MinGapZ=1mm Objects=Region FacetLevel=5 ProximitySizeFunction CurvatureSizeFunction OptimizePCBMesh} MeshRegion1{MeshMethod=MesherHD MeshRegionResolution=5 MinGapX=1mm MinGapY=1mm MinGapZ=1mm Objects=Box4 ProximitySizeFunction CurvatureSizeFunction OptimizePCBMesh}
  MeshOperations:
setups:
  Setup1: IcepakSteadyState Flow_Regime=Laminar Include_Temperature=true Include_Flow=true Include_Gravity Solution_Initialization_-_Z_Velocity=0.000980665m_per_sec Convergence_Criteria_-_Flow=0.001 Convergence_Criteria_-_Energy=1e-07 Convergence_Criteria_-_Discrete_Ordinates=1e-06 Radiation_Model="Discrete Ordinates Model" Flow_Iteration_Per_Radiation_Iteration=10 ThetaDivision=2 PhiDivision=2 ThetaPixels=2 PhiPixels=2 Under-relaxation_-_Pressure=0.7 Under-relaxation_-_Momentum=0.3 Under-relaxation_-_Temperature=1 Discretization_Scheme_-_Pressure=Standard Discretization_Scheme_-_Momentum=First Discretization_Scheme_-_Temperature=First Discretization_Scheme_-_Discrete_Ordinates=First Convergence_Criteria_-_Max_Iterations=1000
field plots:
  Temperature2: Temperature over a plane on Setup1 : SteadyState

design [Thermal]Flatwise_100kW_coldplate (Icepak, SteadyState TemperatureAndFlow, model units mm)
options: Default_Fluid_Material=air Default_Solid_Material=Al-Extruded Default_Surface_Material=Steel-oxidised-surface AmbientTemperature=25cel AmbientPressure=0n_per_meter_sq AmbientRadiationTemperature=25cel Gravity_Vector_CS_ID=Global Gravity_Vector_Axis=Z Positive=false SherlockExportDirectory=C:/Users/karlr/Documents/Ansoft/1kW_Final.aedtexport/[Thermal]8turns_3D_CoreLoss_FullInterleaved_Flatwise/ Altitude=0meter
geometry:
  Region [air] = region(percentage_offset: +X=1000, -X=1000, +Y=1000, -Y=1000, +Z=1000, -Z=0)
  Body1 [ferrite - Copy (2)] = imported_body(C:\Users\karlr\Documents\flatwise_100kW.step)
  Body1_1..Body1_4 [aluminum] = imported_body(C:\Users\karlr\Documents\flatwise_100kW.step)
  Body1_5 [ferrite - Copy (2)] = imported_body(C:\Users\karlr\Documents\flatwise_100kW.step)
  plate_2, plate_1 [silicon - Copy] = imported_body(C:\Users\karlr\Documents\flatwise_100kW.step)
  Ns1, Ns7, Ns4, Ns8, Ns2, Ns6, Ns5, Ns3, Np1, Np7, Np4, Np8, Np2, Np6, Np5, Np3 [copper] = imported_body(C:\Users\karlr\Documents\flatwise_100kW.step)
  Box1 [silicon - Copy] = box(corner=(115.73936mm, -26.246905mm, 0mm), size=(-115.73936mm, 213.32725mm, -1mm))
  Box2 [non-model] = box(corner=(-6.2172489e-13mm, -26.246905mm, -1mm), size=(115.73936mm, 213.32725mm, 60.029183mm))
  Rectangle1 [Al-Extruded, non-model] = rectangle(corner=(0mm, 80.416721mm, 0mm), z_size=59.029183mm, x_size=115.73936mm)
  group flatwise_100kW = Body1, Body1_1..Body1_5, plate_2, plate_1, Ns1, Ns7, Ns4, Ns8, Ns2, Ns6, Ns5, Ns3, Np1, Np7, Np4, Np8, Np2, Np6, Np5, Np3
boundaries and excitations:
  Opening1: Opening Faces=Region.face(-y) Temperature=AmbientTemp External_Rad._Temperature=AmbientRadTemp Inlet_Type=Pressure Total_Pressure=AmbientPressure
  Opening2: Opening Faces=Region.face(+y) Temperature=AmbientTemp External_Rad._Temperature=AmbientRadTemp Inlet_Type=Velocity Static_Pressure=AmbientPressure X_Velocity=0m_per_sec Y_Velocity=0m_per_sec Z_Velocity=0m_per_sec
  StationaryWall1: Stationary Wall Faces=Box1.face(-z) Thickness=0mm Solid_Material=Al-Extruded External_Condition=Temperature Heat_Flux=0irrad_W_per_m2 Temperature=20cel Heat_Transfer_Coefficient=0w_per_m2kel Reference_Temperature=AmbientTemp Heat_Transfer_Data{Heat_Transfer_Convection_Type="Forced Convection"} External_Material=Steel-oxidised-surface External_Radiation_Reference_Temperature=AmbientTemp External_Radiation_View_Factor=1
  EMLoss1: EM Loss Objects=[Np1..Np8, Ns1..Ns8, Body1_1..Body1_4, Body1, Body1_5] LinkID=742 Project="This Project*" Product=ElectronicsDesktop Design=Flatwise_100kW Params{freq_hz=28500Hz} ForceSourceToSolve PreservePartnerSoln PathRelativeTo=TargetProject Intrinsics(28.5kHz) LossMultiplier=1
mesh:
  MeshRegions:  Global{MeshMethod=MesherHD ComputeGap MeshRegionResolution=5 MinGapX=1mm MinGapY=1mm MinGapZ=1mm Objects=Region FacetLevel=5 ProximitySizeFunction CurvatureSizeFunction OptimizePCBMesh} MeshRegion1{MeshMethod=MesherHD MeshRegionResolution=5 MinGapX=1mm MinGapY=1mm MinGapZ=1mm Objects=Box2 ProximitySizeFunction CurvatureSizeFunction OptimizePCBMesh}
  MeshOperations:
setups:
  Setup1: IcepakSteadyState Flow_Regime=Laminar Include_Temperature=true Include_Flow=true Include_Gravity Solution_Initialization_-_Z_Velocity=0.000980665m_per_sec Convergence_Criteria_-_Flow=0.001 Convergence_Criteria_-_Energy=1e-07 Convergence_Criteria_-_Discrete_Ordinates=1e-06 Radiation_Model="Discrete Ordinates Model" Flow_Iteration_Per_Radiation_Iteration=10 ThetaDivision=2 PhiDivision=2 ThetaPixels=2 PhiPixels=2 Under-relaxation_-_Pressure=0.7 Under-relaxation_-_Momentum=0.3 Under-relaxation_-_Temperature=1 Discretization_Scheme_-_Pressure=Standard Discretization_Scheme_-_Momentum=First Discretization_Scheme_-_Temperature=First Discretization_Scheme_-_Discrete_Ordinates=First Convergence_Criteria_-_Max_Iterations=1500
field plots:
  Temperature1: Temperature over Body1, Body1_1..Body1_5, plate_2, plate_1, Ns1, Ns7, Ns4, Ns8, Ns2, Ns6, Ns5, Ns3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 on Setup1 : SteadyState
  Temperature2: Temperature over a plane on Setup1 : SteadyState

design [Thermal]Edgewise_100kW_coldplate (Icepak, SteadyState TemperatureAndFlow, model units mm)
options: Default_Fluid_Material=air Default_Solid_Material=Al-Extruded Default_Surface_Material=Steel-oxidised-surface AmbientTemperature=25cel AmbientPressure=0n_per_meter_sq AmbientRadiationTemperature=25cel Gravity_Vector_CS_ID=Global Gravity_Vector_Axis=Z Positive=false SherlockExportDirectory=C:/Users/karlr/Documents/Ansoft/1kW_Final.aedtexport/[Thermal]8turns_3D_CoreLoss_FullInterleaved_Flatwise/ Altitude=0meter
geometry:
  Region [air] = region(percentage_offset: +X=1000, -X=1000, +Y=1000, -Y=1000, +Z=1000, -Z=0)
  Body1 [ferrite - Copy (2)] = imported_body(C:\Users\karlr\Documents\edgewise_100kW.step)
  Body1_1, Body1_2 [aluminum] = imported_body(C:\Users\karlr\Documents\edgewise_100kW.step)
  Body1_3 [ferrite - Copy (2)] = imported_body(C:\Users\karlr\Documents\edgewise_100kW.step)
  Body1_4, Body1_5 [aluminum] = imported_body(C:\Users\karlr\Documents\edgewise_100kW.step)
  plate1, plate2 [silicon - Copy] = imported_body(C:\Users\karlr\Documents\edgewise_100kW.step)
  Ns8 [copper] = imported_body(C:\Users\karlr\Documents\edgewise_100kW.step)
  Ns4 [copper] = imported_body(C:\Users\karlr\Documents\edgewise_100kW.step)
  Ns1 [copper] = imported_body(C:\Users\karlr\Documents\edgewise_100kW.step)
  Ns5 [copper] = imported_body(C:\Users\karlr\Documents\edgewise_100kW.step)
  Ns7 [copper] = imported_body(C:\Users\karlr\Documents\edgewise_100kW.step)
  Ns3 [copper] = imported_body(C:\Users\karlr\Documents\edgewise_100kW.step)
  Ns2 [copper] = imported_body(C:\Users\karlr\Documents\edgewise_100kW.step)
  Ns6 [copper] = imported_body(C:\Users\karlr\Documents\edgewise_100kW.step)
  Np8 [copper] = imported_body(C:\Users\karlr\Documents\edgewise_100kW.step)
  Np4 [copper] = imported_body(C:\Users\karlr\Documents\edgewise_100kW.step)
  Np1 [copper] = imported_body(C:\Users\karlr\Documents\edgewise_100kW.step)
  Np5 [copper] = imported_body(C:\Users\karlr\Documents\edgewise_100kW.step)
  Np7 [copper] = imported_body(C:\Users\karlr\Documents\edgewise_100kW.step)
  Np3 [copper] = imported_body(C:\Users\karlr\Documents\edgewise_100kW.step)
  Np2 [copper] = imported_body(C:\Users\karlr\Documents\edgewise_100kW.step)
  Np6 [copper] = imported_body(C:\Users\karlr\Documents\edgewise_100kW.step)
  Box1 [silicon - Copy] = box(corner=(0mm, 188.23985mm, 0mm), size=(118.05837mm, -215.64625mm, -1mm))
  Box2 [non-model] = box(corner=(-6.8167694e-12mm, -27.406406mm, -1mm), size=(118.05837mm, 215.64625mm, 58.869681mm))
  Rectangle1 [Al-Extruded, non-model] = rectangle(corner=(0mm, 80.416721mm, 0mm), z_size=57.869681mm, x_size=118.05837mm)
  group edgewise_100kW = Body1, Body1_1..Body1_5, plate1, plate2, Ns8, Ns4, Ns1, Ns5, Ns7, Ns3, Ns2, Ns6, Np8, Np4, Np1, Np5, Np7, Np3, Np2, Np6
boundaries and excitations:
  Opening1: Opening Faces=Region.face(-y) Temperature=AmbientTemp External_Rad._Temperature=AmbientRadTemp Inlet_Type=Pressure Total_Pressure=AmbientPressure
  Opening2: Opening Faces=Region.face(+y) Temperature=AmbientTemp External_Rad._Temperature=AmbientRadTemp Inlet_Type=Velocity Static_Pressure=AmbientPressure X_Velocity=0m_per_sec Y_Velocity=0m_per_sec Z_Velocity=0m_per_sec
  StationaryWall1: Stationary Wall Faces=Box1.face(-z) Thickness=0mm Solid_Material=Al-Extruded External_Condition=Temperature Heat_Flux=0irrad_W_per_m2 Temperature=20cel Heat_Transfer_Coefficient=0w_per_m2kel Reference_Temperature=AmbientTemp Heat_Transfer_Data{Heat_Transfer_Convection_Type="Forced Convection"} External_Material=Steel-oxidised-surface External_Radiation_Reference_Temperature=AmbientTemp External_Radiation_View_Factor=1
  EMLoss1: EM Loss Objects=[Body1_1, Body1_2, Body1_4, Body1_5, Np1..Np8, Ns1..Ns8, Body1, Body1_3] LinkID=759 Project="This Project*" Product=ElectronicsDesktop Design=Edgewise_100kW Params{freq_hz=28500Hz} ForceSourceToSolve PreservePartnerSoln PathRelativeTo=TargetProject Intrinsics(28.5kHz) LossMultiplier=1
mesh:
  MeshRegions:  Global{MeshMethod=MesherHD ComputeGap MeshRegionResolution=5 MinGapX=1mm MinGapY=1mm MinGapZ=1mm Objects=Region FacetLevel=5 ProximitySizeFunction CurvatureSizeFunction OptimizePCBMesh} MeshRegion1{MeshMethod=MesherHD UserSpecifiedSettings MaxElementSizeX=0.6mm MaxElementSizeY=0.6mm MaxElementSizeZ=0.6mm MinElementsInGap=3 MinElementsOnEdge=2 MaxSizeRatio=2 EnableMLM EnforeMLMType=3D MaxLevels=0 BufferLayers=0 UniformMeshParametersType=Average 2DMLMType=2DMLM_None MinGapX=0.6mm MinGapY=0.6mm MinGapZ=0.6mm Objects=Box2 ProximitySizeFunction CurvatureSizeFunction OptimizePCBMesh}
  MeshOperations:
setups:
  Setup1: IcepakSteadyState Flow_Regime=Laminar Include_Temperature=true Include_Flow=true Include_Gravity Solution_Initialization_-_Z_Velocity=0.000980665m_per_sec Convergence_Criteria_-_Flow=0.001 Convergence_Criteria_-_Energy=1e-07 Convergence_Criteria_-_Discrete_Ordinates=1e-06 Radiation_Model="Discrete Ordinates Model" Flow_Iteration_Per_Radiation_Iteration=10 ThetaDivision=2 PhiDivision=2 ThetaPixels=2 PhiPixels=2 Under-relaxation_-_Pressure=0.7 Under-relaxation_-_Momentum=0.3 Under-relaxation_-_Temperature=1 Discretization_Scheme_-_Pressure=Standard Discretization_Scheme_-_Momentum=First Discretization_Scheme_-_Temperature=First Discretization_Scheme_-_Discrete_Ordinates=First Convergence_Criteria_-_Max_Iterations=1500
field plots:
  Temperature1: Temperature over Body1, Body1_1..Body1_5, plate1, plate2, Ns8, Ns4, Ns1, Ns5, Ns7, Ns3, Ns2, Ns6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 on Setup1 : SteadyState
  Temperature2: Temperature over a plane on Setup1 : SteadyState

design [Thermal]Edgewise_0.3_fix_coldplate2 (Icepak, SteadyState TemperatureAndFlow, model units mm)
options: Default_Fluid_Material=air Default_Solid_Material=Al-Extruded Default_Surface_Material=Steel-oxidised-surface AmbientTemperature=25cel AmbientPressure=0n_per_meter_sq AmbientRadiationTemperature=25cel Gravity_Vector_CS_ID=Global Gravity_Vector_Axis=Z Positive=false SherlockExportDirectory=C:/Users/karlr/Documents/Ansoft/1kW_Final.aedtexport/[Thermal]8turns_3D_CoreLoss_FullInterleaved_Flatwise/ Altitude=0meter
geometry:
  Region [air] = region(percentage_offset: +X=1000, -X=1000, +Y=1000, -Y=1000, +Z=1000, -Z=0)
  Rectangle1 [Al-Extruded, non-model] = rectangle(corner=(37.333333mm, 25.43mm, 0mm), z_size=18.3mm, x_size=-37.333333mm)
  Body1 [ferrite - Copy (2)] = imported_body(C:\Karl\APEC + IPEC\core_assembled_edgewise.step)
  Body1_1, Body1_2 [aluminum] = imported_body(C:\Karl\APEC + IPEC\core_assembled_edgewise.step)
  Body1_3 [ferrite - Copy (2)] = imported_body(C:\Karl\APEC + IPEC\core_assembled_edgewise.step)
  Body1_4, Body1_5 [aluminum] = imported_body(C:\Karl\APEC + IPEC\core_assembled_edgewise.step)
  plate1, plate2 [silicon - Copy] = imported_body(C:\Karl\APEC + IPEC\core_assembled_edgewise.step)
  Ns8, Ns4, Ns1, Ns5, Ns7, Ns3, Ns2, Ns6, Np8, Np4, Np1, Np5, Np7, Np3, Np2, Np6 [copper] = imported_body(C:\Karl\APEC + IPEC\core_assembled_edgewise.step)
  Box1 [silicon - Copy] = box(corner=(37.333333mm, -8.6666667mm, 1.6666612e-08mm), size=(-37.333333mm, 68.193333mm, -1mm))
  group core_assembled_edgewise = Body1, Body1_1..Body1_5, plate1, plate2, Ns8, Ns4, Ns1, Ns5, Ns7, Ns3, Ns2, Ns6, Np8, Np4, Np1, Np5, Np7, Np3, Np2, Np6
boundaries and excitations:
  Opening1: Opening Faces=Region.face(-y) Temperature=AmbientTemp External_Rad._Temperature=AmbientRadTemp Inlet_Type=Pressure Total_Pressure=AmbientPressure
  Opening2: Opening Faces=Region.face(+y) Temperature=AmbientTemp External_Rad._Temperature=AmbientRadTemp Inlet_Type=Velocity Static_Pressure=AmbientPressure X_Velocity=0m_per_sec Y_Velocity=0m_per_sec Z_Velocity=0m_per_sec
  StationaryWall1: Stationary Wall Faces=Box1.face(-z) Thickness=0mm Solid_Material=Al-Extruded External_Condition=Temperature Heat_Flux=0irrad_W_per_m2 Temperature=20cel Heat_Transfer_Coefficient=0w_per_m2kel Reference_Temperature=AmbientTemp Heat_Transfer_Data{Heat_Transfer_Convection_Type="Forced Convection"} External_Material=Steel-oxidised-surface External_Radiation_Reference_Temperature=AmbientTemp External_Radiation_View_Factor=1
  EMLoss1: EM Loss Objects=[Body1_1, Body1_2, Body1_4, Body1_5, Np1..Np8, Ns1..Ns8, Body1, Body1_3] LinkID=668 Project="This Project*" Product=ElectronicsDesktop Design=Edgewise_0.3_interleaved_full Params{freq_hz=28500Hz} ForceSourceToSolve PreservePartnerSoln PathRelativeTo=TargetProject Intrinsics(28.5kHz) LossMultiplier=1
mesh:
  MeshRegions:  Global{MeshMethod=MesherHD ComputeGap MeshRegionResolution=5 MinGapX=1mm MinGapY=1mm MinGapZ=1mm Objects=Region FacetLevel=5 ProximitySizeFunction CurvatureSizeFunction OptimizePCBMesh}
  MeshOperations:
setups:
  Setup1: IcepakSteadyState Flow_Regime=Laminar Include_Temperature=true Include_Flow=true Include_Gravity Solution_Initialization_-_Z_Velocity=0.000980665m_per_sec Convergence_Criteria_-_Flow=0.001 Convergence_Criteria_-_Energy=1e-07 Convergence_Criteria_-_Discrete_Ordinates=1e-06 Radiation_Model="Discrete Ordinates Model" Flow_Iteration_Per_Radiation_Iteration=10 ThetaDivision=2 PhiDivision=2 ThetaPixels=2 PhiPixels=2 Under-relaxation_-_Pressure=0.7 Under-relaxation_-_Momentum=0.3 Under-relaxation_-_Temperature=1 Discretization_Scheme_-_Pressure=Standard Discretization_Scheme_-_Momentum=First Discretization_Scheme_-_Temperature=First Discretization_Scheme_-_Discrete_Ordinates=First Convergence_Criteria_-_Max_Iterations=10000
field plots:
  Temperature3: Temperature over Body1_1, Body1_2, Body1_4, Body1_5, Np1..Np8, Ns1..Ns8, Body1, Body1_3, plate1, plate2 on Setup1 : SteadyState
