# Ansys Electronics Desktop project, version 2023.1
materials:
  aluminum: permeability=1.000021 conductivity=38000000 thermal_conductivity=237.5 mass_density=2689 specific_heat=951 youngs_modulus=69000000000 poissons_ratio=0.31 thermal_expansion_coefficient=2.33e-05
  copper: permeability=0.999991 conductivity=58000000 thermal_conductivity=400 mass_density=8933 specific_heat=385 youngs_modulus=120000000000 poissons_ratio=0.38 thermal_expansion_coefficient=1.77e-05
  ferrite - Copy (2): core_loss_curve{25kHz (0, 0) (0.050633, 1) (0.0590114, 1.50406) (0.0691674, 2.34392) (0.0792528, 3.65275) (0.088772, 5.02746) (0.0939521, 6.11121) (0.1, 7.16954) (0.109499, 8.56175) (0.121957, 11.5767) (0.138164, 16.5092) (0.153013, 23.1293) (0.173347, 32.9841) (0.195272, 44.5991) (0.21382, 61.3838) (0.235462, 78.6962) (0.259294, 104.536) (0.280722, 138.862) (0.295422, 151.746)} core_loss_curve{100kHz (0, 0) (0.0263744, 1.03613) (0.0293752, 1.42608) (0.0332788, 2.03369) (0.0396755, 3.1693) (0.0449479, 4.44016) (0.0523856, 6.91954) (0.0628101, 11.373) (0.0753091, 20.068) (0.0882699, 32.4039) (0.103461, 49.6099) (0.118547, 74.6161) (0.142138, 118.363) (0.165658, 191.122) (0.184506, 245.025) (0.1975, 325.48) (0.215037, 409.937) (0.242235, 554.291) (0.26827, 762.898) (0.287163, 911.04)} core_loss_curve{200kHz (0, 0) (0.0153013, 1.07357) (0.0196383, 2.03369) (0.0260769, 4.28533) (0.0305648, 7.42858) (0.0396755, 14.0722) (0.0481134, 22.7224) (0.059347, 38.6962) (0.0757374, 74.6161) (0.0994345, 162.909) (0.110748, 216.401) (0.130546, 319.755) (0.147894, 472.47) (0.164721, 605.722) (0.183462, 848.612) (0.194168, 1013.4) (0.210213, 1167.99) (0.235462, 1607.55) (0.252045, 2024.69) (0.274425, 2333.54) (0.290439, 2939.06)} core_loss_curve{500kHz (0, 0) (0.0101716, 5.89811) (0.01199, 8.71505) (0.0149581, 13.5815) (0.0170423, 18.6929) (0.0202031, 30.1834) (0.0235462, 38.6962) (0.0266752, 55.1837) (0.0309135, 72.0142) (0.0356225, 99.1166) (0.0401281, 129.346) (0.0465037, 187.76) (0.0515018, 236.481) (0.0580159, 319.755) (0.067616, 447.974) (0.0761681, 574.318) (0.0892769, 776.557) (0.101141, 1068.81) (0.1199, 1524.21) (0.142138, 2292.49) (0.174333, 3327.81) (0.199753, 5186.04) (0.22248, 6531.74) (0.249202, 8373.92)} permittivity=12 permeability=3400 conductivity=0.25 thermal_conductivity=4 core_loss_type="Power Ferrite" core_loss_cm=0.062032234 core_loss_x=1.7066326 core_loss_y=2.5354555 mass_density=4800 specific_heat=750 youngs_modulus=119000000000 thermal_expansion_coefficient=1e-05 core_loss_equiv_cut_depth=0.001meter
  silicon - Copy: permittivity=9 thermal_conductivity=10 mass_density=3700 specific_heat=712 youngs_modulus=135000000000 poissons_ratio=0.25 thermal_expansion_coefficient=2.54e-06
  vacuum: permittivity=1
  air: permittivity=1.0006 permeability=1.0000004 thermal_conductivity=0.0261 mass_density=1.1614 specific_heat=1005 thermal_expansion_coefficient=0.00333 thermal_material_type=Fluid diffusivity=2.88e-05 molecular_mass=0.028966 viscosity=1.84e-05 material_refractive_index=1.000293
  Al-Extruded: thermal_conductivity=205 mass_density=2800 specific_heat=900 youngs_modulus=69000000000 poissons_ratio=0.33 thermal_expansion_coefficient=2.277e-06 thermal_material_type=Solid
  polyimide: permittivity=3.5 dielectric_loss_tangent=0.008 thermal_conductivity=0.25 mass_density=1400 specific_heat=1150 youngs_modulus=7500000000 poissons_ratio=0.35 thermal_expansion_coefficient=7e-05
surface materials:
  Steel-oxidised-surface: surface_emissivity=0.8

design Edgewise_0.2_interleaved_full (Maxwell 3D, EddyCurrent, model units mm)
variables:
  freq_hz = 28500Hz
  volt_ac = 141/28500*Freq
geometry:
  Region [vacuum] = region(percentage_offset=0 on all sides)
  Np1..Np8, Ns1..Ns8 [copper] = imported_body(C:\Users\karlr\Documents\ICMaSS_sweeping\edgewise_0.1_0.2.step)
  plate1, plate2 [silicon - Copy] = imported_body(C:\Users\karlr\Documents\ICMaSS_sweeping\edgewise_0.1_0.2.step)
  Body1 [ferrite - Copy (2)] = imported_body(C:\Users\karlr\Documents\ICMaSS_sweeping\edgewise_0.1_0.2.step)
  Body1_1, Body1_2 [aluminum] = imported_body(C:\Users\karlr\Documents\ICMaSS_sweeping\edgewise_0.1_0.2.step)
  Body1_3 [ferrite - Copy (2)] = imported_body(C:\Users\karlr\Documents\ICMaSS_sweeping\edgewise_0.1_0.2.step)
  Body1_4, Body1_5 [aluminum] = imported_body(C:\Users\karlr\Documents\ICMaSS_sweeping\edgewise_0.1_0.2.step)
  Np1_Section1 = Np1.section(plane=ZX)
  Np2_Section1 [copper] = Np2.section(plane=ZX)
  Np3_Section1 [copper] = Np3.section(plane=ZX)
  Np4_Section1 [copper] = Np4.section(plane=ZX)
  Np5_Section1 [copper] = Np5.section(plane=ZX)
  Np6_Section1 [copper] = Np6.section(plane=ZX)
  Np7_Section1 [copper] = Np7.section(plane=ZX)
  Np8_Section1 [copper] = Np8.section(plane=ZX)
  Ns1_Section1 [copper] = Ns1.section(plane=ZX)
  Ns2_Section1 [copper] = Ns2.section(plane=ZX)
  Ns3_Section1 [copper] = Ns3.section(plane=ZX)
  Ns4_Section1 [copper] = Ns4.section(plane=ZX)
  Ns5_Section1 [copper] = Ns5.section(plane=ZX)
  Ns6_Section1 [copper] = Ns6.section(plane=ZX)
  Ns7_Section1 [copper] = Ns7.section(plane=ZX)
  Ns8_Section1 = Ns8.section(plane=ZX)
  Np1_Section1_Separate1 [copper] = Np1_Section1.separate_bodies()
  Np1_Section1.delete()
  Np2_Section1.separate_bodies()
  Np3_Section1.separate_bodies()
  Np4_Section1.separate_bodies()
  Np5_Section1.separate_bodies()
  Np6_Section1.separate_bodies()
  Np7_Section1.separate_bodies()
  Np8_Section1.separate_bodies()
  Ns1_Section1.separate_bodies()
  Ns2_Section1.separate_bodies()
  Ns3_Section1.separate_bodies()
  Ns4_Section1.separate_bodies()
  Ns5_Section1.separate_bodies()
  Ns6_Section1.separate_bodies()
  Ns7_Section1.separate_bodies()
  Ns8_Section1_Separate1 [copper] = Ns8_Section1.separate_bodies()
  Ns8_Section1.delete()
  Rectangle1 [non-model] = rectangle(corner=(6mm, -11mm, 8.2mm), x_size=32mm, y_size=72.95mm)
  group core_assembled_edgewise = Np1..Np8, Ns1..Ns8, plate1, plate2, Np2_Section1, Np3_Section1, Np4_Section1, Np5_Section1, Np6_Section1, Np7_Section1, Np8_Section1, Ns1_Section1, Ns2_Section1, Ns3_Section1, Ns4_Section1, Ns5_Section1, Ns6_Section1, Ns7_Section1, Np1_Section1_Separate1, Ns8_Section1_Separate1
  group core_together_1 = Body1, Body1_1, Body1_2
  group core_together = Body1_3, Body1_4, Body1_5
boundaries and excitations:
  Np_1: Coil Terminal Objects=Np1_Section1_Separate1 Conductor_number=1 Winding=Np Point_out_of_terminal=false
  Np_2: Coil Terminal Objects=Np2_Section1 Conductor_number=1 Winding=Np Point_out_of_terminal=false
  Np_3: Coil Terminal Objects=Np3_Section1 Conductor_number=1 Winding=Np Point_out_of_terminal=false
  Np_4: Coil Terminal Objects=Np4_Section1 Conductor_number=1 Winding=Np Point_out_of_terminal=false
  Np_5: Coil Terminal Objects=Np5_Section1 Conductor_number=1 Winding=Np Point_out_of_terminal=false
  Np_6: Coil Terminal Objects=Np6_Section1 Conductor_number=1 Winding=Np Point_out_of_terminal=false
  Np_7: Coil Terminal Objects=Np7_Section1 Conductor_number=1 Winding=Np Point_out_of_terminal=false
  Np_8: Coil Terminal Objects=Np8_Section1 Conductor_number=1 Winding=Np Point_out_of_terminal=false
  Ns_1: Coil Terminal Objects=Ns1_Section1 Conductor_number=1 Winding=Ns Point_out_of_terminal=true
  Ns_2: Coil Terminal Objects=Ns2_Section1 Conductor_number=1 Winding=Ns Point_out_of_terminal=true
  Ns_3: Coil Terminal Objects=Ns3_Section1 Conductor_number=1 Winding=Ns Point_out_of_terminal=true
  Ns_4: Coil Terminal Objects=Ns4_Section1 Conductor_number=1 Winding=Ns Point_out_of_terminal=true
  Ns_5: Coil Terminal Objects=Ns5_Section1 Conductor_number=1 Winding=Ns Point_out_of_terminal=true
  Ns_6: Coil Terminal Objects=Ns6_Section1 Conductor_number=1 Winding=Ns Point_out_of_terminal=true
  Ns_7: Coil Terminal Objects=Ns7_Section1 Conductor_number=1 Winding=Ns Point_out_of_terminal=true
  Ns_8: Coil Terminal Objects=Ns8_Section1_Separate1 Conductor_number=1 Winding=Ns Point_out_of_terminal=true
  Np: Winding Group Type=Current IsSolid=true Current=1000*1.41/volt_ac*1.414 ParallelBranchesNum=1 Phase=0rad
  Ns: Winding Group Type=Current IsSolid=true Current=1000*1.41/volt_ac*1.414 ParallelBranchesNum=1 Phase=0.1522rad
  core loss on: Body1, Body1_3
parameters:
  Matrix1: Matrix Np, Ns:
mesh:
  Length1: LengthBased Objects=[Np1..Np8, Ns1..Ns8] MaxLength=2mm
  Length2: LengthBased Objects=[Body1, Body1_1..Body1_5] MaxLength=5mm
  initial mesh: GlobalSurfApproximation{CurvedSurfaceApproxChoice=UseSlider SliderMeshSettings=9} GlobalCurvilinear{Apply}
setups:
  Setup1: EddyCurrent MaximumPasses=20 MinimumPasses=2 MinimumConvergedPasses=1 PercentRefinement=30 PercentError=1 NonLinearResidual=0.0001 SmoothBHCurve Frequency=28.5kHz
  Setup2: EddyCurrent MaximumPasses=20 MinimumPasses=2 MinimumConvergedPasses=1 PercentRefinement=30 PercentError=1 NonLinearResidual=0.0001 Frequency=1Hz
field plots:
  Mag_J1: J over a plane on Setup2 : LastAdaptive at Freq=1Hz Phase=0deg
reports:
  L Table 1: Matrix1.L(Np,Np), Matrix1.L(Ns,Np), Matrix1.L(Np,Ns), Matrix1.L(Ns,Ns), Matrix1.R(Np,Np), Matrix1.R(Ns,Np), Matrix1.R(Np,Ns), Matrix1.R(Ns,Ns) vs Freq on Setup1 : LastAdaptive

design Edgewise_0.25_interleaved_full (Maxwell 3D, EddyCurrent, model units mm)
variables:
  freq_hz = 28500Hz
  volt_ac = 141/28500*Freq
geometry:
  Region [vacuum] = region(percentage_offset=0 on all sides)
  Np1..Np8, Ns1..Ns8 [copper] = imported_body(C:\Users\karlr\Documents\ICMaSS_sweeping\edgewise_0.1_0.25.step)
  plate1, plate2 [silicon - Copy] = imported_body(C:\Users\karlr\Documents\ICMaSS_sweeping\edgewise_0.1_0.25.step)
  Body1 [ferrite - Copy (2)] = imported_body(C:\Users\karlr\Documents\ICMaSS_sweeping\edgewise_0.1_0.25.step)
  Body1_1, Body1_2 [aluminum] = imported_body(C:\Users\karlr\Documents\ICMaSS_sweeping\edgewise_0.1_0.25.step)
  Body1_3 [ferrite - Copy (2)] = imported_body(C:\Users\karlr\Documents\ICMaSS_sweeping\edgewise_0.1_0.25.step)
  Body1_4, Body1_5 [aluminum] = imported_body(C:\Users\karlr\Documents\ICMaSS_sweeping\edgewise_0.1_0.25.step)
  Np1_Section1 = Np1.section(plane=ZX)
  Np2_Section1 [copper] = Np2.section(plane=ZX)
  Np3_Section1 [copper] = Np3.section(plane=ZX)
  Np4_Section1 [copper] = Np4.section(plane=ZX)
  Np5_Section1 [copper] = Np5.section(plane=ZX)
  Np6_Section1 [copper] = Np6.section(plane=ZX)
  Np7_Section1 [copper] = Np7.section(plane=ZX)
  Np8_Section1 [copper] = Np8.section(plane=ZX)
  Ns1_Section1 [copper] = Ns1.section(plane=ZX)
  Ns2_Section1 [copper] = Ns2.section(plane=ZX)
  Ns3_Section1 [copper] = Ns3.section(plane=ZX)
  Ns4_Section1 [copper] = Ns4.section(plane=ZX)
  Ns5_Section1 [copper] = Ns5.section(plane=ZX)
  Ns6_Section1 [copper] = Ns6.section(plane=ZX)
  Ns7_Section1 [copper] = Ns7.section(plane=ZX)
  Ns8_Section1 = Ns8.section(plane=ZX)
  Np1_Section1_Separate1 [copper] = Np1_Section1.separate_bodies()
  Np1_Section1.delete()
  Np2_Section1.separate_bodies()
  Np3_Section1.separate_bodies()
  Np4_Section1.separate_bodies()
  Np5_Section1.separate_bodies()
  Np6_Section1.separate_bodies()
  Np7_Section1.separate_bodies()
  Np8_Section1.separate_bodies()
  Ns1_Section1.separate_bodies()
  Ns2_Section1.separate_bodies()
  Ns3_Section1.separate_bodies()
  Ns4_Section1.separate_bodies()
  Ns5_Section1.separate_bodies()
  Ns6_Section1.separate_bodies()
  Ns7_Section1.separate_bodies()
  Ns8_Section1_Separate1 [copper] = Ns8_Section1.separate_bodies()
  Ns8_Section1.delete()
  group core_assembled_edgewise = Np1..Np8, Ns1..Ns8, plate1, plate2, Np2_Section1, Np3_Section1, Np4_Section1, Np5_Section1, Np6_Section1, Np7_Section1, Np8_Section1, Ns1_Section1, Ns2_Section1, Ns3_Section1, Ns4_Section1, Ns5_Section1, Ns6_Section1, Ns7_Section1, Np1_Section1_Separate1, Ns8_Section1_Separate1
  group core_together_1 = Body1, Body1_1, Body1_2
  group core_together = Body1_3, Body1_4, Body1_5
boundaries and excitations:
  Np_1: Coil Terminal Objects=Np1_Section1_Separate1 Conductor_number=1 Winding=Np Point_out_of_terminal=false
  Np_2: Coil Terminal Objects=Np2_Section1 Conductor_number=1 Winding=Np Point_out_of_terminal=false
  Np_3: Coil Terminal Objects=Np3_Section1 Conductor_number=1 Winding=Np Point_out_of_terminal=false
  Np_4: Coil Terminal Objects=Np4_Section1 Conductor_number=1 Winding=Np Point_out_of_terminal=false
  Np_5: Coil Terminal Objects=Np5_Section1 Conductor_number=1 Winding=Np Point_out_of_terminal=false
  Np_6: Coil Terminal Objects=Np6_Section1 Conductor_number=1 Winding=Np Point_out_of_terminal=false
  Np_7: Coil Terminal Objects=Np7_Section1 Conductor_number=1 Winding=Np Point_out_of_terminal=false
  Np_8: Coil Terminal Objects=Np8_Section1 Conductor_number=1 Winding=Np Point_out_of_terminal=false
  Ns_1: Coil Terminal Objects=Ns1_Section1 Conductor_number=1 Winding=Ns Point_out_of_terminal=true
  Ns_2: Coil Terminal Objects=Ns2_Section1 Conductor_number=1 Winding=Ns Point_out_of_terminal=true
  Ns_3: Coil Terminal Objects=Ns3_Section1 Conductor_number=1 Winding=Ns Point_out_of_terminal=true
  Ns_4: Coil Terminal Objects=Ns4_Section1 Conductor_number=1 Winding=Ns Point_out_of_terminal=true
  Ns_5: Coil Terminal Objects=Ns5_Section1 Conductor_number=1 Winding=Ns Point_out_of_terminal=true
  Ns_6: Coil Terminal Objects=Ns6_Section1 Conductor_number=1 Winding=Ns Point_out_of_terminal=true
  Ns_7: Coil Terminal Objects=Ns7_Section1 Conductor_number=1 Winding=Ns Point_out_of_terminal=true
  Ns_8: Coil Terminal Objects=Ns8_Section1_Separate1 Conductor_number=1 Winding=Ns Point_out_of_terminal=true
  Np: Winding Group Type=Voltage IsSolid=true Current=16.36A Resistance=0ohm Inductance=0nH Voltage=volt_ac ParallelBranchesNum=1 Phase=0rad
  Ns: Winding Group Type=Current IsSolid=true Current=1000*1.41/volt_ac*1.414 ParallelBranchesNum=1 Phase=0.1522rad
  core loss on: Body1, Body1_3
parameters:
  Matrix1: Matrix Np, Ns:
mesh:
  Length1: LengthBased Objects=[Np1..Np8, Ns1..Ns8, plate1, plate2] MaxLength=2mm
  Length2: LengthBased Objects=[Body1, Body1_1..Body1_5] MaxLength=5mm
  initial mesh: GlobalSurfApproximation{CurvedSurfaceApproxChoice=UseSlider SliderMeshSettings=9} GlobalCurvilinear{Apply}
setups:
  Setup1: EddyCurrent MaximumPasses=20 MinimumPasses=2 MinimumConvergedPasses=1 PercentRefinement=30 PercentError=1 NonLinearResidual=0.0001 SmoothBHCurve Frequency=28.5kHz SweepRanges{0.1Hz to 1Hz, log, 10 per decade 1Hz to 1000Hz, log, 10 per decade 1000Hz to 10000Hz, log, 10 per decade 10000Hz to 100000Hz, log, 10 per decade 100000Hz to 1000000Hz, log, 10 per decade 1000000Hz to 10000000Hz, log, 10 per decade} SaveAllFields
reports:
  L Table 1: Matrix1.L(Np,Np), Matrix1.L(Ns,Np), Matrix1.L(Np,Ns), Matrix1.L(Ns,Ns), Matrix1.R(Np,Np), Matrix1.R(Ns,Np), Matrix1.R(Np,Ns), Matrix1.R(Ns,Ns) vs Freq on Setup1 : LastAdaptive

design Edgewise_0.3_interleaved_full (Maxwell 3D, EddyCurrent, model units mm)
variables:
  freq_hz = 28500Hz
  volt_ac = 141/28500*Freq
geometry:
  Region [vacuum] = region(percentage_offset=0 on all sides)
  Np1..Np8, Ns1..Ns8 [copper] = imported_body(C:\Users\karlr\Documents\ICMaSS_sweeping\edgewise_0.1_0.3.step)
  plate1, plate2 [silicon - Copy] = imported_body(C:\Users\karlr\Documents\ICMaSS_sweeping\edgewise_0.1_0.3.step)
  Body1 [ferrite - Copy (2)] = imported_body(C:\Users\karlr\Documents\ICMaSS_sweeping\edgewise_0.1_0.3.step)
  Body1_1, Body1_2 [aluminum] = imported_body(C:\Users\karlr\Documents\ICMaSS_sweeping\edgewise_0.1_0.3.step)
  Body1_3 [ferrite - Copy (2)] = imported_body(C:\Users\karlr\Documents\ICMaSS_sweeping\edgewise_0.1_0.3.step)
  Body1_4, Body1_5 [aluminum] = imported_body(C:\Users\karlr\Documents\ICMaSS_sweeping\edgewise_0.1_0.3.step)
  Np1_Section1 = Np1.section(plane=ZX)
  Np2_Section1 [copper] = Np2.section(plane=ZX)
  Np3_Section1 [copper] = Np3.section(plane=ZX)
  Np4_Section1 [copper] = Np4.section(plane=ZX)
  Np5_Section1 [copper] = Np5.section(plane=ZX)
  Np6_Section1 [copper] = Np6.section(plane=ZX)
  Np7_Section1 [copper] = Np7.section(plane=ZX)
  Np8_Section1 [copper] = Np8.section(plane=ZX)
  Ns1_Section1 [copper] = Ns1.section(plane=ZX)
  Ns2_Section1 [copper] = Ns2.section(plane=ZX)
  Ns3_Section1 [copper] = Ns3.section(plane=ZX)
  Ns4_Section1 [copper] = Ns4.section(plane=ZX)
  Ns5_Section1 [copper] = Ns5.section(plane=ZX)
  Ns6_Section1 [copper] = Ns6.section(plane=ZX)
  Ns7_Section1 [copper] = Ns7.section(plane=ZX)
  Ns8_Section1 = Ns8.section(plane=ZX)
  Np1_Section1_Separate1 [copper] = Np1_Section1.separate_bodies()
  Np1_Section1.delete()
  Np2_Section1.separate_bodies()
  Np3_Section1.separate_bodies()
  Np4_Section1.separate_bodies()
  Np5_Section1.separate_bodies()
  Np6_Section1.separate_bodies()
  Np7_Section1.separate_bodies()
  Np8_Section1.separate_bodies()
  Ns1_Section1.separate_bodies()
  Ns2_Section1.separate_bodies()
  Ns3_Section1.separate_bodies()
  Ns4_Section1.separate_bodies()
  Ns5_Section1.separate_bodies()
  Ns6_Section1.separate_bodies()
  Ns7_Section1.separate_bodies()
  Ns8_Section1_Separate1 [copper] = Ns8_Section1.separate_bodies()
  Ns8_Section1.delete()
  [Np1..Np8, Ns1..Ns8, plate1, plate2, Body1, Body1_1..Body1_5, Np2_Section1, Np3_Section1, Np4_Section1, Np5_Section1, Np6_Section1, Np7_Section1, Np8_Section1, Ns1_Section1, Ns2_Section1, Ns3_Section1, Ns4_Section1, Ns5_Section1, Ns6_Section1, Ns7_Section1, Np1_Section1_Separate1, Ns8_Section1_Separate1].move(-18.666667mm, -25.43mm, -1.6666613e-08mm)
  group core_assembled_edgewise2 = Np1..Np8, Ns1..Ns8, plate1, plate2, Np2_Section1, Np3_Section1, Np4_Section1, Np5_Section1, Np6_Section1, Np7_Section1, Np8_Section1, Ns1_Section1, Ns2_Section1, Ns3_Section1, Ns4_Section1, Ns5_Section1, Ns6_Section1, Ns7_Section1, Np1_Section1_Separate1, Ns8_Section1_Separate1
  group core_together_3 = Body1, Body1_1, Body1_2
  group core_together2 = Body1_3, Body1_4, Body1_5
boundaries and excitations:
  Ns_1: Coil Terminal Objects=Ns8_Section1_Separate1 Conductor_number=1 Winding=Ns Point_out_of_terminal=true
  Ns_2: Coil Terminal Objects=Ns1_Section1 Conductor_number=1 Winding=Ns Point_out_of_terminal=true
  Ns_3: Coil Terminal Objects=Ns2_Section1 Conductor_number=1 Winding=Ns Point_out_of_terminal=true
  Ns_4: Coil Terminal Objects=Ns3_Section1 Conductor_number=1 Winding=Ns Point_out_of_terminal=true
  Ns_5: Coil Terminal Objects=Ns4_Section1 Conductor_number=1 Winding=Ns Point_out_of_terminal=true
  Ns_6: Coil Terminal Objects=Ns5_Section1 Conductor_number=1 Winding=Ns Point_out_of_terminal=true
  Ns_7: Coil Terminal Objects=Ns6_Section1 Conductor_number=1 Winding=Ns Point_out_of_terminal=true
  Ns_8: Coil Terminal Objects=Ns7_Section1 Conductor_number=1 Winding=Ns Point_out_of_terminal=true
  Np_1: Coil Terminal Objects=Np1_Section1_Separate1 Conductor_number=1 Winding=Np Point_out_of_terminal=false
  Np_2: Coil Terminal Objects=Np2_Section1 Conductor_number=1 Winding=Np Point_out_of_terminal=false
  Np_3: Coil Terminal Objects=Np3_Section1 Conductor_number=1 Winding=Np Point_out_of_terminal=false
  Np_4: Coil Terminal Objects=Np4_Section1 Conductor_number=1 Winding=Np Point_out_of_terminal=false
  Np_5: Coil Terminal Objects=Np5_Section1 Conductor_number=1 Winding=Np Point_out_of_terminal=false
  Np_6: Coil Terminal Objects=Np6_Section1 Conductor_number=1 Winding=Np Point_out_of_terminal=false
  Np_7: Coil Terminal Objects=Np7_Section1 Conductor_number=1 Winding=Np Point_out_of_terminal=false
  Np_8: Coil Terminal Objects=Np8_Section1 Conductor_number=1 Winding=Np Point_out_of_terminal=false
  Np: Winding Group Type=Voltage IsSolid=true Current=16.36A Resistance=0ohm Inductance=0nH Voltage=volt_ac ParallelBranchesNum=1 Phase=0rad
  Ns: Winding Group Type=Current IsSolid=true Current=1000*1.41/volt_ac*1.414 ParallelBranchesNum=1 Phase=0.1522rad
  core loss on: Body1, Body1_3
parameters:
  Matrix1: Matrix Np, Ns:
mesh:
  Length1: LengthBased Objects=[Np1..Np8, Ns1..Ns8, plate1, plate2] MaxLength=5mm
  Length2: LengthBased Objects=[Np1..Np8, Ns1..Ns8, plate1, plate2] MaxLength=2mm
  initial mesh: GlobalSurfApproximation{CurvedSurfaceApproxChoice=UseSlider SliderMeshSettings=9} GlobalCurvilinear{Apply}
setups:
  Setup1: EddyCurrent MaximumPasses=20 MinimumPasses=2 MinimumConvergedPasses=1 PercentRefinement=30 PercentError=1 NonLinearResidual=0.0001 SmoothBHCurve Frequency=28.5kHz
reports:
  L Table 1: Matrix1.L(Np,Np), Matrix1.L(Ns,Np), Matrix1.L(Np,Ns), Matrix1.L(Ns,Ns), Matrix1.R(Np,Np), Matrix1.R(Ns,Np), Matrix1.R(Np,Ns), Matrix1.R(Ns,Ns) vs Freq on Setup1 : LastAdaptive

design Edgewise_0.4_interleaved_full (Maxwell 3D, EddyCurrent, model units mm)
variables:
  freq_hz = 28500Hz
  volt_ac = 141/28500*Freq
geometry:
  Region [vacuum] = region(percentage_offset=0 on all sides)
  Np1..Np8, Ns1..Ns8 [copper] = imported_body(C:\Users\karlr\Documents\ICMaSS_sweeping\edgewise_0.1_0.4.step)
  plate1, plate2 [silicon - Copy] = imported_body(C:\Users\karlr\Documents\ICMaSS_sweeping\edgewise_0.1_0.4.step)
  Body1 [aluminum] = imported_body(C:\Users\karlr\Documents\ICMaSS_sweeping\edgewise_0.1_0.4.step)
  Body1_1 [ferrite - Copy (2)] = imported_body(C:\Users\karlr\Documents\ICMaSS_sweeping\edgewise_0.1_0.4.step)
  Body1_2, Body1_3 [aluminum] = imported_body(C:\Users\karlr\Documents\ICMaSS_sweeping\edgewise_0.1_0.4.step)
  Body1_4 [ferrite - Copy (2)] = imported_body(C:\Users\karlr\Documents\ICMaSS_sweeping\edgewise_0.1_0.4.step)
  Body1_5 [aluminum] = imported_body(C:\Users\karlr\Documents\ICMaSS_sweeping\edgewise_0.1_0.4.step)
  Np1_Section1 = Np1.section(plane=ZX)
  Np2_Section1 [copper] = Np2.section(plane=ZX)
  Np3_Section1 [copper] = Np3.section(plane=ZX)
  Np4_Section1 [copper] = Np4.section(plane=ZX)
  Np5_Section1 [copper] = Np5.section(plane=ZX)
  Np6_Section1 [copper] = Np6.section(plane=ZX)
  Np7_Section1 [copper] = Np7.section(plane=ZX)
  Np8_Section1 [copper] = Np8.section(plane=ZX)
  Ns1_Section1 [copper] = Ns1.section(plane=ZX)
  Ns2_Section1 [copper] = Ns2.section(plane=ZX)
  Ns3_Section1 [copper] = Ns3.section(plane=ZX)
  Ns4_Section1 [copper] = Ns4.section(plane=ZX)
  Ns5_Section1 [copper] = Ns5.section(plane=ZX)
  Ns6_Section1 [copper] = Ns6.section(plane=ZX)
  Ns7_Section1 [copper] = Ns7.section(plane=ZX)
  Ns8_Section1 = Ns8.section(plane=ZX)
  Np1_Section1_Separate1 [copper] = Np1_Section1.separate_bodies()
  Np1_Section1.delete()
  Np2_Section1.separate_bodies()
  Np3_Section1.separate_bodies()
  Np4_Section1.separate_bodies()
  Np5_Section1.separate_bodies()
  Np6_Section1.separate_bodies()
  Np7_Section1.separate_bodies()
  Np8_Section1.separate_bodies()
  Ns1_Section1.separate_bodies()
  Ns2_Section1.separate_bodies()
  Ns3_Section1.separate_bodies()
  Ns4_Section1.separate_bodies()
  Ns5_Section1.separate_bodies()
  Ns6_Section1.separate_bodies()
  Ns7_Section1.separate_bodies()
  Ns8_Section1_Separate1 [copper] = Ns8_Section1.separate_bodies()
  Ns8_Section1.delete()
  group core_assembled_edgewise3 = Np1..Np8, Ns1..Ns8, plate1, plate2, Np2_Section1, Np3_Section1, Np4_Section1, Np5_Section1, Np6_Section1, Np7_Section1, Np8_Section1, Ns1_Section1, Ns2_Section1, Ns3_Section1, Ns4_Section1, Ns5_Section1, Ns6_Section1, Ns7_Section1, Np1_Section1_Separate1, Ns8_Section1_Separate1
  group core_together_4 = Body1, Body1_1, Body1_2
  group core_together3 = Body1_3, Body1_4, Body1_5
boundaries and excitations:
  Np_1: Coil Terminal Objects=Np1_Section1_Separate1 Conductor_number=1 Winding=Np Point_out_of_terminal=false
  Np_2: Coil Terminal Objects=Np2_Section1 Conductor_number=1 Winding=Np Point_out_of_terminal=false
  Np_3: Coil Terminal Objects=Np3_Section1 Conductor_number=1 Winding=Np Point_out_of_terminal=false
  Np_4: Coil Terminal Objects=Np4_Section1 Conductor_number=1 Winding=Np Point_out_of_terminal=false
  Np_5: Coil Terminal Objects=Np5_Section1 Conductor_number=1 Winding=Np Point_out_of_terminal=false
  Np_6: Coil Terminal Objects=Np6_Section1 Conductor_number=1 Winding=Np Point_out_of_terminal=false
  Np_7: Coil Terminal Objects=Np7_Section1 Conductor_number=1 Winding=Np Point_out_of_terminal=false
  Np_8: Coil Terminal Objects=Np8_Section1 Conductor_number=1 Winding=Np Point_out_of_terminal=false
  Ns_1: Coil Terminal Objects=Ns1_Section1 Conductor_number=1 Winding=Ns Point_out_of_terminal=true
  Ns_2: Coil Terminal Objects=Ns2_Section1 Conductor_number=1 Winding=Ns Point_out_of_terminal=true
  Ns_3: Coil Terminal Objects=Ns3_Section1 Conductor_number=1 Winding=Ns Point_out_of_terminal=true
  Ns_4: Coil Terminal Objects=Ns4_Section1 Conductor_number=1 Winding=Ns Point_out_of_terminal=true
  Ns_5: Coil Terminal Objects=Ns5_Section1 Conductor_number=1 Winding=Ns Point_out_of_terminal=true
  Ns_6: Coil Terminal Objects=Ns6_Section1 Conductor_number=1 Winding=Ns Point_out_of_terminal=true
  Ns_7: Coil Terminal Objects=Ns7_Section1 Conductor_number=1 Winding=Ns Point_out_of_terminal=true
  Ns_8: Coil Terminal Objects=Ns8_Section1_Separate1 Conductor_number=1 Winding=Ns Point_out_of_terminal=true
  Np: Winding Group Type=Voltage IsSolid=true Current=16.36A Resistance=0ohm Inductance=0nH Voltage=volt_ac ParallelBranchesNum=1 Phase=0rad
  Ns: Winding Group Type=Current IsSolid=true Current=1000*1.41/volt_ac*1.414 ParallelBranchesNum=1 Phase=0.1522rad
  core loss on: Body1_1, Body1_4
parameters:
  Matrix1: Matrix Np, Ns:
mesh:
  Length1: LengthBased Objects=[Body1, Body1_1..Body1_5] MaxLength=5mm
  Length2: LengthBased Objects=[Np1..Np8, Ns1..Ns8, plate1, plate2] MaxLength=2mm
  initial mesh: GlobalSurfApproximation{CurvedSurfaceApproxChoice=UseSlider SliderMeshSettings=9} GlobalCurvilinear{Apply}
setups:
  Setup1: EddyCurrent MaximumPasses=20 MinimumPasses=2 MinimumConvergedPasses=1 PercentRefinement=30 PercentError=1 NonLinearResidual=0.0001 SmoothBHCurve Frequency=28.5kHz SweepRanges{0.1Hz to 1Hz, log, 10 per decade 1Hz to 1000Hz, log, 10 per decade 1000Hz to 10000Hz, log, 10 per decade 10000Hz to 100000Hz, log, 10 per decade 100000Hz to 1000000Hz, log, 10 per decade 1000000Hz to 10000000Hz, log, 10 per decade} SaveAllFields
reports:
  L Table 1: Matrix1.L(Np,Np), Matrix1.L(Ns,Np), Matrix1.L(Np,Ns), Matrix1.L(Ns,Ns), Matrix1.R(Np,Np), Matrix1.R(Ns,Np), Matrix1.R(Np,Ns), Matrix1.R(Ns,Ns) vs Freq on Setup1 : LastAdaptive

design Edgewise_0.5_interleaved_full (Maxwell 3D, EddyCurrent, model units mm)
variables:
  freq_hz = 28500Hz
  volt_ac = 141/28500*Freq
geometry:
  Region [vacuum] = region(percentage_offset=0 on all sides)
  Np1..Np8, Ns1..Ns8 [copper] = imported_body(C:\Users\karlr\Documents\ICMaSS_sweeping\edgewise_0.1_0.5.step)
  plate1, plate2 [silicon - Copy] = imported_body(C:\Users\karlr\Documents\ICMaSS_sweeping\edgewise_0.1_0.5.step)
  Body1 [ferrite - Copy (2)] = imported_body(C:\Users\karlr\Documents\ICMaSS_sweeping\edgewise_0.1_0.5.step)
  Body1_1, Body1_2 [aluminum] = imported_body(C:\Users\karlr\Documents\ICMaSS_sweeping\edgewise_0.1_0.5.step)
  Body1_3 [ferrite - Copy (2)] = imported_body(C:\Users\karlr\Documents\ICMaSS_sweeping\edgewise_0.1_0.5.step)
  Body1_4, Body1_5 [aluminum] = imported_body(C:\Users\karlr\Documents\ICMaSS_sweeping\edgewise_0.1_0.5.step)
  Np1_Section1 = Np1.section(plane=ZX)
  Np2_Section1 [copper] = Np2.section(plane=ZX)
  Np3_Section1 [copper] = Np3.section(plane=ZX)
  Np4_Section1 [copper] = Np4.section(plane=ZX)
  Np5_Section1 [copper] = Np5.section(plane=ZX)
  Np6_Section1 [copper] = Np6.section(plane=ZX)
  Np7_Section1 [copper] = Np7.section(plane=ZX)
  Np8_Section1 [copper] = Np8.section(plane=ZX)
  Ns1_Section1 [copper] = Ns1.section(plane=ZX)
  Ns2_Section1 [copper] = Ns2.section(plane=ZX)
  Ns3_Section1 [copper] = Ns3.section(plane=ZX)
  Ns4_Section1 [copper] = Ns4.section(plane=ZX)
  Ns5_Section1 [copper] = Ns5.section(plane=ZX)
  Ns6_Section1 [copper] = Ns6.section(plane=ZX)
  Ns7_Section1 [copper] = Ns7.section(plane=ZX)
  Ns8_Section1 = Ns8.section(plane=ZX)
  Np1_Section1_Separate1 [copper] = Np1_Section1.separate_bodies()
  Np1_Section1.delete()
  Np2_Section1.separate_bodies()
  Np3_Section1.separate_bodies()
  Np4_Section1.separate_bodies()
  Np5_Section1.separate_bodies()
  Np6_Section1.separate_bodies()
  Np7_Section1.separate_bodies()
  Np8_Section1.separate_bodies()
  Ns1_Section1.separate_bodies()
  Ns2_Section1.separate_bodies()
  Ns3_Section1.separate_bodies()
  Ns4_Section1.separate_bodies()
  Ns5_Section1.separate_bodies()
  Ns6_Section1.separate_bodies()
  Ns7_Section1.separate_bodies()
  Ns8_Section1_Separate1 [copper] = Ns8_Section1.separate_bodies()
  Ns8_Section1.delete()
  group core_assembled_edgewise4 = Np1..Np8, Ns1..Ns8, plate1, plate2, Np2_Section1, Np3_Section1, Np4_Section1, Np5_Section1, Np6_Section1, Np7_Section1, Np8_Section1, Ns1_Section1, Ns2_Section1, Ns3_Section1, Ns4_Section1, Ns5_Section1, Ns6_Section1, Ns7_Section1, Np1_Section1_Separate1, Ns8_Section1_Separate1
  group core_together_5 = Body1, Body1_1, Body1_2
  group core_together4 = Body1_3, Body1_4, Body1_5
boundaries and excitations:
  Np_1: Coil Terminal Objects=Np1_Section1_Separate1 Conductor_number=1 Winding=Np Point_out_of_terminal=false
  Np_2: Coil Terminal Objects=Np2_Section1 Conductor_number=1 Winding=Np Point_out_of_terminal=false
  Np_3: Coil Terminal Objects=Np3_Section1 Conductor_number=1 Winding=Np Point_out_of_terminal=false
  Np_4: Coil Terminal Objects=Np4_Section1 Conductor_number=1 Winding=Np Point_out_of_terminal=false
  Np_5: Coil Terminal Objects=Np5_Section1 Conductor_number=1 Winding=Np Point_out_of_terminal=false
  Np_6: Coil Terminal Objects=Np6_Section1 Conductor_number=1 Winding=Np Point_out_of_terminal=false
  Np_7: Coil Terminal Objects=Np7_Section1 Conductor_number=1 Winding=Np Point_out_of_terminal=false
  Np_8: Coil Terminal Objects=Np8_Section1 Conductor_number=1 Winding=Np Point_out_of_terminal=false
  Ns_1: Coil Terminal Objects=Ns1_Section1 Conductor_number=1 Winding=Ns Point_out_of_terminal=true
  Ns_2: Coil Terminal Objects=Ns2_Section1 Conductor_number=1 Winding=Ns Point_out_of_terminal=true
  Ns_3: Coil Terminal Objects=Ns3_Section1 Conductor_number=1 Winding=Ns Point_out_of_terminal=true
  Ns_4: Coil Terminal Objects=Ns4_Section1 Conductor_number=1 Winding=Ns Point_out_of_terminal=true
  Ns_5: Coil Terminal Objects=Ns5_Section1 Conductor_number=1 Winding=Ns Point_out_of_terminal=true
  Ns_6: Coil Terminal Objects=Ns6_Section1 Conductor_number=1 Winding=Ns Point_out_of_terminal=true
  Ns_7: Coil Terminal Objects=Ns7_Section1 Conductor_number=1 Winding=Ns Point_out_of_terminal=true
  Ns_8: Coil Terminal Objects=Ns8_Section1_Separate1 Conductor_number=1 Winding=Ns Point_out_of_terminal=true
  Np: Winding Group Type=Voltage IsSolid=true Current=16.36A Resistance=0ohm Inductance=0nH Voltage=volt_ac ParallelBranchesNum=1 Phase=0rad
  Ns: Winding Group Type=Current IsSolid=true Current=1000*1.41/volt_ac*1.414 ParallelBranchesNum=1 Phase=0.1522rad
  core loss on: Body1, Body1_3
parameters:
  Matrix1: Matrix Np, Ns:
mesh:
  Length1: LengthBased Objects=[Np1..Np8, Ns1..Ns8, plate1, plate2] MaxLength=2mm
  Length2: LengthBased Objects=[Body1, Body1_1..Body1_5] MaxLength=5mm
  initial mesh: GlobalSurfApproximation{CurvedSurfaceApproxChoice=UseSlider SliderMeshSettings=9} GlobalCurvilinear{Apply}
setups:
  Setup1: EddyCurrent MaximumPasses=20 MinimumPasses=2 MinimumConvergedPasses=1 PercentRefinement=30 PercentError=1 NonLinearResidual=0.0001 SmoothBHCurve Frequency=28.5kHz
reports:
  L Table 1: Matrix1.L(Np,Np), Matrix1.L(Ns,Np), Matrix1.L(Np,Ns), Matrix1.L(Ns,Ns), Matrix1.R(Np,Np), Matrix1.R(Ns,Np), Matrix1.R(Np,Ns), Matrix1.R(Ns,Ns) vs Freq on Setup1 : LastAdaptive

design Edgewise_0.3_interleaved_full1 (Maxwell 3D, EddyCurrent, model units mm)
variables:
  freq_hz = 28500Hz
  volt_ac = 141/28500*Freq
geometry:
  Region [vacuum] = region(percentage_offset=0 on all sides)
  Np1..Np8, Ns1..Ns8 [copper] = imported_body(C:\Users\karlr\Documents\ICMaSS_sweeping\edgewise_0.1_0.3.step)
  plate1, plate2 [silicon - Copy] = imported_body(C:\Users\karlr\Documents\ICMaSS_sweeping\edgewise_0.1_0.3.step)
  Body1 [ferrite - Copy (2)] = imported_body(C:\Users\karlr\Documents\ICMaSS_sweeping\edgewise_0.1_0.3.step)
  Body1_1, Body1_2 [aluminum] = imported_body(C:\Users\karlr\Documents\ICMaSS_sweeping\edgewise_0.1_0.3.step)
  Body1_3 [ferrite - Copy (2)] = imported_body(C:\Users\karlr\Documents\ICMaSS_sweeping\edgewise_0.1_0.3.step)
  Body1_4, Body1_5 [aluminum] = imported_body(C:\Users\karlr\Documents\ICMaSS_sweeping\edgewise_0.1_0.3.step)
  Np1_Section1 = Np1.section(plane=ZX)
  Np2_Section1 [copper] = Np2.section(plane=ZX)
  Np3_Section1 [copper] = Np3.section(plane=ZX)
  Np4_Section1 [copper] = Np4.section(plane=ZX)
  Np5_Section1 [copper] = Np5.section(plane=ZX)
  Np6_Section1 [copper] = Np6.section(plane=ZX)
  Np7_Section1 [copper] = Np7.section(plane=ZX)
  Np8_Section1 [copper] = Np8.section(plane=ZX)
  Ns1_Section1 [copper] = Ns1.section(plane=ZX)
  Ns2_Section1 [copper] = Ns2.section(plane=ZX)
  Ns3_Section1 [copper] = Ns3.section(plane=ZX)
  Ns4_Section1 [copper] = Ns4.section(plane=ZX)
  Ns5_Section1 [copper] = Ns5.section(plane=ZX)
  Ns6_Section1 [copper] = Ns6.section(plane=ZX)
  Ns7_Section1 [copper] = Ns7.section(plane=ZX)
  Ns8_Section1 = Ns8.section(plane=ZX)
  Np1_Section1_Separate1 [copper] = Np1_Section1.separate_bodies()
  Np1_Section1.delete()
  Np2_Section1.separate_bodies()
  Np3_Section1.separate_bodies()
  Np4_Section1.separate_bodies()
  Np5_Section1.separate_bodies()
  Np6_Section1.separate_bodies()
  Np7_Section1.separate_bodies()
  Np8_Section1.separate_bodies()
  Ns1_Section1.separate_bodies()
  Ns2_Section1.separate_bodies()
  Ns3_Section1.separate_bodies()
  Ns4_Section1.separate_bodies()
  Ns5_Section1.separate_bodies()
  Ns6_Section1.separate_bodies()
  Ns7_Section1.separate_bodies()
  Ns8_Section1_Separate1 [copper] = Ns8_Section1.separate_bodies()
  Ns8_Section1.delete()
  [Np1..Np8, Ns1..Ns8, plate1, plate2, Body1, Body1_1..Body1_5, Np2_Section1, Np3_Section1, Np4_Section1, Np5_Section1, Np6_Section1, Np7_Section1, Np8_Section1, Ns1_Section1, Ns2_Section1, Ns3_Section1, Ns4_Section1, Ns5_Section1, Ns6_Section1, Ns7_Section1, Np1_Section1_Separate1, Ns8_Section1_Separate1].move(-18.666667mm, -25.43mm, -1.6666613e-08mm)
  group core_assembled_edgewise2 = Np1..Np8, Ns1..Ns8, plate1, plate2, Np2_Section1, Np3_Section1, Np4_Section1, Np5_Section1, Np6_Section1, Np7_Section1, Np8_Section1, Ns1_Section1, Ns2_Section1, Ns3_Section1, Ns4_Section1, Ns5_Section1, Ns6_Section1, Ns7_Section1, Np1_Section1_Separate1, Ns8_Section1_Separate1
  group core_together_3 = Body1, Body1_1, Body1_2
  group core_together2 = Body1_3, Body1_4, Body1_5
boundaries and excitations:
  Ns_1: Coil Terminal Objects=Ns8_Section1_Separate1 Conductor_number=1 Winding=Ns Point_out_of_terminal=true
  Ns_2: Coil Terminal Objects=Ns1_Section1 Conductor_number=1 Winding=Ns Point_out_of_terminal=true
  Ns_3: Coil Terminal Objects=Ns2_Section1 Conductor_number=1 Winding=Ns Point_out_of_terminal=true
  Ns_4: Coil Terminal Objects=Ns3_Section1 Conductor_number=1 Winding=Ns Point_out_of_terminal=true
  Ns_5: Coil Terminal Objects=Ns4_Section1 Conductor_number=1 Winding=Ns Point_out_of_terminal=true
  Ns_6: Coil Terminal Objects=Ns5_Section1 Conductor_number=1 Winding=Ns Point_out_of_terminal=true
  Ns_7: Coil Terminal Objects=Ns6_Section1 Conductor_number=1 Winding=Ns Point_out_of_terminal=true
  Ns_8: Coil Terminal Objects=Ns7_Section1 Conductor_number=1 Winding=Ns Point_out_of_terminal=true
  Np_1: Coil Terminal Objects=Np1_Section1_Separate1 Conductor_number=1 Winding=Np Point_out_of_terminal=false
  Np_2: Coil Terminal Objects=Np2_Section1 Conductor_number=1 Winding=Np Point_out_of_terminal=false
  Np_3: Coil Terminal Objects=Np3_Section1 Conductor_number=1 Winding=Np Point_out_of_terminal=false
  Np_4: Coil Terminal Objects=Np4_Section1 Conductor_number=1 Winding=Np Point_out_of_terminal=false
  Np_5: Coil Terminal Objects=Np5_Section1 Conductor_number=1 Winding=Np Point_out_of_terminal=false
  Np_6: Coil Terminal Objects=Np6_Section1 Conductor_number=1 Winding=Np Point_out_of_terminal=false
  Np_7: Coil Terminal Objects=Np7_Section1 Conductor_number=1 Winding=Np Point_out_of_terminal=false
  Np_8: Coil Terminal Objects=Np8_Section1 Conductor_number=1 Winding=Np Point_out_of_terminal=false
  Np: Winding Group Type=Voltage IsSolid=true Current=16.36A Resistance=0ohm Inductance=0nH Voltage=volt_ac ParallelBranchesNum=1 Phase=0rad
  Ns: Winding Group Type=Current IsSolid=true Current=1000*1.41/volt_ac*1.414 ParallelBranchesNum=1 Phase=180deg
  core loss on: Body1, Body1_3
parameters:
  Matrix1: Matrix Np, Ns:
mesh:
  Length1: LengthBased Objects=[Np1..Np8, Ns1..Ns8, plate1, plate2] MaxLength=5mm
  Length2: LengthBased Objects=[Np1..Np8, Ns1..Ns8, plate1, plate2] MaxLength=0.5mm
  initial mesh: GlobalSurfApproximation{CurvedSurfaceApproxChoice=UseSlider SliderMeshSettings=9} GlobalCurvilinear{Apply}
setups:
  Setup1: EddyCurrent MaximumPasses=20 MinimumPasses=2 MinimumConvergedPasses=1 PercentRefinement=30 PercentError=1 NonLinearResidual=0.0001 SmoothBHCurve Frequency=28.5kHz SweepRanges{0.1Hz to 1Hz, log, 10 per decade 1Hz to 1000Hz, log, 10 per decade 1000Hz to 10000Hz, log, 10 per decade 10000Hz to 100000Hz, log, 10 per decade 100000Hz to 1000000Hz, log, 10 per decade 1000000Hz to 10000000Hz, log, 10 per decade} SaveAllFields
reports:
  L Table 1: Matrix1.L(Np,Np), Matrix1.L(Ns,Np), Matrix1.L(Np,Ns), Matrix1.L(Ns,Ns), Matrix1.R(Np,Np), Matrix1.R(Ns,Np), Matrix1.R(Np,Ns), Matrix1.R(Ns,Ns) vs Freq on Setup1 : LastAdaptive

design Edgewise_0.3_interleaved_full2 (Maxwell 3D, EddyCurrent, model units mm)
variables:
  freq_hz = 28500Hz
  volt_ac = 141/28500*Freq
geometry:
  Region [vacuum] = region(percentage_offset=0 on all sides)
  Np1..Np8, Ns1..Ns8 [copper] = imported_body(C:\Users\karlr\Documents\ICMaSS_sweeping\edgewise_0.1_0.3.step)
  plate1, plate2 [silicon - Copy] = imported_body(C:\Users\karlr\Documents\ICMaSS_sweeping\edgewise_0.1_0.3.step)
  Body1 [ferrite - Copy (2)] = imported_body(C:\Users\karlr\Documents\ICMaSS_sweeping\edgewise_0.1_0.3.step)
  Body1_1, Body1_2 [aluminum] = imported_body(C:\Users\karlr\Documents\ICMaSS_sweeping\edgewise_0.1_0.3.step)
  Body1_3 [ferrite - Copy (2)] = imported_body(C:\Users\karlr\Documents\ICMaSS_sweeping\edgewise_0.1_0.3.step)
  Body1_4, Body1_5 [aluminum] = imported_body(C:\Users\karlr\Documents\ICMaSS_sweeping\edgewise_0.1_0.3.step)
  Np1_Section1 = Np1.section(plane=ZX)
  Np2_Section1 [copper] = Np2.section(plane=ZX)
  Np3_Section1 [copper] = Np3.section(plane=ZX)
  Np4_Section1 [copper] = Np4.section(plane=ZX)
  Np5_Section1 [copper] = Np5.section(plane=ZX)
  Np6_Section1 [copper] = Np6.section(plane=ZX)
  Np7_Section1 [copper] = Np7.section(plane=ZX)
  Np8_Section1 [copper] = Np8.section(plane=ZX)
  Ns1_Section1 [copper] = Ns1.section(plane=ZX)
  Ns2_Section1 [copper] = Ns2.section(plane=ZX)
  Ns3_Section1 [copper] = Ns3.section(plane=ZX)
  Ns4_Section1 [copper] = Ns4.section(plane=ZX)
  Ns5_Section1 [copper] = Ns5.section(plane=ZX)
  Ns6_Section1 [copper] = Ns6.section(plane=ZX)
  Ns7_Section1 [copper] = Ns7.section(plane=ZX)
  Ns8_Section1 = Ns8.section(plane=ZX)
  Np1_Section1_Separate1 [copper] = Np1_Section1.separate_bodies()
  Np1_Section1.delete()
  Np2_Section1.separate_bodies()
  Np3_Section1.separate_bodies()
  Np4_Section1.separate_bodies()
  Np5_Section1.separate_bodies()
  Np6_Section1.separate_bodies()
  Np7_Section1.separate_bodies()
  Np8_Section1.separate_bodies()
  Ns1_Section1.separate_bodies()
  Ns2_Section1.separate_bodies()
  Ns3_Section1.separate_bodies()
  Ns4_Section1.separate_bodies()
  Ns5_Section1.separate_bodies()
  Ns6_Section1.separate_bodies()
  Ns7_Section1.separate_bodies()
  Ns8_Section1_Separate1 [copper] = Ns8_Section1.separate_bodies()
  Ns8_Section1.delete()
  [Np1..Np8, Ns1..Ns8, plate1, plate2, Body1, Body1_1..Body1_5, Np2_Section1, Np3_Section1, Np4_Section1, Np5_Section1, Np6_Section1, Np7_Section1, Np8_Section1, Ns1_Section1, Ns2_Section1, Ns3_Section1, Ns4_Section1, Ns5_Section1, Ns6_Section1, Ns7_Section1, Np1_Section1_Separate1, Ns8_Section1_Separate1].move(-18.666667mm, -25.43mm, -1.6666613e-08mm)
  group core_assembled_edgewise2 = Np1..Np8, Ns1..Ns8, plate1, plate2, Np2_Section1, Np3_Section1, Np4_Section1, Np5_Section1, Np6_Section1, Np7_Section1, Np8_Section1, Ns1_Section1, Ns2_Section1, Ns3_Section1, Ns4_Section1, Ns5_Section1, Ns6_Section1, Ns7_Section1, Np1_Section1_Separate1, Ns8_Section1_Separate1
  group core_together_3 = Body1, Body1_1, Body1_2
  group core_together2 = Body1_3, Body1_4, Body1_5
boundaries and excitations:
  Ns_1: Coil Terminal Objects=Ns8_Section1_Separate1 Conductor_number=1 Winding=Ns Point_out_of_terminal=true
  Ns_2: Coil Terminal Objects=Ns1_Section1 Conductor_number=1 Winding=Ns Point_out_of_terminal=true
  Ns_3: Coil Terminal Objects=Ns2_Section1 Conductor_number=1 Winding=Ns Point_out_of_terminal=true
  Ns_4: Coil Terminal Objects=Ns3_Section1 Conductor_number=1 Winding=Ns Point_out_of_terminal=true
  Ns_5: Coil Terminal Objects=Ns4_Section1 Conductor_number=1 Winding=Ns Point_out_of_terminal=true
  Ns_6: Coil Terminal Objects=Ns5_Section1 Conductor_number=1 Winding=Ns Point_out_of_terminal=true
  Ns_7: Coil Terminal Objects=Ns6_Section1 Conductor_number=1 Winding=Ns Point_out_of_terminal=true
  Ns_8: Coil Terminal Objects=Ns7_Section1 Conductor_number=1 Winding=Ns Point_out_of_terminal=true
  Np_1: Coil Terminal Objects=Np1_Section1_Separate1 Conductor_number=1 Winding=Np Point_out_of_terminal=false
  Np_2: Coil Terminal Objects=Np2_Section1 Conductor_number=1 Winding=Np Point_out_of_terminal=false
  Np_3: Coil Terminal Objects=Np3_Section1 Conductor_number=1 Winding=Np Point_out_of_terminal=false
  Np_4: Coil Terminal Objects=Np4_Section1 Conductor_number=1 Winding=Np Point_out_of_terminal=false
  Np_5: Coil Terminal Objects=Np5_Section1 Conductor_number=1 Winding=Np Point_out_of_terminal=false
  Np_6: Coil Terminal Objects=Np6_Section1 Conductor_number=1 Winding=Np Point_out_of_terminal=false
  Np_7: Coil Terminal Objects=Np7_Section1 Conductor_number=1 Winding=Np Point_out_of_terminal=false
  Np_8: Coil Terminal Objects=Np8_Section1 Conductor_number=1 Winding=Np Point_out_of_terminal=false
  Np: Winding Group Type=Voltage IsSolid=true Current=16.36A Resistance=0ohm Inductance=0nH Voltage=volt_ac ParallelBranchesNum=1 Phase=0rad
  Ns: Winding Group Type=Current IsSolid=true Current=1000*1.41/volt_ac*1.414 ParallelBranchesNum=1 Phase=180deg
  core loss on: Body1, Body1_3
parameters:
  Matrix1: Matrix Np, Ns:
mesh:
  Length1: LengthBased Objects=[Np1..Np8, Ns1..Ns8, plate1, plate2] MaxLength=5mm
  Length2: LengthBased Objects=[Np1..Np8, Ns1..Ns8, plate1, plate2] MaxLength=2mm
  initial mesh: GlobalSurfApproximation{CurvedSurfaceApproxChoice=UseSlider SliderMeshSettings=9} GlobalCurvilinear{Apply}
setups:
  Setup1: EddyCurrent MaximumPasses=20 MinimumPasses=2 MinimumConvergedPasses=1 PercentRefinement=30 PercentError=1 NonLinearResidual=0.0001 SmoothBHCurve Frequency=28.5kHz SweepRanges{0.1Hz to 1Hz, log, 10 per decade 1Hz to 1000Hz, log, 10 per decade 1000Hz to 10000Hz, log, 10 per decade 10000Hz to 100000Hz, log, 10 per decade 100000Hz to 1000000Hz, log, 10 per decade 1000000Hz to 10000000Hz, log, 10 per decade} SaveAllFields
field plots:
  Mag_B1: B over Body1, Body1_3 on Setup1 : LastAdaptive at Freq=28.5kHz Phase=45deg
  Mag_J1: J over Np1_Section1_Separate1.face Np2_Section1.face(at (9.33333, -25.43, 6.95)) Np3_Section1.face(at (9.33333, -25.43, 7.75)) Np4_Section1.face(at (9.33333, -25.43, 8.55)) Np5_Section1.face(at (9.33333, -25.43, 9.35)) Np6_Section1.face(at (9.33333, -25.43, 10.15)) Np7_Section1.face(at (9.33333, -25.43, 10.95)) Np8_Section1.face(at (9.33333, -25.43, 11.75)) Ns1_Section1.face(at (9.33333, -25.43, 6.55)) Ns2_Section1.face(at (9.33333, -25.43, 7.35)) Ns3_Section1.face(at (9.33333, -25.43, 8.15)) Ns4_Section1.face(at (9.33333, -25.43, 8.95)) Ns5_Section1.face(at (9.33333, -25.43, 9.75)) Ns6_Section1.face(at (9.33333, -25.43, 10.55)) Ns7_Section1.face(at (9.33333, -25.43, 11.35)) Ns8_Section1_Separate1.face on Setup1 : LastAdaptive at Freq=28.5kHz Phase=0deg
reports:
  L Table 1: Matrix1.L(Np,Np), Matrix1.L(Ns,Np), Matrix1.L(Np,Ns), Matrix1.L(Ns,Ns), Matrix1.R(Np,Np), Matrix1.R(Ns,Np), Matrix1.R(Np,Ns), Matrix1.R(Ns,Ns) vs Freq on Setup1 : LastAdaptive

design Edgewise_0.3_interleaved_full_INTERWINDING (Maxwell 3D, Electrostatic, model units mm)
variables:
  freq_hz = 28500Hz
  volt_ac = 141/28500*Freq
geometry:
  Region [vacuum] = region(percentage_offset=0 on all sides)
  Np1..Np8, Ns1..Ns8 [copper] = imported_body(C:\Users\karlr\Documents\ICMaSS_sweeping\edgewise_0.1_0.3.step)
  plate1, plate2 [silicon - Copy] = imported_body(C:\Users\karlr\Documents\ICMaSS_sweeping\edgewise_0.1_0.3.step)
  Body1 [ferrite - Copy (2)] = imported_body(C:\Users\karlr\Documents\ICMaSS_sweeping\edgewise_0.1_0.3.step)
  Body1_1, Body1_2 [aluminum] = imported_body(C:\Users\karlr\Documents\ICMaSS_sweeping\edgewise_0.1_0.3.step)
  Body1_3 [ferrite - Copy (2)] = imported_body(C:\Users\karlr\Documents\ICMaSS_sweeping\edgewise_0.1_0.3.step)
  Body1_4, Body1_5 [aluminum] = imported_body(C:\Users\karlr\Documents\ICMaSS_sweeping\edgewise_0.1_0.3.step)
  Np1_Section1 = Np1.section(plane=ZX)
  Np2_Section1 [copper] = Np2.section(plane=ZX)
  Np3_Section1 [copper] = Np3.section(plane=ZX)
  Np4_Section1 [copper] = Np4.section(plane=ZX)
  Np5_Section1 [copper] = Np5.section(plane=ZX)
  Np6_Section1 [copper] = Np6.section(plane=ZX)
  Np7_Section1 [copper] = Np7.section(plane=ZX)
  Np8_Section1 [copper] = Np8.section(plane=ZX)
  Ns1_Section1 [copper] = Ns1.section(plane=ZX)
  Ns2_Section1 [copper] = Ns2.section(plane=ZX)
  Ns3_Section1 [copper] = Ns3.section(plane=ZX)
  Ns4_Section1 [copper] = Ns4.section(plane=ZX)
  Ns5_Section1 [copper] = Ns5.section(plane=ZX)
  Ns6_Section1 [copper] = Ns6.section(plane=ZX)
  Ns7_Section1 [copper] = Ns7.section(plane=ZX)
  Ns8_Section1 = Ns8.section(plane=ZX)
  Np1_Section1_Separate1 [copper] = Np1_Section1.separate_bodies()
  Np1_Section1.delete()
  Np2_Section1.separate_bodies()
  Np3_Section1.separate_bodies()
  Np4_Section1.separate_bodies()
  Np5_Section1.separate_bodies()
  Np6_Section1.separate_bodies()
  Np7_Section1.separate_bodies()
  Np8_Section1.separate_bodies()
  Ns1_Section1.separate_bodies()
  Ns2_Section1.separate_bodies()
  Ns3_Section1.separate_bodies()
  Ns4_Section1.separate_bodies()
  Ns5_Section1.separate_bodies()
  Ns6_Section1.separate_bodies()
  Ns7_Section1.separate_bodies()
  Ns8_Section1_Separate1 [copper] = Ns8_Section1.separate_bodies()
  Ns8_Section1.delete()
  [Np1..Np8, Ns1..Ns8, plate1, plate2, Body1, Body1_1..Body1_5, Np2_Section1, Np3_Section1, Np4_Section1, Np5_Section1, Np6_Section1, Np7_Section1, Np8_Section1, Ns1_Section1, Ns2_Section1, Ns3_Section1, Ns4_Section1, Ns5_Section1, Ns6_Section1, Ns7_Section1, Np1_Section1_Separate1, Ns8_Section1_Separate1].move(-18.666667mm, -25.43mm, -1.6666613e-08mm)
  group core_assembled_edgewise2 = Np1..Np8, Ns1..Ns8, plate1, plate2, Np2_Section1, Np3_Section1, Np4_Section1, Np5_Section1, Np6_Section1, Np7_Section1, Np8_Section1, Ns1_Section1, Ns2_Section1, Ns3_Section1, Ns4_Section1, Ns5_Section1, Ns6_Section1, Ns7_Section1, Np1_Section1_Separate1, Ns8_Section1_Separate1
  group core_together_3 = Body1, Body1_1, Body1_2
  group core_together2 = Body1_3, Body1_4, Body1_5
boundaries and excitations:
  Voltage1: Voltage Objects=[Np1..Np8] Voltage=1V
  Voltage2: Voltage Objects=[Ns1..Ns8] Voltage=0mV
parameters:
  Matrix1: Matrix Voltage1, Voltage2: NumberOfTurns=1
mesh:
  Length1: LengthBased Objects=[Np1..Np8, Ns1..Ns8, plate1, plate2] MaxLength=5mm
  Length2: LengthBased Objects=[Np1..Np8, Ns1..Ns8, plate1, plate2] MaxLength=2mm
  initial mesh: GlobalSurfApproximation{CurvedSurfaceApproxChoice=UseSlider SliderMeshSettings=9} GlobalCurvilinear{Apply}
setups:
  Setup1: Electrostatic MaximumPasses=20 MinimumPasses=2 MinimumConvergedPasses=1 PercentRefinement=30 PercentError=1 NonLinearResidual=0.001

design Edgewise_0.3_interleaved_full_EFIELD (Maxwell 3D, Electrostatic, model units mm)
variables:
  freq_hz = 28500Hz
  volt_ac = 141/28500*Freq
geometry:
  Region [vacuum] = region(percentage_offset=0 on all sides)
  Np1..Np8, Ns1..Ns8 [copper] = imported_body(C:\Users\karlr\Documents\ICMaSS_sweeping\edgewise_0.1_0.3.step)
  plate1, plate2 [silicon - Copy] = imported_body(C:\Users\karlr\Documents\ICMaSS_sweeping\edgewise_0.1_0.3.step)
  Body1 [ferrite - Copy (2)] = imported_body(C:\Users\karlr\Documents\ICMaSS_sweeping\edgewise_0.1_0.3.step)
  Body1_1, Body1_2 [aluminum] = imported_body(C:\Users\karlr\Documents\ICMaSS_sweeping\edgewise_0.1_0.3.step)
  Body1_3 [ferrite - Copy (2)] = imported_body(C:\Users\karlr\Documents\ICMaSS_sweeping\edgewise_0.1_0.3.step)
  Body1_4, Body1_5 [aluminum] = imported_body(C:\Users\karlr\Documents\ICMaSS_sweeping\edgewise_0.1_0.3.step)
  Np1_Section1 = Np1.section(plane=ZX)
  Np2_Section1 [copper] = Np2.section(plane=ZX)
  Np3_Section1 [copper] = Np3.section(plane=ZX)
  Np4_Section1 [copper] = Np4.section(plane=ZX)
  Np5_Section1 [copper] = Np5.section(plane=ZX)
  Np6_Section1 [copper] = Np6.section(plane=ZX)
  Np7_Section1 [copper] = Np7.section(plane=ZX)
  Np8_Section1 [copper] = Np8.section(plane=ZX)
  Ns1_Section1 [copper] = Ns1.section(plane=ZX)
  Ns2_Section1 [copper] = Ns2.section(plane=ZX)
  Ns3_Section1 [copper] = Ns3.section(plane=ZX)
  Ns4_Section1 [copper] = Ns4.section(plane=ZX)
  Ns5_Section1 [copper] = Ns5.section(plane=ZX)
  Ns6_Section1 [copper] = Ns6.section(plane=ZX)
  Ns7_Section1 [copper] = Ns7.section(plane=ZX)
  Ns8_Section1 = Ns8.section(plane=ZX)
  Np1_Section1_Separate1 [copper] = Np1_Section1.separate_bodies()
  Np1_Section1.delete()
  Np2_Section1.separate_bodies()
  Np3_Section1.separate_bodies()
  Np4_Section1.separate_bodies()
  Np5_Section1.separate_bodies()
  Np6_Section1.separate_bodies()
  Np7_Section1.separate_bodies()
  Np8_Section1.separate_bodies()
  Ns1_Section1.separate_bodies()
  Ns2_Section1.separate_bodies()
  Ns3_Section1.separate_bodies()
  Ns4_Section1.separate_bodies()
  Ns5_Section1.separate_bodies()
  Ns6_Section1.separate_bodies()
  Ns7_Section1.separate_bodies()
  Ns8_Section1_Separate1 [copper] = Ns8_Section1.separate_bodies()
  Ns8_Section1.delete()
  [Np1..Np8, Ns1..Ns8, plate1, plate2, Body1, Body1_1..Body1_5, Np2_Section1, Np3_Section1, Np4_Section1, Np5_Section1, Np6_Section1, Np7_Section1, Np8_Section1, Ns1_Section1, Ns2_Section1, Ns3_Section1, Ns4_Section1, Ns5_Section1, Ns6_Section1, Ns7_Section1, Np1_Section1_Separate1, Ns8_Section1_Separate1].move(-18.666667mm, -25.43mm, -1.6666613e-08mm)
  Rectangle1 [non-model] = rectangle(corner=(18.666667mm, 0mm, -1.6666613e-08mm), z_size=18.3mm, x_size=-37.333333mm)
  group core_assembled_edgewise2 = Np1..Np8, Ns1..Ns8, plate1, plate2, Np2_Section1, Np3_Section1, Np4_Section1, Np5_Section1, Np6_Section1, Np7_Section1, Np8_Section1, Ns1_Section1, Ns2_Section1, Ns3_Section1, Ns4_Section1, Ns5_Section1, Ns6_Section1, Ns7_Section1, Np1_Section1_Separate1, Ns8_Section1_Separate1
  group core_together_3 = Body1, Body1_1, Body1_2
  group core_together2 = Body1_3, Body1_4, Body1_5
boundaries and excitations:
  Voltage1: Voltage Objects=[Np1..Np8] Voltage=100V
  Voltage2: Voltage Objects=[Ns1..Ns8] Voltage=0mV
parameters:
  Matrix1: Matrix Voltage1, Voltage2: NumberOfTurns=1
mesh:
  Length1: LengthBased Objects=[Np1..Np8, Ns1..Ns8, plate1, plate2] MaxLength=5mm
  Length2: LengthBased Objects=[Np1..Np8, Ns1..Ns8, plate1, plate2] MaxLength=2mm
  initial mesh: GlobalSurfApproximation{CurvedSurfaceApproxChoice=UseSlider SliderMeshSettings=9} GlobalCurvilinear{Apply}
setups:
  Setup1: Electrostatic MaximumPasses=20 MinimumPasses=2 MinimumConvergedPasses=1 PercentRefinement=30 PercentError=1 NonLinearResidual=0.001
field plots:
  Mag_E1: E over a plane on Setup1 : LastAdaptive

design Maxwell2DDesign1 (Maxwell 2D, EddyCurrent, XY geometry, model units mm)
options: ModelDepth=1meter
geometry:
  Region [vacuum] = region(percentage_offset: +X=100, -X=0, +Y=100, -Y=100, +Z=0, -Z=0)
  Np1#25790, Np2#25842, Np3#25894, Np4#25946, Np5#25998, Np6#26050, Np7#26102, Np8#26154, Ns1#26206, Ns2#26258, Ns3#26310, Ns4#26362, Ns5#26414, Ns6#26466, Ns7#26518, Ns8#26570, plate1#26622, plate2#26674, Body1#26726, Body1_3#26906 = imported_body(C:\Users\karlr\Documents\ICMaSS_sweeping\edgewise_0.1_0.3.step)
  [Np1#25790, Np2#25842, Np3#25894, Np4#25946, Np5#25998, Np6#26050, Np7#26102, Np8#26154, Ns1#26206, Ns2#26258, Ns3#26310, Ns4#26362, Ns5#26414, Ns6#26466, Ns7#26518, Ns8#26570, plate1#26622, plate2#26674, Body1#26726, Body1_3#26906].move(-18.666667mm, -25.43mm, -1.6666613e-08mm)
  Np1 [copper] = Np1#25790.section(plane=ZX)
  Np1#25790.delete()
  Np1.rotate(axis=X, angle=-90deg)
  Np2 [copper] = Np2#25842.section(plane=ZX)
  Np2#25842.delete()
  Np2.rotate(axis=X, angle=-90deg)
  Np3 [copper] = Np3#25894.section(plane=ZX)
  Np3#25894.delete()
  Np3.rotate(axis=X, angle=-90deg)
  Np4 [copper] = Np4#25946.section(plane=ZX)
  Np4#25946.delete()
  Np4.rotate(axis=X, angle=-90deg)
  Np5 [copper] = Np5#25998.section(plane=ZX)
  Np5#25998.delete()
  Np5.rotate(axis=X, angle=-90deg)
  Np6 [copper] = Np6#26050.section(plane=ZX)
  Np6#26050.delete()
  Np6.rotate(axis=X, angle=-90deg)
  Np7 [copper] = Np7#26102.section(plane=ZX)
  Np7#26102.delete()
  Np7.rotate(axis=X, angle=-90deg)
  Np8 [copper] = Np8#26154.section(plane=ZX)
  Np8#26154.delete()
  Np8.rotate(axis=X, angle=-90deg)
  Ns1 [copper] = Ns1#26206.section(plane=ZX)
  Ns1#26206.delete()
  Ns1.rotate(axis=X, angle=-90deg)
  Ns2 [copper] = Ns2#26258.section(plane=ZX)
  Ns2#26258.delete()
  Ns2.rotate(axis=X, angle=-90deg)
  Ns3 [copper] = Ns3#26310.section(plane=ZX)
  Ns3#26310.delete()
  Ns3.rotate(axis=X, angle=-90deg)
  Ns4 [copper] = Ns4#26362.section(plane=ZX)
  Ns4#26362.delete()
  Ns4.rotate(axis=X, angle=-90deg)
  Ns5 [copper] = Ns5#26414.section(plane=ZX)
  Ns5#26414.delete()
  Ns5.rotate(axis=X, angle=-90deg)
  Ns6 [copper] = Ns6#26466.section(plane=ZX)
  Ns6#26466.delete()
  Ns6.rotate(axis=X, angle=-90deg)
  Ns7 [copper] = Ns7#26518.section(plane=ZX)
  Ns7#26518.delete()
  Ns7.rotate(axis=X, angle=-90deg)
  Ns8 [copper] = Ns8#26570.section(plane=ZX)
  Ns8#26570.delete()
  Ns8.rotate(axis=X, angle=-90deg)
  plate1 [silicon - Copy] = plate1#26622.section(plane=ZX)
  plate1#26622.delete()
  plate1.rotate(axis=X, angle=-90deg)
  plate2 [silicon - Copy] = plate2#26674.section(plane=ZX)
  plate2#26674.delete()
  plate2.rotate(axis=X, angle=-90deg)
  Body1 [ferrite - Copy (2)] = Body1#26726.section(plane=ZX)
  Body1#26726.delete()
  Body1.rotate(axis=X, angle=-90deg)
  Body1_3 [ferrite - Copy (2)] = Body1_3#26906.section(plane=ZX)
  Body1_3#26906.delete()
  Body1_3.rotate(axis=X, angle=-90deg)
  [Np1..Np8, Ns1..Ns8, plate1, plate2, Body1, Body1_3].split(plane=YZ, keep=PositiveOnly)
  group core_assembled_edgewise2 = Np1..Np8, Ns1..Ns8, plate1, plate2
  group core_together_3 = Body1
  group core_together2 = Body1_3
boundaries and excitations:
  Balloon1: Balloon Edges=Region.edge(at (18.6667, 36.6, 0), at (37.3333, 9.15, 0), at (18.6667, -18.3, 0))
  Symmetry1: Symmetry Edges=Region.edge(at (0, 9.15, 0)) IsOdd=true
  Current_1: Current Objects=Np1 Phase=0deg Current=1A IsSolid=true IsPositive=true
  Current_2: Current Objects=Np2 Phase=0deg Current=1A IsSolid=true IsPositive=true
  Current_3: Current Objects=Np3 Phase=0deg Current=1A IsSolid=true IsPositive=true
  Current_4: Current Objects=Np4 Phase=0deg Current=1A IsSolid=true IsPositive=true
  Current_5: Current Objects=Np5 Phase=0deg Current=1A IsSolid=true IsPositive=true
  Current_6: Current Objects=Np6 Phase=0deg Current=1A IsSolid=true IsPositive=true
  Current_7: Current Objects=Np7 Phase=0deg Current=1A IsSolid=true IsPositive=true
  Current_8: Current Objects=Np8 Phase=0deg Current=1A IsSolid=true IsPositive=true
  Current_9: Current Objects=Ns1 Phase=0deg Current=-1A IsSolid=true IsPositive=true
  Current_10: Current Objects=Ns2 Phase=0deg Current=-1A IsSolid=true IsPositive=true
  Current_11: Current Objects=Ns3 Phase=0deg Current=-1A IsSolid=true IsPositive=true
  Current_12: Current Objects=Ns4 Phase=0deg Current=-1A IsSolid=true IsPositive=true
  Current_13: Current Objects=Ns5 Phase=0deg Current=-1A IsSolid=true IsPositive=true
  Current_14: Current Objects=Ns6 Phase=0deg Current=-1A IsSolid=true IsPositive=true
  Current_15: Current Objects=Ns7 Phase=0deg Current=-1A IsSolid=true IsPositive=true
  Current_16: Current Objects=Ns8 Phase=0deg Current=-1A IsSolid=true IsPositive=true
  eddy effects on: Np1..Np8, Ns1..Ns8
mesh:
  Length1: LengthBased Objects=[Np1..Np8, Ns1..Ns8, plate1, plate2, Body1, Body1_3] MaxLength=0.1mm
setups:
  Setup1: EddyCurrent MaximumPasses=20 MinimumPasses=2 MinimumConvergedPasses=1 PercentRefinement=30 PercentError=1 NonLinearResidual=0.0001 Frequency=28500Hz
field plots:
  JAtPhase1: J over Np1..Np8, Ns1..Ns8 on Setup1 : LastAdaptive at Freq=28.5kHz Phase=45deg

design [Thermal]Edgewise_0.2_fix (Icepak, SteadyState TemperatureAndFlow, model units mm)
options: Default_Fluid_Material=air Default_Solid_Material=Al-Extruded Default_Surface_Material=Steel-oxidised-surface AmbientTemperature=25cel AmbientPressure=0n_per_meter_sq AmbientRadiationTemperature=25cel Gravity_Vector_CS_ID=Global Gravity_Vector_Axis=Z Positive=false SherlockExportDirectory=C:/Users/karlr/Documents/Ansoft/1kW_Final.aedtexport/[Thermal]8turns_3D_CoreLoss_FullInterleaved_Flatwise/ Altitude=0meter
geometry:
  Region [air] = region(percentage_offset=1000 on all sides)
  Np1 [copper] = imported_body(C:\Users\karlr\Documents\ICMaSS_sweeping\edgewise_0.1_0.2.step)
  Np2 [copper] = imported_body(C:\Users\karlr\Documents\ICMaSS_sweeping\edgewise_0.1_0.2.step)
  Np3 [copper] = imported_body(C:\Users\karlr\Documents\ICMaSS_sweeping\edgewise_0.1_0.2.step)
  Np4 [copper] = imported_body(C:\Users\karlr\Documents\ICMaSS_sweeping\edgewise_0.1_0.2.step)
  Np5 [copper] = imported_body(C:\Users\karlr\Documents\ICMaSS_sweeping\edgewise_0.1_0.2.step)
  Np6 [copper] = imported_body(C:\Users\karlr\Documents\ICMaSS_sweeping\edgewise_0.1_0.2.step)
  Np7 [copper] = imported_body(C:\Users\karlr\Documents\ICMaSS_sweeping\edgewise_0.1_0.2.step)
  Np8 [copper] = imported_body(C:\Users\karlr\Documents\ICMaSS_sweeping\edgewise_0.1_0.2.step)
  Ns1 [copper] = imported_body(C:\Users\karlr\Documents\ICMaSS_sweeping\edgewise_0.1_0.2.step)
  Ns2 [copper] = imported_body(C:\Users\karlr\Documents\ICMaSS_sweeping\edgewise_0.1_0.2.step)
  Ns3 [copper] = imported_body(C:\Users\karlr\Documents\ICMaSS_sweeping\edgewise_0.1_0.2.step)
  Ns4 [copper] = imported_body(C:\Users\karlr\Documents\ICMaSS_sweeping\edgewise_0.1_0.2.step)
  Ns5 [copper] = imported_body(C:\Users\karlr\Documents\ICMaSS_sweeping\edgewise_0.1_0.2.step)
  Ns6 [copper] = imported_body(C:\Users\karlr\Documents\ICMaSS_sweeping\edgewise_0.1_0.2.step)
  Ns7 [copper] = imported_body(C:\Users\karlr\Documents\ICMaSS_sweeping\edgewise_0.1_0.2.step)
  Ns8 [copper] = imported_body(C:\Users\karlr\Documents\ICMaSS_sweeping\edgewise_0.1_0.2.step)
  plate1, plate2 [silicon - Copy] = imported_body(C:\Users\karlr\Documents\ICMaSS_sweeping\edgewise_0.1_0.2.step)
  Body1 [ferrite - Copy (2)] = imported_body(C:\Users\karlr\Documents\ICMaSS_sweeping\edgewise_0.1_0.2.step)
  Body1_1, Body1_2 [aluminum] = imported_body(C:\Users\karlr\Documents\ICMaSS_sweeping\edgewise_0.1_0.2.step)
  Body1_3 [ferrite - Copy (2)] = imported_body(C:\Users\karlr\Documents\ICMaSS_sweeping\edgewise_0.1_0.2.step)
  Body1_4, Body1_5 [aluminum] = imported_body(C:\Users\karlr\Documents\ICMaSS_sweeping\edgewise_0.1_0.2.step)
  Rectangle1 [Al-Extruded, non-model] = rectangle(corner=(44mm, 25.475mm, 0mm), z_size=16.7mm, x_size=-44mm)
  group core_together_1 = Body1, Body1_1, Body1_2
  group core_together = Body1_3, Body1_4, Body1_5
  group core_assembled_edgewise = Np1..Np8, Ns1..Ns8, plate1, plate2
boundaries and excitations:
  Opening1: Opening Faces=Region.face(-y) Temperature=AmbientTemp External_Rad._Temperature=AmbientRadTemp Inlet_Type=Pressure Total_Pressure=AmbientPressure
  Opening2: Opening Faces=Region.face(+y) Temperature=AmbientTemp External_Rad._Temperature=AmbientRadTemp Inlet_Type=Velocity Static_Pressure=AmbientPressure X_Velocity=0m_per_sec Y_Velocity=0m_per_sec Z_Velocity=0m_per_sec
  EMLoss1: EM Loss Objects=[Body1, Body1_1..Body1_5, Np1..Np8, Ns1..Ns8] LinkID=418 Project="This Project*" Product=ElectronicsDesktop Design=Edgewise_0.2_interleaved_full Params{freq_hz=28500Hz} ForceSourceToSolve PreservePartnerSoln PathRelativeTo=TargetProject Intrinsics(28.5kHz) LossMultiplier=1
mesh:
  MeshRegions:  Global{MeshMethod=MesherHD ComputeGap MeshRegionResolution=5 MinGapX=1mm MinGapY=1mm MinGapZ=1mm Objects=Region FacetLevel=5 ProximitySizeFunction CurvatureSizeFunction OptimizePCBMesh}
  MeshOperations:
setups:
  Setup1: IcepakSteadyState Flow_Regime=Laminar Include_Temperature=true Include_Flow=true Include_Gravity Solution_Initialization_-_Z_Velocity=0.000980665m_per_sec Convergence_Criteria_-_Flow=0.001 Convergence_Criteria_-_Energy=1e-07 Convergence_Criteria_-_Discrete_Ordinates=1e-06 Radiation_Model="Discrete Ordinates Model" Flow_Iteration_Per_Radiation_Iteration=10 ThetaDivision=2 PhiDivision=2 ThetaPixels=2 PhiPixels=2 Under-relaxation_-_Pressure=0.7 Under-relaxation_-_Momentum=0.3 Under-relaxation_-_Temperature=1 Discretization_Scheme_-_Pressure=Standard Discretization_Scheme_-_Momentum=First Discretization_Scheme_-_Temperature=First Discretization_Scheme_-_Discrete_Ordinates=First Convergence_Criteria_-_Max_Iterations=10000
field plots:
  Temperature1: Temperature over Np1..Np8, Ns1..Ns8, plate1, plate2, Body1, Body1_1..Body1_5 on Setup1 : SteadyState
  Temperature2: Temperature over a plane on Setup1 : SteadyState

design [Thermal]Edgewise_0.3_fix (Icepak, SteadyState TemperatureAndFlow, model units mm)
options: Default_Fluid_Material=air Default_Solid_Material=Al-Extruded Default_Surface_Material=Steel-oxidised-surface AmbientTemperature=25cel AmbientPressure=0n_per_meter_sq AmbientRadiationTemperature=25cel Gravity_Vector_CS_ID=Global Gravity_Vector_Axis=Z Positive=false SherlockExportDirectory=C:/Users/karlr/Documents/Ansoft/1kW_Final.aedtexport/[Thermal]8turns_3D_CoreLoss_FullInterleaved_Flatwise/ Altitude=0meter
geometry:
  Region [air] = region(percentage_offset=1000 on all sides)
  Np1 [copper] = imported_body(C:\Users\karlr\Documents\ICMaSS_sweeping\edgewise_0.1_0.3.step)
  Np2 [copper] = imported_body(C:\Users\karlr\Documents\ICMaSS_sweeping\edgewise_0.1_0.3.step)
  Np3 [copper] = imported_body(C:\Users\karlr\Documents\ICMaSS_sweeping\edgewise_0.1_0.3.step)
  Np4 [copper] = imported_body(C:\Users\karlr\Documents\ICMaSS_sweeping\edgewise_0.1_0.3.step)
  Np5 [copper] = imported_body(C:\Users\karlr\Documents\ICMaSS_sweeping\edgewise_0.1_0.3.step)
  Np6 [copper] = imported_body(C:\Users\karlr\Documents\ICMaSS_sweeping\edgewise_0.1_0.3.step)
  Np7 [copper] = imported_body(C:\Users\karlr\Documents\ICMaSS_sweeping\edgewise_0.1_0.3.step)
  Np8 [copper] = imported_body(C:\Users\karlr\Documents\ICMaSS_sweeping\edgewise_0.1_0.3.step)
  Ns1 [copper] = imported_body(C:\Users\karlr\Documents\ICMaSS_sweeping\edgewise_0.1_0.3.step)
  Ns2 [copper] = imported_body(C:\Users\karlr\Documents\ICMaSS_sweeping\edgewise_0.1_0.3.step)
  Ns3 [copper] = imported_body(C:\Users\karlr\Documents\ICMaSS_sweeping\edgewise_0.1_0.3.step)
  Ns4 [copper] = imported_body(C:\Users\karlr\Documents\ICMaSS_sweeping\edgewise_0.1_0.3.step)
  Ns5 [copper] = imported_body(C:\Users\karlr\Documents\ICMaSS_sweeping\edgewise_0.1_0.3.step)
  Ns6 [copper] = imported_body(C:\Users\karlr\Documents\ICMaSS_sweeping\edgewise_0.1_0.3.step)
  Ns7 [copper] = imported_body(C:\Users\karlr\Documents\ICMaSS_sweeping\edgewise_0.1_0.3.step)
  Ns8 [copper] = imported_body(C:\Users\karlr\Documents\ICMaSS_sweeping\edgewise_0.1_0.3.step)
  plate1, plate2 [silicon - Copy] = imported_body(C:\Users\karlr\Documents\ICMaSS_sweeping\edgewise_0.1_0.3.step)
  Body1 [ferrite - Copy (2)] = imported_body(C:\Users\karlr\Documents\ICMaSS_sweeping\edgewise_0.1_0.3.step)
  Body1_1, Body1_2 [aluminum] = imported_body(C:\Users\karlr\Documents\ICMaSS_sweeping\edgewise_0.1_0.3.step)
  Body1_3 [ferrite - Copy (2)] = imported_body(C:\Users\karlr\Documents\ICMaSS_sweeping\edgewise_0.1_0.3.step)
  Body1_4, Body1_5 [aluminum] = imported_body(C:\Users\karlr\Documents\ICMaSS_sweeping\edgewise_0.1_0.3.step)
  Rectangle1 [Al-Extruded, non-model] = rectangle(corner=(37.333333mm, 25.43mm, 0mm), z_size=18.3mm, x_size=-37.333333mm)
  group core_assembled_edgewise2 = Np1..Np8, Ns1..Ns8, plate1, plate2
  group core_together_3 = Body1, Body1_1, Body1_2
  group core_together2 = Body1_3, Body1_4, Body1_5
boundaries and excitations:
  Opening1: Opening Faces=Region.face(-y) Temperature=AmbientTemp External_Rad._Temperature=AmbientRadTemp Inlet_Type=Pressure Total_Pressure=AmbientPressure
  Opening2: Opening Faces=Region.face(+y) Temperature=AmbientTemp External_Rad._Temperature=AmbientRadTemp Inlet_Type=Velocity Static_Pressure=AmbientPressure X_Velocity=0m_per_sec Y_Velocity=0m_per_sec Z_Velocity=0m_per_sec
  EMLoss1: EM Loss Objects=[Body1, Body1_1..Body1_5, Np1..Np8, Ns1..Ns8] LinkID=433 Project="This Project*" Product=ElectronicsDesktop Design=Edgewise_0.3_interleaved_full Params{freq_hz=28500Hz} ForceSourceToSolve PreservePartnerSoln PathRelativeTo=TargetProject Intrinsics(28.5kHz) LossMultiplier=1
mesh:
  MeshRegions:  Global{MeshMethod=MesherHD ComputeGap MeshRegionResolution=5 MinGapX=1mm MinGapY=1mm MinGapZ=1mm Objects=Region FacetLevel=5 ProximitySizeFunction CurvatureSizeFunction OptimizePCBMesh}
  MeshOperations:
setups:
  Setup1: IcepakSteadyState Flow_Regime=Laminar Include_Temperature=true Include_Flow=true Include_Gravity Solution_Initialization_-_Z_Velocity=0.000980665m_per_sec Convergence_Criteria_-_Flow=0.001 Convergence_Criteria_-_Energy=1e-07 Convergence_Criteria_-_Discrete_Ordinates=1e-06 Radiation_Model="Discrete Ordinates Model" Flow_Iteration_Per_Radiation_Iteration=10 ThetaDivision=2 PhiDivision=2 ThetaPixels=2 PhiPixels=2 Under-relaxation_-_Pressure=0.7 Under-relaxation_-_Momentum=0.3 Under-relaxation_-_Temperature=1 Discretization_Scheme_-_Pressure=Standard Discretization_Scheme_-_Momentum=First Discretization_Scheme_-_Temperature=First Discretization_Scheme_-_Discrete_Ordinates=First Convergence_Criteria_-_Max_Iterations=10000
field plots:
  Temperature1: Temperature over a plane on Setup1 : SteadyState
  Temperature2: Temperature on Setup1 : SteadyState

design [Thermal]Edgewise_0.4_fix (Icepak, SteadyState TemperatureAndFlow, model units mm)
options: Default_Fluid_Material=air Default_Solid_Material=Al-Extruded Default_Surface_Material=Steel-oxidised-surface AmbientTemperature=25cel AmbientPressure=0n_per_meter_sq AmbientRadiationTemperature=25cel Gravity_Vector_CS_ID=Global Gravity_Vector_Axis=Z Positive=false SherlockExportDirectory=C:/Users/karlr/Documents/Ansoft/1kW_Final.aedtexport/[Thermal]8turns_3D_CoreLoss_FullInterleaved_Flatwise/ Altitude=0meter
geometry:
  Region [air] = region(percentage_offset=1000 on all sides)
  Np1 [copper] = imported_body(C:\Users\karlr\Documents\ICMaSS_sweeping\edgewise_0.1_0.4.step)
  Np2 [copper] = imported_body(C:\Users\karlr\Documents\ICMaSS_sweeping\edgewise_0.1_0.4.step)
  Np3 [copper] = imported_body(C:\Users\karlr\Documents\ICMaSS_sweeping\edgewise_0.1_0.4.step)
  Np4 [copper] = imported_body(C:\Users\karlr\Documents\ICMaSS_sweeping\edgewise_0.1_0.4.step)
  Np5 [copper] = imported_body(C:\Users\karlr\Documents\ICMaSS_sweeping\edgewise_0.1_0.4.step)
  Np6 [copper] = imported_body(C:\Users\karlr\Documents\ICMaSS_sweeping\edgewise_0.1_0.4.step)
  Np7 [copper] = imported_body(C:\Users\karlr\Documents\ICMaSS_sweeping\edgewise_0.1_0.4.step)
  Np8 [copper] = imported_body(C:\Users\karlr\Documents\ICMaSS_sweeping\edgewise_0.1_0.4.step)
  Ns1 [copper] = imported_body(C:\Users\karlr\Documents\ICMaSS_sweeping\edgewise_0.1_0.4.step)
  Ns2 [copper] = imported_body(C:\Users\karlr\Documents\ICMaSS_sweeping\edgewise_0.1_0.4.step)
  Ns3 [copper] = imported_body(C:\Users\karlr\Documents\ICMaSS_sweeping\edgewise_0.1_0.4.step)
  Ns4 [copper] = imported_body(C:\Users\karlr\Documents\ICMaSS_sweeping\edgewise_0.1_0.4.step)
  Ns5 [copper] = imported_body(C:\Users\karlr\Documents\ICMaSS_sweeping\edgewise_0.1_0.4.step)
  Ns6 [copper] = imported_body(C:\Users\karlr\Documents\ICMaSS_sweeping\edgewise_0.1_0.4.step)
  Ns7 [copper] = imported_body(C:\Users\karlr\Documents\ICMaSS_sweeping\edgewise_0.1_0.4.step)
  Ns8 [copper] = imported_body(C:\Users\karlr\Documents\ICMaSS_sweeping\edgewise_0.1_0.4.step)
  plate1, plate2 [silicon - Copy] = imported_body(C:\Users\karlr\Documents\ICMaSS_sweeping\edgewise_0.1_0.4.step)
  Body1 [aluminum] = imported_body(C:\Users\karlr\Documents\ICMaSS_sweeping\edgewise_0.1_0.4.step)
  Body1_1 [ferrite - Copy (2)] = imported_body(C:\Users\karlr\Documents\ICMaSS_sweeping\edgewise_0.1_0.4.step)
  Body1_2, Body1_3 [aluminum] = imported_body(C:\Users\karlr\Documents\ICMaSS_sweeping\edgewise_0.1_0.4.step)
  Body1_4 [ferrite - Copy (2)] = imported_body(C:\Users\karlr\Documents\ICMaSS_sweeping\edgewise_0.1_0.4.step)
  Body1_5 [aluminum] = imported_body(C:\Users\karlr\Documents\ICMaSS_sweeping\edgewise_0.1_0.4.step)
  group core_assembled_edgewise3 = Np1..Np8, Ns1..Ns8, plate1, plate2
  group core_together_4 = Body1, Body1_1, Body1_2
  group core_together3 = Body1_3, Body1_4, Body1_5
boundaries and excitations:
  Opening1: Opening Faces=Region.face(-y) Temperature=AmbientTemp External_Rad._Temperature=AmbientRadTemp Inlet_Type=Pressure Total_Pressure=AmbientPressure
  Opening2: Opening Faces=Region.face(+y) Temperature=AmbientTemp External_Rad._Temperature=AmbientRadTemp Inlet_Type=Velocity Static_Pressure=AmbientPressure X_Velocity=0m_per_sec Y_Velocity=0m_per_sec Z_Velocity=0m_per_sec
  EMLoss1: EM Loss Objects=[Body1, Body1_1..Body1_5, Np1..Np8, Ns1..Ns8] LinkID=448 Project="This Project*" Product=ElectronicsDesktop Design=Edgewise_0.4_interleaved_full Params{freq_hz=28500Hz} ForceSourceToSolve PreservePartnerSoln PathRelativeTo=TargetProject Intrinsics(28.5kHz) LossMultiplier=1
mesh:
  MeshRegions:  Global{MeshMethod=MesherHD ComputeGap MeshRegionResolution=5 MinGapX=1mm MinGapY=1mm MinGapZ=1mm Objects=Region FacetLevel=5 ProximitySizeFunction CurvatureSizeFunction OptimizePCBMesh}
  MeshOperations:
setups:
  Setup1: IcepakSteadyState Flow_Regime=Laminar Include_Temperature=true Include_Flow=true Include_Gravity Solution_Initialization_-_Z_Velocity=0.000980665m_per_sec Convergence_Criteria_-_Flow=0.001 Convergence_Criteria_-_Energy=1e-07 Convergence_Criteria_-_Discrete_Ordinates=1e-06 Radiation_Model="Discrete Ordinates Model" Flow_Iteration_Per_Radiation_Iteration=10 ThetaDivision=2 PhiDivision=2 ThetaPixels=2 PhiPixels=2 Under-relaxation_-_Pressure=0.7 Under-relaxation_-_Momentum=0.3 Under-relaxation_-_Temperature=1 Discretization_Scheme_-_Pressure=Standard Discretization_Scheme_-_Momentum=First Discretization_Scheme_-_Temperature=First Discretization_Scheme_-_Discrete_Ordinates=First Convergence_Criteria_-_Max_Iterations=10000

design [Thermal]Edgewise_0.5_fix (Icepak, SteadyState TemperatureAndFlow, model units mm)
options: Default_Fluid_Material=air Default_Solid_Material=Al-Extruded Default_Surface_Material=Steel-oxidised-surface AmbientTemperature=25cel AmbientPressure=0n_per_meter_sq AmbientRadiationTemperature=25cel Gravity_Vector_CS_ID=Global Gravity_Vector_Axis=Z Positive=false SherlockExportDirectory=C:/Users/karlr/Documents/Ansoft/1kW_Final.aedtexport/[Thermal]8turns_3D_CoreLoss_FullInterleaved_Flatwise/ Altitude=0meter
geometry:
  Region [air] = region(percentage_offset=1000 on all sides)
  Np1 [copper] = imported_body(C:\Users\karlr\Documents\ICMaSS_sweeping\edgewise_0.1_0.5.step)
  Np2 [copper] = imported_body(C:\Users\karlr\Documents\ICMaSS_sweeping\edgewise_0.1_0.5.step)
  Np3 [copper] = imported_body(C:\Users\karlr\Documents\ICMaSS_sweeping\edgewise_0.1_0.5.step)
  Np4 [copper] = imported_body(C:\Users\karlr\Documents\ICMaSS_sweeping\edgewise_0.1_0.5.step)
  Np5 [copper] = imported_body(C:\Users\karlr\Documents\ICMaSS_sweeping\edgewise_0.1_0.5.step)
  Np6 [copper] = imported_body(C:\Users\karlr\Documents\ICMaSS_sweeping\edgewise_0.1_0.5.step)
  Np7 [copper] = imported_body(C:\Users\karlr\Documents\ICMaSS_sweeping\edgewise_0.1_0.5.step)
  Np8 [copper] = imported_body(C:\Users\karlr\Documents\ICMaSS_sweeping\edgewise_0.1_0.5.step)
  Ns1 [copper] = imported_body(C:\Users\karlr\Documents\ICMaSS_sweeping\edgewise_0.1_0.5.step)
  Ns2 [copper] = imported_body(C:\Users\karlr\Documents\ICMaSS_sweeping\edgewise_0.1_0.5.step)
  Ns3 [copper] = imported_body(C:\Users\karlr\Documents\ICMaSS_sweeping\edgewise_0.1_0.5.step)
  Ns4 [copper] = imported_body(C:\Users\karlr\Documents\ICMaSS_sweeping\edgewise_0.1_0.5.step)
  Ns5 [copper] = imported_body(C:\Users\karlr\Documents\ICMaSS_sweeping\edgewise_0.1_0.5.step)
  Ns6 [copper] = imported_body(C:\Users\karlr\Documents\ICMaSS_sweeping\edgewise_0.1_0.5.step)
  Ns7 [copper] = imported_body(C:\Users\karlr\Documents\ICMaSS_sweeping\edgewise_0.1_0.5.step)
  Ns8 [copper] = imported_body(C:\Users\karlr\Documents\ICMaSS_sweeping\edgewise_0.1_0.5.step)
  plate1, plate2 [silicon - Copy] = imported_body(C:\Users\karlr\Documents\ICMaSS_sweeping\edgewise_0.1_0.5.step)
  Body1 [ferrite - Copy (2)] = imported_body(C:\Users\karlr\Documents\ICMaSS_sweeping\edgewise_0.1_0.5.step)
  Body1_1, Body1_2 [aluminum] = imported_body(C:\Users\karlr\Documents\ICMaSS_sweeping\edgewise_0.1_0.5.step)
  Body1_3 [ferrite - Copy (2)] = imported_body(C:\Users\karlr\Documents\ICMaSS_sweeping\edgewise_0.1_0.5.step)
  Body1_4, Body1_5 [aluminum] = imported_body(C:\Users\karlr\Documents\ICMaSS_sweeping\edgewise_0.1_0.5.step)
  Rectangle1 [Al-Extruded, non-model] = rectangle(corner=(32mm, 25.56mm, 0mm), z_size=21.5mm, x_size=-32mm)
  group core_assembled_edgewise4 = Np1..Np8, Ns1..Ns8, plate1, plate2
  group core_together_5 = Body1, Body1_1, Body1_2
  group core_together4 = Body1_3, Body1_4, Body1_5
boundaries and excitations:
  Opening1: Opening Faces=Region.face(-y) Temperature=AmbientTemp External_Rad._Temperature=AmbientRadTemp Inlet_Type=Pressure Total_Pressure=AmbientPressure
  Opening2: Opening Faces=Region.face(+y) Temperature=AmbientTemp External_Rad._Temperature=AmbientRadTemp Inlet_Type=Velocity Static_Pressure=AmbientPressure X_Velocity=0m_per_sec Y_Velocity=0m_per_sec Z_Velocity=0m_per_sec
  EMLoss1: EM Loss Objects=[Body1, Body1_1..Body1_5, Np1..Np8, Ns1..Ns8] LinkID=463 Project="This Project*" Product=ElectronicsDesktop Design=Edgewise_0.5_interleaved_full Params{freq_hz=28500Hz} ForceSourceToSolve PreservePartnerSoln PathRelativeTo=TargetProject Intrinsics(28.5kHz) LossMultiplier=1
mesh:
  MeshRegions:  Global{MeshMethod=MesherHD ComputeGap MeshRegionResolution=5 MinGapX=1mm MinGapY=1mm MinGapZ=1mm Objects=Region FacetLevel=5 ProximitySizeFunction CurvatureSizeFunction OptimizePCBMesh}
  MeshOperations:
setups:
  Setup1: IcepakSteadyState Flow_Regime=Laminar Include_Temperature=true Include_Flow=true Include_Gravity Solution_Initialization_-_Z_Velocity=0.000980665m_per_sec Convergence_Criteria_-_Flow=0.001 Convergence_Criteria_-_Energy=1e-07 Convergence_Criteria_-_Discrete_Ordinates=1e-06 Radiation_Model="Discrete Ordinates Model" Flow_Iteration_Per_Radiation_Iteration=10 ThetaDivision=2 PhiDivision=2 ThetaPixels=2 PhiPixels=2 Under-relaxation_-_Pressure=0.7 Under-relaxation_-_Momentum=0.3 Under-relaxation_-_Temperature=1 Discretization_Scheme_-_Pressure=Standard Discretization_Scheme_-_Momentum=First Discretization_Scheme_-_Temperature=First Discretization_Scheme_-_Discrete_Ordinates=First Convergence_Criteria_-_Max_Iterations=10000
field plots:
  Temperature1: Temperature over Np1..Np8, Ns1..Ns8, plate1, plate2, Body1, Body1_1..Body1_5 on Setup1 : SteadyState
  Temperature2: Temperature over a plane on Setup1 : SteadyState

design [Thermal]Edgewise_0.25_fix (Icepak, SteadyState TemperatureAndFlow, model units mm)
options: Default_Fluid_Material=air Default_Solid_Material=Al-Extruded Default_Surface_Material=Steel-oxidised-surface AmbientTemperature=25cel AmbientPressure=0n_per_meter_sq AmbientRadiationTemperature=25cel Gravity_Vector_CS_ID=Global Gravity_Vector_Axis=Z Positive=false SherlockExportDirectory=C:/Users/karlr/Documents/Ansoft/1kW_Final.aedtexport/[Thermal]8turns_3D_CoreLoss_FullInterleaved_Flatwise/ Altitude=0meter
geometry:
  Region [air] = region(percentage_offset=1000 on all sides)
  Np1 [copper] = imported_body(C:\Users\karlr\Documents\ICMaSS_sweeping\edgewise_0.1_0.25.step)
  Np2 [copper] = imported_body(C:\Users\karlr\Documents\ICMaSS_sweeping\edgewise_0.1_0.25.step)
  Np3 [copper] = imported_body(C:\Users\karlr\Documents\ICMaSS_sweeping\edgewise_0.1_0.25.step)
  Np4 [copper] = imported_body(C:\Users\karlr\Documents\ICMaSS_sweeping\edgewise_0.1_0.25.step)
  Np5 [copper] = imported_body(C:\Users\karlr\Documents\ICMaSS_sweeping\edgewise_0.1_0.25.step)
  Np6 [copper] = imported_body(C:\Users\karlr\Documents\ICMaSS_sweeping\edgewise_0.1_0.25.step)
  Np7 [copper] = imported_body(C:\Users\karlr\Documents\ICMaSS_sweeping\edgewise_0.1_0.25.step)
  Np8 [copper] = imported_body(C:\Users\karlr\Documents\ICMaSS_sweeping\edgewise_0.1_0.25.step)
  Ns1 [copper] = imported_body(C:\Users\karlr\Documents\ICMaSS_sweeping\edgewise_0.1_0.25.step)
  Ns2 [copper] = imported_body(C:\Users\karlr\Documents\ICMaSS_sweeping\edgewise_0.1_0.25.step)
  Ns3 [copper] = imported_body(C:\Users\karlr\Documents\ICMaSS_sweeping\edgewise_0.1_0.25.step)
  Ns4 [copper] = imported_body(C:\Users\karlr\Documents\ICMaSS_sweeping\edgewise_0.1_0.25.step)
  Ns5 [copper] = imported_body(C:\Users\karlr\Documents\ICMaSS_sweeping\edgewise_0.1_0.25.step)
  Ns6 [copper] = imported_body(C:\Users\karlr\Documents\ICMaSS_sweeping\edgewise_0.1_0.25.step)
  Ns7 [copper] = imported_body(C:\Users\karlr\Documents\ICMaSS_sweeping\edgewise_0.1_0.25.step)
  Ns8 [copper] = imported_body(C:\Users\karlr\Documents\ICMaSS_sweeping\edgewise_0.1_0.25.step)
  plate1, plate2 [silicon - Copy] = imported_body(C:\Users\karlr\Documents\ICMaSS_sweeping\edgewise_0.1_0.25.step)
  Body1 [ferrite - Copy (2)] = imported_body(C:\Users\karlr\Documents\ICMaSS_sweeping\edgewise_0.1_0.25.step)
  Body1_1, Body1_2 [aluminum] = imported_body(C:\Users\karlr\Documents\ICMaSS_sweeping\edgewise_0.1_0.25.step)
  Body1_3 [ferrite - Copy (2)] = imported_body(C:\Users\karlr\Documents\ICMaSS_sweeping\edgewise_0.1_0.25.step)
  Body1_4, Body1_5 [aluminum] = imported_body(C:\Users\karlr\Documents\ICMaSS_sweeping\edgewise_0.1_0.25.step)
  Rectangle1 [Al-Extruded, non-model] = rectangle(corner=(40mm, 25.43mm, 17.5mm), z_size=-17.5mm, x_size=-40mm)
  group core_together_1 = Body1, Body1_1, Body1_2
  group core_together = Body1_3, Body1_4, Body1_5
  group core_assembled_edgewise = Np1..Np8, Ns1..Ns8, plate1, plate2
boundaries and excitations:
  Opening1: Opening Faces=Region.face(-y) Temperature=AmbientTemp External_Rad._Temperature=AmbientRadTemp Inlet_Type=Pressure Total_Pressure=AmbientPressure
  Opening2: Opening Faces=Region.face(+y) Temperature=AmbientTemp External_Rad._Temperature=AmbientRadTemp Inlet_Type=Velocity Static_Pressure=AmbientPressure X_Velocity=0m_per_sec Y_Velocity=0m_per_sec Z_Velocity=0m_per_sec
  EMLoss1: EM Loss Objects=[Body1, Body1_1..Body1_5, Np1..Np8, Ns1..Ns8] LinkID=433 Project="This Project*" Product=ElectronicsDesktop Design=Edgewise_0.25_interleaved_full Params{freq_hz=28500Hz} ForceSourceToSolve PreservePartnerSoln PathRelativeTo=TargetProject Intrinsics(28.5kHz) LossMultiplier=1
mesh:
  MeshRegions:  Global{MeshMethod=MesherHD ComputeGap MeshRegionResolution=5 MinGapX=1mm MinGapY=1mm MinGapZ=1mm Objects=Region FacetLevel=5 ProximitySizeFunction CurvatureSizeFunction OptimizePCBMesh}
  MeshOperations:
setups:
  Setup1: IcepakSteadyState Flow_Regime=Laminar Include_Temperature=true Include_Flow=true Include_Gravity Solution_Initialization_-_Z_Velocity=0.000980665m_per_sec Convergence_Criteria_-_Flow=0.001 Convergence_Criteria_-_Energy=1e-07 Convergence_Criteria_-_Discrete_Ordinates=1e-06 Radiation_Model="Discrete Ordinates Model" Flow_Iteration_Per_Radiation_Iteration=10 ThetaDivision=2 PhiDivision=2 ThetaPixels=2 PhiPixels=2 Under-relaxation_-_Pressure=0.7 Under-relaxation_-_Momentum=0.3 Under-relaxation_-_Temperature=1 Discretization_Scheme_-_Pressure=Standard Discretization_Scheme_-_Momentum=First Discretization_Scheme_-_Temperature=First Discretization_Scheme_-_Discrete_Ordinates=First Convergence_Criteria_-_Max_Iterations=10000
field plots:
  Temperature1: Temperature over a plane on Setup1 : SteadyState
  Temperature2: Temperature on Setup1 : SteadyState

design [Thermal]Edgewise_0.2_fix_heatsink (Icepak, SteadyState TemperatureAndFlow, model units mm)
options: Default_Fluid_Material=air Default_Solid_Material=Al-Extruded Default_Surface_Material=Steel-oxidised-surface AmbientTemperature=25cel AmbientPressure=0n_per_meter_sq AmbientRadiationTemperature=25cel Gravity_Vector_CS_ID=Global Gravity_Vector_Axis=Z Positive=false SherlockExportDirectory=C:/Users/karlr/Documents/Ansoft/1kW_Final.aedtexport/[Thermal]8turns_3D_CoreLoss_FullInterleaved_Flatwise/ Altitude=0meter
geometry:
  Region [air] = region(percentage_offset: +X=1000, -X=1000, +Y=1000, -Y=1000, +Z=1000, -Z=0)
  Np1 [copper] = imported_body(C:\Users\karlr\Documents\ICMaSS_sweeping\edgewise_0.1_0.2.step)
  Np2 [copper] = imported_body(C:\Users\karlr\Documents\ICMaSS_sweeping\edgewise_0.1_0.2.step)
  Np3 [copper] = imported_body(C:\Users\karlr\Documents\ICMaSS_sweeping\edgewise_0.1_0.2.step)
  Np4 [copper] = imported_body(C:\Users\karlr\Documents\ICMaSS_sweeping\edgewise_0.1_0.2.step)
  Np5 [copper] = imported_body(C:\Users\karlr\Documents\ICMaSS_sweeping\edgewise_0.1_0.2.step)
  Np6 [copper] = imported_body(C:\Users\karlr\Documents\ICMaSS_sweeping\edgewise_0.1_0.2.step)
  Np7 [copper] = imported_body(C:\Users\karlr\Documents\ICMaSS_sweeping\edgewise_0.1_0.2.step)
  Np8 [copper] = imported_body(C:\Users\karlr\Documents\ICMaSS_sweeping\edgewise_0.1_0.2.step)
  Ns1 [copper] = imported_body(C:\Users\karlr\Documents\ICMaSS_sweeping\edgewise_0.1_0.2.step)
  Ns2 [copper] = imported_body(C:\Users\karlr\Documents\ICMaSS_sweeping\edgewise_0.1_0.2.step)
  Ns3 [copper] = imported_body(C:\Users\karlr\Documents\ICMaSS_sweeping\edgewise_0.1_0.2.step)
  Ns4 [copper] = imported_body(C:\Users\karlr\Documents\ICMaSS_sweeping\edgewise_0.1_0.2.step)
  Ns5 [copper] = imported_body(C:\Users\karlr\Documents\ICMaSS_sweeping\edgewise_0.1_0.2.step)
  Ns6 [copper] = imported_body(C:\Users\karlr\Documents\ICMaSS_sweeping\edgewise_0.1_0.2.step)
  Ns7 [copper] = imported_body(C:\Users\karlr\Documents\ICMaSS_sweeping\edgewise_0.1_0.2.step)
  Ns8 [copper] = imported_body(C:\Users\karlr\Documents\ICMaSS_sweeping\edgewise_0.1_0.2.step)
  plate1, plate2 [silicon - Copy] = imported_body(C:\Users\karlr\Documents\ICMaSS_sweeping\edgewise_0.1_0.2.step)
  Body1 [ferrite - Copy (2)] = imported_body(C:\Users\karlr\Documents\ICMaSS_sweeping\edgewise_0.1_0.2.step)
  Body1_1, Body1_2 [aluminum] = imported_body(C:\Users\karlr\Documents\ICMaSS_sweeping\edgewise_0.1_0.2.step)
  Body1_3 [ferrite - Copy (2)] = imported_body(C:\Users\karlr\Documents\ICMaSS_sweeping\edgewise_0.1_0.2.step)
  Body1_4, Body1_5 [aluminum] = imported_body(C:\Users\karlr\Documents\ICMaSS_sweeping\edgewise_0.1_0.2.step)
  Rectangle1 [Al-Extruded, non-model] = rectangle(corner=(44mm, 25.475mm, 0mm), z_size=16.7mm, x_size=-44mm)
  Box2 [aluminum] = box(corner=(70mm, -50mm, -1mm), size=(-100mm, 150mm, -5mm))
  Box3 [silicon - Copy] = box(corner=(1.6666272e-08mm, 62.95mm, 1.6666666e-08mm), size=(43.99999997mm, -74.94999997mm, -1mm))
  group core_together_1 = Body1, Body1_1, Body1_2
  group core_together = Body1_3, Body1_4, Body1_5
  group core_assembled_edgewise = Np1..Np8, Ns1..Ns8, plate1, plate2
boundaries and excitations:
  Opening1: Opening Faces=Region.face(-y) Temperature=AmbientTemp External_Rad._Temperature=AmbientRadTemp Inlet_Type=Pressure Total_Pressure=AmbientPressure
  Opening2: Opening Faces=Region.face(+y) Temperature=AmbientTemp External_Rad._Temperature=AmbientRadTemp Inlet_Type=Velocity Static_Pressure=AmbientPressure X_Velocity=0m_per_sec Y_Velocity=0m_per_sec Z_Velocity=0m_per_sec
  EMLoss1: EM Loss Objects=[Body1, Body1_1..Body1_5, Np1..Np8, Ns1..Ns8] LinkID=418 Project="This Project*" Product=ElectronicsDesktop Design=Edgewise_0.2_interleaved_full Params{freq_hz=28500Hz} ForceSourceToSolve PreservePartnerSoln PathRelativeTo=TargetProject Intrinsics(28.5kHz) LossMultiplier=1
  StationaryWall1: Stationary Wall Faces=Box2.face(-z) Thickness=0mm Solid_Material=Al-Extruded External_Condition="Heat Transfer Coefficient" Heat_Flux=0irrad_W_per_m2 Temperature=AmbientTemp Heat_Transfer_Coefficient=50w_per_m2kel Reference_Temperature=AmbientTemp Heat_Transfer_Data{Heat_Transfer_Convection_Type="Forced Convection"} External_Material=Steel-oxidised-surface External_Radiation_Reference_Temperature=AmbientTemp External_Radiation_View_Factor=1
mesh:
  MeshRegions:  Global{MeshMethod=MesherHD ComputeGap MeshRegionResolution=5 MinGapX=1mm MinGapY=1mm MinGapZ=1mm Objects=Region FacetLevel=5 ProximitySizeFunction CurvatureSizeFunction OptimizePCBMesh}
  MeshOperations:
setups:
  Setup1: IcepakSteadyState Flow_Regime=Laminar Include_Temperature=true Include_Flow=true Include_Gravity Solution_Initialization_-_Z_Velocity=0.000980665m_per_sec Convergence_Criteria_-_Flow=0.001 Convergence_Criteria_-_Energy=1e-07 Convergence_Criteria_-_Discrete_Ordinates=1e-06 Radiation_Model="Discrete Ordinates Model" Flow_Iteration_Per_Radiation_Iteration=10 ThetaDivision=2 PhiDivision=2 ThetaPixels=2 PhiPixels=2 Under-relaxation_-_Pressure=0.7 Under-relaxation_-_Momentum=0.3 Under-relaxation_-_Temperature=1 Discretization_Scheme_-_Pressure=Standard Discretization_Scheme_-_Momentum=First Discretization_Scheme_-_Temperature=First Discretization_Scheme_-_Discrete_Ordinates=First Convergence_Criteria_-_Max_Iterations=10000
field plots:
  Temperature1: Temperature on Setup1 : SteadyState
  Temperature2: Temperature over a plane on Setup1 : SteadyState

design [Thermal]Edgewise_0.3_fix_heatsink (Icepak, SteadyState TemperatureAndFlow, model units mm)
options: Default_Fluid_Material=air Default_Solid_Material=Al-Extruded Default_Surface_Material=Steel-oxidised-surface AmbientTemperature=25cel AmbientPressure=0n_per_meter_sq AmbientRadiationTemperature=25cel Gravity_Vector_CS_ID=Global Gravity_Vector_Axis=Z Positive=false SherlockExportDirectory=C:/Users/karlr/Documents/Ansoft/1kW_Final.aedtexport/[Thermal]8turns_3D_CoreLoss_FullInterleaved_Flatwise/ Altitude=0meter
geometry:
  Region [air] = region(percentage_offset: +X=1000, -X=1000, +Y=1000, -Y=1000, +Z=1000, -Z=0)
  Np1 [copper] = imported_body(C:\Users\karlr\Documents\ICMaSS_sweeping\edgewise_0.1_0.3.step)
  Np2 [copper] = imported_body(C:\Users\karlr\Documents\ICMaSS_sweeping\edgewise_0.1_0.3.step)
  Np3 [copper] = imported_body(C:\Users\karlr\Documents\ICMaSS_sweeping\edgewise_0.1_0.3.step)
  Np4 [copper] = imported_body(C:\Users\karlr\Documents\ICMaSS_sweeping\edgewise_0.1_0.3.step)
  Np5 [copper] = imported_body(C:\Users\karlr\Documents\ICMaSS_sweeping\edgewise_0.1_0.3.step)
  Np6 [copper] = imported_body(C:\Users\karlr\Documents\ICMaSS_sweeping\edgewise_0.1_0.3.step)
  Np7 [copper] = imported_body(C:\Users\karlr\Documents\ICMaSS_sweeping\edgewise_0.1_0.3.step)
  Np8 [copper] = imported_body(C:\Users\karlr\Documents\ICMaSS_sweeping\edgewise_0.1_0.3.step)
  Ns1 [copper] = imported_body(C:\Users\karlr\Documents\ICMaSS_sweeping\edgewise_0.1_0.3.step)
  Ns2 [copper] = imported_body(C:\Users\karlr\Documents\ICMaSS_sweeping\edgewise_0.1_0.3.step)
  Ns3 [copper] = imported_body(C:\Users\karlr\Documents\ICMaSS_sweeping\edgewise_0.1_0.3.step)
  Ns4 [copper] = imported_body(C:\Users\karlr\Documents\ICMaSS_sweeping\edgewise_0.1_0.3.step)
  Ns5 [copper] = imported_body(C:\Users\karlr\Documents\ICMaSS_sweeping\edgewise_0.1_0.3.step)
  Ns6 [copper] = imported_body(C:\Users\karlr\Documents\ICMaSS_sweeping\edgewise_0.1_0.3.step)
  Ns7 [copper] = imported_body(C:\Users\karlr\Documents\ICMaSS_sweeping\edgewise_0.1_0.3.step)
  Ns8 [copper] = imported_body(C:\Users\karlr\Documents\ICMaSS_sweeping\edgewise_0.1_0.3.step)
  plate1, plate2 [silicon - Copy] = imported_body(C:\Users\karlr\Documents\ICMaSS_sweeping\edgewise_0.1_0.3.step)
  Body1 [ferrite - Copy (2)] = imported_body(C:\Users\karlr\Documents\ICMaSS_sweeping\edgewise_0.1_0.3.step)
  Body1_1, Body1_2 [aluminum] = imported_body(C:\Users\karlr\Documents\ICMaSS_sweeping\edgewise_0.1_0.3.step)
  Body1_3 [ferrite - Copy (2)] = imported_body(C:\Users\karlr\Documents\ICMaSS_sweeping\edgewise_0.1_0.3.step)
  Body1_4, Body1_5 [aluminum] = imported_body(C:\Users\karlr\Documents\ICMaSS_sweeping\edgewise_0.1_0.3.step)
  Rectangle1 [Al-Extruded, non-model] = rectangle(corner=(37.333333mm, 25.43mm, 0mm), z_size=18.3mm, x_size=-37.333333mm)
  Box1 [silicon - Copy] = box(corner=(37.333333mm, -8.6666667mm, 1.6666612e-08mm), size=(-37.333333mm, 68.193333mm, -1mm))
  Box2 [aluminum] = box(corner=(70mm, -50mm, -1mm), size=(-100mm, 150mm, -5mm))
  group core_assembled_edgewise2 = Np1..Np8, Ns1..Ns8, plate1, plate2
  group core_together_3 = Body1, Body1_1, Body1_2
  group core_together2 = Body1_3, Body1_4, Body1_5
boundaries and excitations:
  Opening1: Opening Faces=Region.face(-y) Temperature=AmbientTemp External_Rad._Temperature=AmbientRadTemp Inlet_Type=Pressure Total_Pressure=AmbientPressure
  Opening2: Opening Faces=Region.face(+y) Temperature=AmbientTemp External_Rad._Temperature=AmbientRadTemp Inlet_Type=Velocity Static_Pressure=AmbientPressure X_Velocity=0m_per_sec Y_Velocity=0m_per_sec Z_Velocity=0m_per_sec
  EMLoss1: EM Loss Objects=[Body1, Body1_1..Body1_5, Np1..Np8, Ns1..Ns8] LinkID=433 Project="This Project*" Product=ElectronicsDesktop Design=Edgewise_0.3_interleaved_full Params{freq_hz=28500Hz} ForceSourceToSolve PreservePartnerSoln PathRelativeTo=TargetProject Intrinsics(28.5kHz) LossMultiplier=1
  StationaryWall1: Stationary Wall Faces=Box2.face(-z) Thickness=0mm Solid_Material=Al-Extruded External_Condition="Heat Transfer Coefficient" Heat_Flux=0irrad_W_per_m2 Temperature=AmbientTemp Heat_Transfer_Coefficient=50w_per_m2kel Reference_Temperature=AmbientTemp Heat_Transfer_Data{Heat_Transfer_Convection_Type="Forced Convection"} External_Material=Steel-oxidised-surface External_Radiation_Reference_Temperature=AmbientTemp External_Radiation_View_Factor=1
mesh:
  MeshRegions:  Global{MeshMethod=MesherHD ComputeGap MeshRegionResolution=5 MinGapX=1mm MinGapY=1mm MinGapZ=1mm Objects=Region FacetLevel=5 ProximitySizeFunction CurvatureSizeFunction OptimizePCBMesh}
  MeshOperations:
setups:
  Setup1: IcepakSteadyState Flow_Regime=Laminar Include_Temperature=true Include_Flow=true Include_Gravity Solution_Initialization_-_Z_Velocity=0.000980665m_per_sec Convergence_Criteria_-_Flow=0.001 Convergence_Criteria_-_Energy=1e-07 Convergence_Criteria_-_Discrete_Ordinates=1e-06 Radiation_Model="Discrete Ordinates Model" Flow_Iteration_Per_Radiation_Iteration=10 ThetaDivision=2 PhiDivision=2 ThetaPixels=2 PhiPixels=2 Under-relaxation_-_Pressure=0.7 Under-relaxation_-_Momentum=0.3 Under-relaxation_-_Temperature=1 Discretization_Scheme_-_Pressure=Standard Discretization_Scheme_-_Momentum=First Discretization_Scheme_-_Temperature=First Discretization_Scheme_-_Discrete_Ordinates=First Convergence_Criteria_-_Max_Iterations=10000
field plots:
  Temperature1: Temperature over a plane on Setup1 : SteadyState
  Temperature2: Temperature on Setup1 : SteadyState

design [Thermal]Edgewise_0.5_fix_heatsink (Icepak, SteadyState TemperatureAndFlow, model units mm)
options: Default_Fluid_Material=air Default_Solid_Material=Al-Extruded Default_Surface_Material=Steel-oxidised-surface AmbientTemperature=25cel AmbientPressure=0n_per_meter_sq AmbientRadiationTemperature=25cel Gravity_Vector_CS_ID=Global Gravity_Vector_Axis=Z Positive=false SherlockExportDirectory=C:/Users/karlr/Documents/Ansoft/1kW_Final.aedtexport/[Thermal]8turns_3D_CoreLoss_FullInterleaved_Flatwise/ Altitude=0meter
geometry:
  Region [air] = region(percentage_offset: +X=1000, -X=1000, +Y=1000, -Y=1000, +Z=1000, -Z=0)
  Np1 [copper] = imported_body(C:\Users\karlr\Documents\ICMaSS_sweeping\edgewise_0.1_0.5.step)
  Np2 [copper] = imported_body(C:\Users\karlr\Documents\ICMaSS_sweeping\edgewise_0.1_0.5.step)
  Np3 [copper] = imported_body(C:\Users\karlr\Documents\ICMaSS_sweeping\edgewise_0.1_0.5.step)
  Np4 [copper] = imported_body(C:\Users\karlr\Documents\ICMaSS_sweeping\edgewise_0.1_0.5.step)
  Np5 [copper] = imported_body(C:\Users\karlr\Documents\ICMaSS_sweeping\edgewise_0.1_0.5.step)
  Np6 [copper] = imported_body(C:\Users\karlr\Documents\ICMaSS_sweeping\edgewise_0.1_0.5.step)
  Np7 [copper] = imported_body(C:\Users\karlr\Documents\ICMaSS_sweeping\edgewise_0.1_0.5.step)
  Np8 [copper] = imported_body(C:\Users\karlr\Documents\ICMaSS_sweeping\edgewise_0.1_0.5.step)
  Ns1 [copper] = imported_body(C:\Users\karlr\Documents\ICMaSS_sweeping\edgewise_0.1_0.5.step)
  Ns2 [copper] = imported_body(C:\Users\karlr\Documents\ICMaSS_sweeping\edgewise_0.1_0.5.step)
  Ns3 [copper] = imported_body(C:\Users\karlr\Documents\ICMaSS_sweeping\edgewise_0.1_0.5.step)
  Ns4 [copper] = imported_body(C:\Users\karlr\Documents\ICMaSS_sweeping\edgewise_0.1_0.5.step)
  Ns5 [copper] = imported_body(C:\Users\karlr\Documents\ICMaSS_sweeping\edgewise_0.1_0.5.step)
  Ns6 [copper] = imported_body(C:\Users\karlr\Documents\ICMaSS_sweeping\edgewise_0.1_0.5.step)
  Ns7 [copper] = imported_body(C:\Users\karlr\Documents\ICMaSS_sweeping\edgewise_0.1_0.5.step)
  Ns8 [copper] = imported_body(C:\Users\karlr\Documents\ICMaSS_sweeping\edgewise_0.1_0.5.step)
  plate1, plate2 [silicon - Copy] = imported_body(C:\Users\karlr\Documents\ICMaSS_sweeping\edgewise_0.1_0.5.step)
  Body1 [ferrite - Copy (2)] = imported_body(C:\Users\karlr\Documents\ICMaSS_sweeping\edgewise_0.1_0.5.step)
  Body1_1, Body1_2 [aluminum] = imported_body(C:\Users\karlr\Documents\ICMaSS_sweeping\edgewise_0.1_0.5.step)
  Body1_3 [ferrite - Copy (2)] = imported_body(C:\Users\karlr\Documents\ICMaSS_sweeping\edgewise_0.1_0.5.step)
  Body1_4, Body1_5 [aluminum] = imported_body(C:\Users\karlr\Documents\ICMaSS_sweeping\edgewise_0.1_0.5.step)
  Rectangle1 [Al-Extruded, non-model] = rectangle(corner=(32mm, 25.56mm, 0mm), z_size=21.5mm, x_size=-32mm)
  Box1 [silicon - Copy] = box(corner=(32mm, -6mm, 1.6666614e-08mm), size=(-32mm, 63.12mm, -1mm))
  Box2 [aluminum] = box(corner=(70mm, -50mm, -1mm), size=(-100mm, 150mm, -5mm))
  group core_assembled_edgewise4 = Np1..Np8, Ns1..Ns8, plate1, plate2
  group core_together_5 = Body1, Body1_1, Body1_2
  group core_together4 = Body1_3, Body1_4, Body1_5
boundaries and excitations:
  Opening1: Opening Faces=Region.face(-y) Temperature=AmbientTemp External_Rad._Temperature=AmbientRadTemp Inlet_Type=Pressure Total_Pressure=AmbientPressure
  Opening2: Opening Faces=Region.face(+y) Temperature=AmbientTemp External_Rad._Temperature=AmbientRadTemp Inlet_Type=Velocity Static_Pressure=AmbientPressure X_Velocity=0m_per_sec Y_Velocity=0m_per_sec Z_Velocity=0m_per_sec
  EMLoss1: EM Loss Objects=[Body1, Body1_1..Body1_5, Np1..Np8, Ns1..Ns8] LinkID=463 Project="This Project*" Product=ElectronicsDesktop Design=Edgewise_0.5_interleaved_full Params{freq_hz=28500Hz} ForceSourceToSolve PreservePartnerSoln PathRelativeTo=TargetProject Intrinsics(28.5kHz) LossMultiplier=1
  StationaryWall1: Stationary Wall Faces=Box2.face(-z) Thickness=0mm Solid_Material=Al-Extruded External_Condition="Heat Transfer Coefficient" Heat_Flux=0irrad_W_per_m2 Temperature=AmbientTemp Heat_Transfer_Coefficient=50w_per_m2kel Reference_Temperature=AmbientTemp Heat_Transfer_Data{Heat_Transfer_Convection_Type="Forced Convection"} External_Material=Steel-oxidised-surface External_Radiation_Reference_Temperature=AmbientTemp External_Radiation_View_Factor=1
mesh:
  MeshRegions:  Global{MeshMethod=MesherHD ComputeGap MeshRegionResolution=5 MinGapX=1mm MinGapY=1mm MinGapZ=1mm Objects=Region FacetLevel=5 ProximitySizeFunction CurvatureSizeFunction OptimizePCBMesh}
  MeshOperations:
setups:
  Setup1: IcepakSteadyState Flow_Regime=Laminar Include_Temperature=true Include_Flow=true Include_Gravity Solution_Initialization_-_Z_Velocity=0.000980665m_per_sec Convergence_Criteria_-_Flow=0.001 Convergence_Criteria_-_Energy=1e-07 Convergence_Criteria_-_Discrete_Ordinates=1e-06 Radiation_Model="Discrete Ordinates Model" Flow_Iteration_Per_Radiation_Iteration=10 ThetaDivision=2 PhiDivision=2 ThetaPixels=2 PhiPixels=2 Under-relaxation_-_Pressure=0.7 Under-relaxation_-_Momentum=0.3 Under-relaxation_-_Temperature=1 Discretization_Scheme_-_Pressure=Standard Discretization_Scheme_-_Momentum=First Discretization_Scheme_-_Temperature=First Discretization_Scheme_-_Discrete_Ordinates=First Convergence_Criteria_-_Max_Iterations=10000
field plots:
  Temperature1: Temperature over Np1..Np8, Ns1..Ns8, plate1, plate2, Body1, Body1_1..Body1_5 on Setup1 : SteadyState
  Temperature2: Temperature over a plane on Setup1 : SteadyState

design [Thermal]Edgewise_0.3_fixkapton (Icepak, SteadyState TemperatureAndFlow, model units mm)
options: Default_Fluid_Material=air Default_Solid_Material=Al-Extruded Default_Surface_Material=Steel-oxidised-surface AmbientTemperature=25cel AmbientPressure=0n_per_meter_sq AmbientRadiationTemperature=25cel Gravity_Vector_CS_ID=Global Gravity_Vector_Axis=Z Positive=false SherlockExportDirectory=C:/Users/karlr/Documents/Ansoft/1kW_Final.aedtexport/[Thermal]8turns_3D_CoreLoss_FullInterleaved_Flatwise/ Altitude=0meter
geometry:
  Region [air] = region(percentage_offset=1000 on all sides)
  Np1 [copper] = imported_body(C:\Users\karlr\Documents\ICMaSS_sweeping\edgewise_0.1_0.3.step)
  Np2 [copper] = imported_body(C:\Users\karlr\Documents\ICMaSS_sweeping\edgewise_0.1_0.3.step)
  Np3 [copper] = imported_body(C:\Users\karlr\Documents\ICMaSS_sweeping\edgewise_0.1_0.3.step)
  Np4 [copper] = imported_body(C:\Users\karlr\Documents\ICMaSS_sweeping\edgewise_0.1_0.3.step)
  Np5 [copper] = imported_body(C:\Users\karlr\Documents\ICMaSS_sweeping\edgewise_0.1_0.3.step)
  Np6 [copper] = imported_body(C:\Users\karlr\Documents\ICMaSS_sweeping\edgewise_0.1_0.3.step)
  Np7 [copper] = imported_body(C:\Users\karlr\Documents\ICMaSS_sweeping\edgewise_0.1_0.3.step)
  Np8 [copper] = imported_body(C:\Users\karlr\Documents\ICMaSS_sweeping\edgewise_0.1_0.3.step)
  Ns1 [copper] = imported_body(C:\Users\karlr\Documents\ICMaSS_sweeping\edgewise_0.1_0.3.step)
  Ns2 [copper] = imported_body(C:\Users\karlr\Documents\ICMaSS_sweeping\edgewise_0.1_0.3.step)
  Ns3 [copper] = imported_body(C:\Users\karlr\Documents\ICMaSS_sweeping\edgewise_0.1_0.3.step)
  Ns4 [copper] = imported_body(C:\Users\karlr\Documents\ICMaSS_sweeping\edgewise_0.1_0.3.step)
  Ns5 [copper] = imported_body(C:\Users\karlr\Documents\ICMaSS_sweeping\edgewise_0.1_0.3.step)
  Ns6 [copper] = imported_body(C:\Users\karlr\Documents\ICMaSS_sweeping\edgewise_0.1_0.3.step)
  Ns7 [copper] = imported_body(C:\Users\karlr\Documents\ICMaSS_sweeping\edgewise_0.1_0.3.step)
  Ns8 [copper] = imported_body(C:\Users\karlr\Documents\ICMaSS_sweeping\edgewise_0.1_0.3.step)
  plate1, plate2 [silicon - Copy] = imported_body(C:\Users\karlr\Documents\ICMaSS_sweeping\edgewise_0.1_0.3.step)
  Body1 [ferrite - Copy (2)] = imported_body(C:\Users\karlr\Documents\ICMaSS_sweeping\edgewise_0.1_0.3.step)
  Body1_1, Body1_2 [aluminum] = imported_body(C:\Users\karlr\Documents\ICMaSS_sweeping\edgewise_0.1_0.3.step)
  Body1_3 [ferrite - Copy (2)] = imported_body(C:\Users\karlr\Documents\ICMaSS_sweeping\edgewise_0.1_0.3.step)
  Body1_4, Body1_5 [aluminum] = imported_body(C:\Users\karlr\Documents\ICMaSS_sweeping\edgewise_0.1_0.3.step)
  Rectangle1 [Al-Extruded, non-model] = rectangle(corner=(37.333333mm, 25.43mm, 0mm), z_size=18.3mm, x_size=-37.333333mm)
  Box1 [polyimide] = box(corner=(31.333333mm, 58.526667mm, 6mm), size=(-25.333333mm, -66.193333mm, 6.3mm))
  Body1_6 = Body1.copy()
  Body1_1_1 = Body1_1.copy()
  Body1_2_1 = Body1_2.copy()
  Body1_3_1 = Body1_3.copy()
  Body1_4_1 = Body1_4.copy()
  Body1_5_1 = Body1_5.copy()
  Np1_1 = Np1.copy()
  Np2_1 = Np2.copy()
  Np3_1 = Np3.copy()
  Np4_1 = Np4.copy()
  Np5_1 = Np5.copy()
  Np6_1 = Np6.copy()
  Np7_1 = Np7.copy()
  Np8_1 = Np8.copy()
  Ns1_1 = Ns1.copy()
  Ns2_1 = Ns2.copy()
  Ns3_1 = Ns3.copy()
  Ns4_1 = Ns4.copy()
  Ns5_1 = Ns5.copy()
  Ns6_1 = Ns6.copy()
  Ns7_1 = Ns7.copy()
  Ns8_1 = Ns8.copy()
  plate1_1 = plate1.copy()
  plate2_1 = plate2.copy()
  Box1.subtract(Body1_6, Body1_1_1, Body1_2_1, Body1_3_1, Body1_4_1, Body1_5_1, Np1_1, Np2_1, Np3_1, Np4_1, Np5_1, Np6_1, Np7_1, Np8_1, Ns1_1, Ns2_1, Ns3_1, Ns4_1, Ns5_1, Ns6_1, Ns7_1, Ns8_1, plate1_1, plate2_1)
  Box2 = box(corner=(24.666667mm, 51.86mm, 12.3mm), size=(-12mm, -52.86mm, -6.3mm))
  Box2_1 = Box2.copy()
  Box2.delete()
  Box1.subtract(Box2_1)
  Box5 [non-model] = box(corner=(5mm, -8.6666667mm, 5mm), size=(27.333333mm, 68.193333mm, 8.3mm))
  Box6 [non-model] = box(corner=(5mm, -8.6666667mm, 5mm), size=(27.333333mm, 68.193333mm, 0.99999998mm))
  Box7 [non-model] = box(corner=(5mm, -8.6666667mm, 12.3mm), size=(27.333333mm, 68.193333mm, 0.99999998mm))
  group core_assembled_edgewise2 = Np1..Np8, Ns1..Ns8, plate1, plate2
  group core_together_3 = Body1, Body1_1, Body1_2
  group core_together2 = Body1_3, Body1_4, Body1_5
boundaries and excitations:
  Opening1: Opening Faces=Region.face(-y) Temperature=AmbientTemp External_Rad._Temperature=AmbientRadTemp Inlet_Type=Pressure Total_Pressure=AmbientPressure
  Opening2: Opening Faces=Region.face(+y) Temperature=AmbientTemp External_Rad._Temperature=AmbientRadTemp Inlet_Type=Velocity Static_Pressure=AmbientPressure X_Velocity=0m_per_sec Y_Velocity=0m_per_sec Z_Velocity=0m_per_sec
  EMLoss1: EM Loss Objects=[Body1, Body1_1..Body1_5, Np1..Np8, Ns1..Ns8] LinkID=433 Project="This Project*" Product=ElectronicsDesktop Design=Edgewise_0.3_interleaved_full Params{freq_hz=28500Hz} ForceSourceToSolve PreservePartnerSoln PathRelativeTo=TargetProject Intrinsics(28.5kHz) LossMultiplier=1
mesh:
  MeshRegions:  Global{MeshMethod=MesherHD ComputeGap MeshRegionResolution=3 MinGapX=1mm MinGapY=1mm MinGapZ=1mm Objects=Region FacetLevel=5 ProximitySizeFunction CurvatureSizeFunction OptimizePCBMesh} MeshRegion2{MeshMethod=MesherHD MeshRegionResolution=3 MinGapX=1mm MinGapY=1mm MinGapZ=1mm Objects=Box5 ProximitySizeFunction CurvatureSizeFunction OptimizePCBMesh} MeshRegion3{MeshMethod=MesherHD MeshRegionResolution=3 MinGapX=1mm MinGapY=1mm MinGapZ=1mm Objects=Box6 ProximitySizeFunction CurvatureSizeFunction OptimizePCBMesh} MeshRegion4{MeshMethod=MesherHD MeshRegionResolution=3 MinGapX=1mm MinGapY=1mm MinGapZ=1mm Objects=Box7 ProximitySizeFunction CurvatureSizeFunction OptimizePCBMesh}
  MeshOperations:
setups:
  Setup1: IcepakSteadyState Flow_Regime=Laminar Include_Temperature=true Include_Flow=true Include_Gravity Solution_Initialization_-_Z_Velocity=0.000980665m_per_sec Convergence_Criteria_-_Flow=0.001 Convergence_Criteria_-_Energy=1e-07 Convergence_Criteria_-_Discrete_Ordinates=1e-06 Radiation_Model="Discrete Ordinates Model" Flow_Iteration_Per_Radiation_Iteration=10 ThetaDivision=2 PhiDivision=2 ThetaPixels=2 PhiPixels=2 Under-relaxation_-_Pressure=0.7 Under-relaxation_-_Momentum=0.3 Under-relaxation_-_Temperature=1 Discretization_Scheme_-_Pressure=Standard Discretization_Scheme_-_Momentum=First Discretization_Scheme_-_Temperature=First Discretization_Scheme_-_Discrete_Ordinates=First Convergence_Criteria_-_Max_Iterations=10000
field plots:
  Temperature1: Temperature over a plane on Setup1 : SteadyState
  Temperature2: Temperature on Setup1 : SteadyState
