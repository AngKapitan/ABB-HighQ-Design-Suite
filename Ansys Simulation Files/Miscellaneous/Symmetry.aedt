# Ansys Electronics Desktop project, version 2023.1
materials:
  aluminum_real: permeability=1.000021 conductivity=38000000 thermal_conductivity=176.5 mass_density=2700 specific_heat=897 youngs_modulus=69000000000 poissons_ratio=0.31 thermal_expansion_coefficient=2.32e-05
  coppe_real: permeability=0.999991 conductivity=59880239.52 thermal_conductivity=393 mass_density=8890 specific_heat=385 youngs_modulus=111000000000 poissons_ratio=0.38 thermal_expansion_coefficient=1.7e-05
  ferrite - real2: core_loss_curve{25kHz (0, 0) (0.050633, 1) (0.0590114, 1.50406) (0.0691674, 2.34392) (0.0792528, 3.65275) (0.088772, 5.02746) (0.0939521, 6.11121) (0.1, 7.16954) (0.109499, 8.56175) (0.121957, 11.5767) (0.138164, 16.5092) (0.153013, 23.1293) (0.173347, 32.9841) (0.195272, 44.5991) (0.21382, 61.3838) (0.235462, 78.6962) (0.259294, 104.536) (0.280722, 138.862) (0.295422, 151.746)} core_loss_curve{100kHz (0, 0) (0.0263744, 1.03613) (0.0293752, 1.42608) (0.0332788, 2.03369) (0.0396755, 3.1693) (0.0449479, 4.44016) (0.0523856, 6.91954) (0.0628101, 11.373) (0.0753091, 20.068) (0.0882699, 32.4039) (0.103461, 49.6099) (0.118547, 74.6161) (0.142138, 118.363) (0.165658, 191.122) (0.184506, 245.025) (0.1975, 325.48) (0.215037, 409.937) (0.242235, 554.291) (0.26827, 762.898) (0.287163, 911.04)} core_loss_curve{200kHz (0, 0) (0.0153013, 1.07357) (0.0196383, 2.03369) (0.0260769, 4.28533) (0.0305648, 7.42858) (0.0396755, 14.0722) (0.0481134, 22.7224) (0.059347, 38.6962) (0.0757374, 74.6161) (0.0994345, 162.909) (0.110748, 216.401) (0.130546, 319.755) (0.147894, 472.47) (0.164721, 605.722) (0.183462, 848.612) (0.194168, 1013.4) (0.210213, 1167.99) (0.235462, 1607.55) (0.252045, 2024.69) (0.274425, 2333.54) (0.290439, 2939.06)} core_loss_curve{500kHz (0, 0) (0.0101716, 5.89811) (0.01199, 8.71505) (0.0149581, 13.5815) (0.0170423, 18.6929) (0.0202031, 30.1834) (0.0235462, 38.6962) (0.0266752, 55.1837) (0.0309135, 72.0142) (0.0356225, 99.1166) (0.0401281, 129.346) (0.0465037, 187.76) (0.0515018, 236.481) (0.0580159, 319.755) (0.067616, 447.974) (0.0761681, 574.318) (0.0892769, 776.557) (0.101141, 1068.81) (0.1199, 1524.21) (0.142138, 2292.49) (0.174333, 3327.81) (0.199753, 5186.04) (0.22248, 6531.74) (0.249202, 8373.92)} permittivity=12 permeability=3300 conductivity=0.25 thermal_conductivity=4 core_loss_type="Power Ferrite" core_loss_cm=2.0420624 core_loss_x=1.4062949 core_loss_y=2.7267175 mass_density=4800 specific_heat=750 youngs_modulus=119000000000 thermal_expansion_coefficient=1e-05 core_loss_equiv_cut_depth=0.001meter
  silicon_TIMreal: permittivity=7 conductivity=1e-11 thermal_conductivity=10 mass_density=3500 specific_heat=712 youngs_modulus=135000000000 poissons_ratio=0.25 thermal_expansion_coefficient=2.54e-06
  vacuum: permittivity=1
  Al-Extruded: thermal_conductivity=205 mass_density=2800 specific_heat=900 youngs_modulus=69000000000 poissons_ratio=0.33 thermal_expansion_coefficient=2.277e-06 thermal_material_type=Solid
  air: permittivity=1.0006 permeability=1.0000004 thermal_conductivity=0.0261 mass_density=1.1614 specific_heat=1005 thermal_expansion_coefficient=0.00333 thermal_material_type=Fluid diffusivity=2.88e-05 molecular_mass=0.028966 viscosity=1.84e-05 material_refractive_index=1.000293
  silicon - Copy: permittivity=9 thermal_conductivity=10 mass_density=3700 specific_heat=712 youngs_modulus=135000000000 poissons_ratio=0.25 thermal_expansion_coefficient=2.54e-06
surface materials:
  Steel-oxidised-surface: surface_emissivity=0.8

design Flatwise_100kW (Maxwell 3D, EddyCurrent, model units mm)
variables:
  freq_hz = 28500Hz
  volt_ac = 1410/28500*Freq
geometry:
  Region [vacuum] = region(percentage_offset=0 on all sides)
  Body1_1 [aluminum_real] = imported_body(D:\Karl_HighPower\flatwise_100kW.step)
  Body1_2 [ferrite - real2] = imported_body(D:\Karl_HighPower\flatwise_100kW.step)
  Body1_4 [aluminum_real] = imported_body(D:\Karl_HighPower\flatwise_100kW.step)
  Body1_5 [ferrite - real2] = imported_body(D:\Karl_HighPower\flatwise_100kW.step)
  plate_1, plate_2 [silicon_TIMreal] = imported_body(D:\Karl_HighPower\flatwise_100kW.step)
  Ns1, Ns7, Ns4, Ns8, Ns2, Ns6, Ns5, Ns3, Np1, Np7, Np4, Np8, Np2, Np6, Np5, Np3 [coppe_real] = imported_body(D:\Karl_HighPower\flatwise_100kW.step)
  [Body1_1, Body1_2, Body1_4, Body1_5, plate_1, plate_2, Ns1, Ns7, Ns4, Ns8, Ns2, Ns6, Ns5, Ns3, Np1, Np7, Np4, Np8, Np2, Np6, Np5, Np3].move(-63.8mm, -100.345mm, 0mm)
  [Body1_1, Body1_2, Body1_4, Body1_5, plate_1, plate_2, Ns1, Ns7, Ns4, Ns8, Ns2, Ns6, Ns5, Ns3, Np1, Np7, Np4, Np8, Np2, Np6, Np5, Np3].split(plane=ZX, keep=PositiveOnly)
  group flatwise_100kW = Body1_1, Body1_2, Body1_4, Body1_5, plate_1, plate_2, Ns1, Ns7, Ns4, Ns8, Ns2, Ns6, Ns5, Ns3, Np1, Np7, Np4, Np8, Np2, Np6, Np5, Np3
boundaries and excitations:
  Symmetry1: Symmetry Faces=Region.face(-y) IsOdd=true
  Np_1: Coil Terminal Faces=Np1.face(at (14.65, 0, 44.5)) Conductor_number=1 Winding=Np Point_out_of_terminal=false
  Np_2: Coil Terminal Faces=Np2.face(at (19.25, 0, 44.5)) Conductor_number=1 Winding=Np Point_out_of_terminal=false
  Np_3: Coil Terminal Faces=Np3.face(at (23.85, 0, 44.5)) Conductor_number=1 Winding=Np Point_out_of_terminal=false
  Np_4: Coil Terminal Faces=Np4.face(at (28.45, 0, 44.5)) Conductor_number=1 Winding=Np Point_out_of_terminal=false
  Np_5: Coil Terminal Faces=Np5.face(at (33.05, 0, 44.5)) Conductor_number=1 Winding=Np Point_out_of_terminal=false
  Np_6: Coil Terminal Faces=Np6.face(at (37.65, 0, 44.5)) Conductor_number=1 Winding=Np Point_out_of_terminal=false
  Np_7: Coil Terminal Faces=Np7.face(at (42.25, 0, 44.5)) Conductor_number=1 Winding=Np Point_out_of_terminal=false
  Np_8: Coil Terminal Faces=Np8.face(at (46.85, 0, 44.5)) Conductor_number=1 Winding=Np Point_out_of_terminal=false
  Np_9: Coil Terminal Faces=Np1.face(at (-14.65, 0, 44.5)) Conductor_number=1 Winding=Np Point_out_of_terminal=true
  Np_10: Coil Terminal Faces=Np2.face(at (-19.25, 0, 44.5)) Conductor_number=1 Winding=Np Point_out_of_terminal=true
  Np_11: Coil Terminal Faces=Np3.face(at (-23.85, 0, 44.5)) Conductor_number=1 Winding=Np Point_out_of_terminal=true
  Np_12: Coil Terminal Faces=Np4.face(at (-28.45, 0, 44.5)) Conductor_number=1 Winding=Np Point_out_of_terminal=true
  Np_13: Coil Terminal Faces=Np5.face(at (-33.05, 0, 44.5)) Conductor_number=1 Winding=Np Point_out_of_terminal=true
  Np_14: Coil Terminal Faces=Np6.face(at (-37.65, 0, 44.5)) Conductor_number=1 Winding=Np Point_out_of_terminal=true
  Np_15: Coil Terminal Faces=Np7.face(at (-42.25, 0, 44.5)) Conductor_number=1 Winding=Np Point_out_of_terminal=true
  Np_16: Coil Terminal Faces=Np8.face(at (-46.85, 0, 44.5)) Conductor_number=1 Winding=Np Point_out_of_terminal=true
  Ns_1: Coil Terminal Faces=Ns1.face(at (16.95, 0, 44.5)) Conductor_number=1 Winding=Ns Point_out_of_terminal=true
  Ns_2: Coil Terminal Faces=Ns2.face(at (21.55, 0, 44.5)) Conductor_number=1 Winding=Ns Point_out_of_terminal=true
  Ns_3: Coil Terminal Faces=Ns3.face(at (26.15, 0, 44.5)) Conductor_number=1 Winding=Ns Point_out_of_terminal=true
  Ns_4: Coil Terminal Faces=Ns4.face(at (30.75, 0, 44.5)) Conductor_number=1 Winding=Ns Point_out_of_terminal=true
  Ns_5: Coil Terminal Faces=Ns5.face(at (35.35, 0, 44.5)) Conductor_number=1 Winding=Ns Point_out_of_terminal=true
  Ns_6: Coil Terminal Faces=Ns6.face(at (39.95, 0, 44.5)) Conductor_number=1 Winding=Ns Point_out_of_terminal=true
  Ns_7: Coil Terminal Faces=Ns7.face(at (44.55, 0, 44.5)) Conductor_number=1 Winding=Ns Point_out_of_terminal=true
  Ns_8: Coil Terminal Faces=Ns8.face(at (49.15, 0, 44.5)) Conductor_number=1 Winding=Ns Point_out_of_terminal=true
  Ns_9: Coil Terminal Faces=Ns8.face(at (-49.15, 0, 44.5)) Conductor_number=1 Winding=Ns Point_out_of_terminal=false
  Ns_10: Coil Terminal Faces=Ns7.face(at (-44.55, 0, 44.5)) Conductor_number=1 Winding=Ns Point_out_of_terminal=false
  Ns_11: Coil Terminal Faces=Ns6.face(at (-39.95, 0, 44.5)) Conductor_number=1 Winding=Ns Point_out_of_terminal=false
  Ns_12: Coil Terminal Faces=Ns5.face(at (-35.35, 0, 44.5)) Conductor_number=1 Winding=Ns Point_out_of_terminal=false
  Ns_13: Coil Terminal Faces=Ns4.face(at (-30.75, 0, 44.5)) Conductor_number=1 Winding=Ns Point_out_of_terminal=false
  Ns_14: Coil Terminal Faces=Ns3.face(at (-26.15, 0, 44.5)) Conductor_number=1 Winding=Ns Point_out_of_terminal=false
  Ns_15: Coil Terminal Faces=Ns2.face(at (-21.55, 0, 44.5)) Conductor_number=1 Winding=Ns Point_out_of_terminal=false
  Ns_16: Coil Terminal Faces=Ns1.face(at (-16.95, 0, 44.5)) Conductor_number=1 Winding=Ns Point_out_of_terminal=false
  Np: Winding Group Type=Voltage IsSolid=true Current=16.36A Resistance=0ohm Inductance=0nH Voltage=volt_ac ParallelBranchesNum=1 Phase=0rad
  Ns: Winding Group Type=Current IsSolid=true Current=100000*1.41/volt_ac*1.414 ParallelBranchesNum=1 Phase=0.1522rad
  eddy effects on: Body1_1, Body1_4, Ns1, Ns7, Ns4, Ns8, Ns2, Ns6, Ns5, Ns3, Np1, Np7, Np4, Np8, Np2, Np6, Np5, Np3
  core loss on: Body1_2, Body1_5
parameters:
  Matrix1: Matrix Np, Ns:
mesh:
  SkinDepth1: SkinDepthBased Objects=[Np1..Np8, Ns1..Ns8] SkinDepth=0.20567444mm SurfTriMaxLength=1mm NumLayers=2
  Length1: LengthBased Objects=[Body1_1, Body1_4, Body1_2, Body1_5, plate_1, plate_2] MaxLength=10mm
  Wire: LengthBased disabled Objects=[Np1..Np8, Ns1..Ns8] MaxLength=5mm
  initial mesh: GlobalSurfApproximation{CurvedSurfaceApproxChoice=UseSlider SliderMeshSettings=9} GlobalCurvilinear{Apply}
setups:
  Setup1: EddyCurrent MaximumPasses=20 MinimumPasses=6 MinimumConvergedPasses=1 PercentRefinement=30 PercentError=1 NonLinearResidual=0.0001 SmoothBHCurve Frequency=28.5kHz SweepRanges{point 28500Hz} SaveAllFields
field plots:
  Mesh1: MeshPlots in Region on Setup1 : LastAdaptive at Freq=28500Hz Phase=0deg
  Mesh3: MeshPlots in Np1..Np8, Ns1..Ns8 on Setup1 : LastAdaptive at Freq=28500Hz Phase=0deg
reports:
  L Table 1: Matrix1.L(Np,Np), Matrix1.L(Ns,Np), Matrix1.L(Np,Ns), Matrix1.L(Ns,Ns), Matrix1.R(Np,Np), Matrix1.R(Ns,Np), Matrix1.R(Np,Ns), Matrix1.R(Ns,Ns) vs Freq on Setup1 : LastAdaptive

design [Thermal]Flatwise_100kW=latest1 (Icepak, SteadyState TemperatureAndFlow, model units mm)
options: Default_Fluid_Material=air Default_Solid_Material=Al-Extruded Default_Surface_Material=Steel-oxidised-surface AmbientTemperature=25cel AmbientPressure=0n_per_meter_sq AmbientRadiationTemperature=25cel Gravity_Vector_CS_ID=Global Gravity_Vector_Axis=Z Positive=false SherlockExportDirectory=C:/Users/karlr/Documents/Ansoft/1kW_Final.aedtexport/[Thermal]8turns_3D_CoreLoss_FullInterleaved_Flatwise/ Altitude=0meter
geometry:
  Region [air] = region(percentage_offset: +X=1000, -X=0, +Y=1000, -Y=1000, +Z=1000, -Z=1000)
  Body1, Body1_1 [aluminum_real] = imported_body(D:\Karl_HighPower\flatwise_100kW.step)
  Body1_2 [ferrite - real2] = imported_body(D:\Karl_HighPower\flatwise_100kW.step)
  Body1_3, Body1_4 [aluminum_real] = imported_body(D:\Karl_HighPower\flatwise_100kW.step)
  Body1_5 [ferrite - real2] = imported_body(D:\Karl_HighPower\flatwise_100kW.step)
  plate_1, plate_2 [silicon_TIMreal] = imported_body(D:\Karl_HighPower\flatwise_100kW.step)
  Box3 [silicon - Copy] = box(corner=(127.6mm, 239.49mm, 0mm), size=(-127.6mm, -278.29mm, -5mm))
  Rectangle1 [Al-Extruded, non-model] = rectangle(corner=(0mm, 100.345mm, -5mm), z_size=94mm, x_size=127.6mm)
  Box4 [non-model] = box(corner=(12.5mm, -38.8mm, 12.5mm), size=(102.6mm, 278.29mm, 64mm))
  Np1..Np8, Ns1..Ns8 [coppe_real] = imported_body()
  [Body1, Body1_1..Body1_5, plate_1, plate_2, Ns1, Ns7, Ns4, Ns8, Ns2, Ns6, Ns5, Ns3, Np1, Np7, Np4, Np8, Np2, Np6, Np5, Np3, Box3, Rectangle1, Box4].move(-63.8mm, -100.345mm, 5mm)
  [Body1, Body1_1..Body1_5, plate_1, plate_2, Ns1, Ns7, Ns4, Ns8, Ns2, Ns6, Ns5, Ns3, Np1, Np7, Np4, Np8, Np2, Np6, Np5, Np3, Box3, Rectangle1, Box4].split(plane=YZ, keep=PositiveOnly)
  Box5 [non-model] = box(corner=(0mm, -139.145mm, 1.110223e-14mm), size=(63.8mm, 278.29mm, 94mm))
  group flatwise_100kW = Body1, Body1_1..Body1_5, plate_1, plate_2, Ns1, Ns7, Ns4, Ns8, Ns2, Ns6, Ns5, Ns3, Np1, Np7, Np4, Np8, Np2, Np6, Np5, Np3
boundaries and excitations:
  Opening1: Opening Faces=Region.face(-y) Temperature=AmbientTemp External_Rad._Temperature=AmbientRadTemp Inlet_Type=Velocity Static_Pressure=AmbientPressure X_Velocity=0m_per_sec Y_Velocity=0m_per_sec Z_Velocity=0m_per_sec
  Opening2: Opening Faces=Region.face(+y) Temperature=AmbientTemp External_Rad._Temperature=AmbientRadTemp Inlet_Type=Pressure Total_Pressure=AmbientPressure
  EMLoss1: EM Loss Objects=[Body1, Body1_1..Body1_5, Ns1, Ns7, Ns4, Ns8, Ns2, Ns6, Ns5, Ns3, Np1, Np7, Np4, Np8, Np2, Np6, Np5, Np3] LinkID=899 Project="This Project*" Product=ElectronicsDesktop Design=Flatwise_100kW Params{freq_hz=28500Hz} ForceSourceToSolve PreservePartnerSoln PathRelativeTo=TargetProject Intrinsics(28.5kHz, 28.5kHz) LossMultiplier=1
  StationaryWall1: Stationary Wall Faces=Box3.face(-z) Thickness=0mm Solid_Material=Al-Extruded External_Condition=Temperature Heat_Flux=0irrad_W_per_m2 Temperature=20cel Heat_Transfer_Coefficient=0w_per_m2kel Reference_Temperature=AmbientTemp Heat_Transfer_Data{Heat_Transfer_Convection_Type="Forced Convection"} External_Material=Steel-oxidised-surface External_Radiation_Reference_Temperature=AmbientTemp External_Radiation_View_Factor=1
  SymmetryWall1: Symmetry Wall Faces=Region.face(-x)
mesh:
  MeshRegions:  Global{MeshMethod=MesherHD ComputeGap MeshRegionResolution=5 MinGapX=1mm MinGapY=1mm MinGapZ=1mm Objects=Region FacetLevel=5 ProximitySizeFunction CurvatureSizeFunction OptimizePCBMesh} MeshRegion1{MeshMethod=MesherHD UserSpecifiedSettings MaxElementSizeX=0.3mm MaxElementSizeY=0.3mm MaxElementSizeZ=1mm MinElementsInGap=3 MinElementsOnEdge=2 MaxSizeRatio=2 EnableMLM EnforeMLMType=3D MaxLevels=0 BufferLayers=0 UniformMeshParametersType=Average 2DMLMType=2DMLM_None MinGapX=0.3mm MinGapY=0.3mm MinGapZ=0.3mm Objects=Box5 ProximitySizeFunction CurvatureSizeFunction OptimizePCBMesh}
  MeshOperations:
setups:
  Setup1: IcepakSteadyState Flow_Regime=Laminar Include_Temperature=true Include_Flow=true Include_Gravity Solution_Initialization_-_Z_Velocity=0.000980665m_per_sec Convergence_Criteria_-_Flow=0.001 Convergence_Criteria_-_Energy=1e-07 Convergence_Criteria_-_Discrete_Ordinates=1e-06 Radiation_Model="Discrete Ordinates Model" Flow_Iteration_Per_Radiation_Iteration=10 ThetaDivision=2 PhiDivision=2 ThetaPixels=2 PhiPixels=2 Under-relaxation_-_Pressure=0.7 Under-relaxation_-_Momentum=0.3 Under-relaxation_-_Temperature=1 Discretization_Scheme_-_Pressure=Standard Discretization_Scheme_-_Momentum=First Discretization_Scheme_-_Temperature=First Discretization_Scheme_-_Discrete_Ordinates=First Convergence_Criteria_-_Max_Iterations=800
field plots:
  Temperature1: Temperature over Body1, Body1_1..Body1_5, plate_1, plate_2, Ns1, Ns7, Ns4, Ns8, Ns2, Ns6, Ns5, Ns3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 on Setup1 : SteadyState
  Temperature2: Temperature over a plane on Setup1 : SteadyState
