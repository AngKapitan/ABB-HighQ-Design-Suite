# Ansys Electronics Desktop project, version 2023.1
materials:
  vacuum: permittivity=1
  copper: permeability=0.999991 conductivity=58000000
  ferrite - Copy (2): core_loss_curve{25kHz (0, 0) (0.050633, 1) (0.0590114, 1.50406) (0.0691674, 2.34392) (0.0792528, 3.65275) (0.088772, 5.02746) (0.0939521, 6.11121) (0.1, 7.16954) (0.109499, 8.56175) (0.121957, 11.5767) (0.138164, 16.5092) (0.153013, 23.1293) (0.173347, 32.9841) (0.195272, 44.5991) (0.21382, 61.3838) (0.235462, 78.6962) (0.259294, 104.536) (0.280722, 138.862) (0.295422, 151.746)} core_loss_curve{100kHz (0, 0) (0.0263744, 1.03613) (0.0293752, 1.42608) (0.0332788, 2.03369) (0.0396755, 3.1693) (0.0449479, 4.44016) (0.0523856, 6.91954) (0.0628101, 11.373) (0.0753091, 20.068) (0.0882699, 32.4039) (0.103461, 49.6099) (0.118547, 74.6161) (0.142138, 118.363) (0.165658, 191.122) (0.184506, 245.025) (0.1975, 325.48) (0.215037, 409.937) (0.242235, 554.291) (0.26827, 762.898) (0.287163, 911.04)} core_loss_curve{200kHz (0, 0) (0.0153013, 1.07357) (0.0196383, 2.03369) (0.0260769, 4.28533) (0.0305648, 7.42858) (0.0396755, 14.0722) (0.0481134, 22.7224) (0.059347, 38.6962) (0.0757374, 74.6161) (0.0994345, 162.909) (0.110748, 216.401) (0.130546, 319.755) (0.147894, 472.47) (0.164721, 605.722) (0.183462, 848.612) (0.194168, 1013.4) (0.210213, 1167.99) (0.235462, 1607.55) (0.252045, 2024.69) (0.274425, 2333.54) (0.290439, 2939.06)} core_loss_curve{500kHz (0, 0) (0.0101716, 5.89811) (0.01199, 8.71505) (0.0149581, 13.5815) (0.0170423, 18.6929) (0.0202031, 30.1834) (0.0235462, 38.6962) (0.0266752, 55.1837) (0.0309135, 72.0142) (0.0356225, 99.1166) (0.0401281, 129.346) (0.0465037, 187.76) (0.0515018, 236.481) (0.0580159, 319.755) (0.067616, 447.974) (0.0761681, 574.318) (0.0892769, 776.557) (0.101141, 1068.81) (0.1199, 1524.21) (0.142138, 2292.49) (0.174333, 3327.81) (0.199753, 5186.04) (0.22248, 6531.74) (0.249202, 8373.92)} permittivity=12 permeability=3400 conductivity=0.25 core_loss_type="Power Ferrite" core_loss_cm=0.062032234 core_loss_x=1.7066326 core_loss_y=2.5354555 mass_density=4800 core_loss_equiv_cut_depth=0.001meter
  silicon - Copy: permittivity=9
  ferrite - Copy (3): core_loss_curve{25kHz (0, 0) (0.050633, 1) (0.0590114, 1.50406) (0.0691674, 2.34392) (0.0792528, 3.65275) (0.088772, 5.02746) (0.0939521, 6.11121) (0.1, 7.16954) (0.109499, 8.56175) (0.121957, 11.5767) (0.138164, 16.5092) (0.153013, 23.1293) (0.173347, 32.9841) (0.195272, 44.5991) (0.21382, 61.3838) (0.235462, 78.6962) (0.259294, 104.536) (0.280722, 138.862) (0.295422, 151.746)} core_loss_curve{100kHz (0, 0) (0.0263744, 1.03613) (0.0293752, 1.42608) (0.0332788, 2.03369) (0.0396755, 3.1693) (0.0449479, 4.44016) (0.0523856, 6.91954) (0.0628101, 11.373) (0.0753091, 20.068) (0.0882699, 32.4039) (0.103461, 49.6099) (0.118547, 74.6161) (0.142138, 118.363) (0.165658, 191.122) (0.184506, 245.025) (0.1975, 325.48) (0.215037, 409.937) (0.242235, 554.291) (0.26827, 762.898) (0.287163, 911.04)} core_loss_curve{200kHz (0, 0) (0.0153013, 1.07357) (0.0196383, 2.03369) (0.0260769, 4.28533) (0.0305648, 7.42858) (0.0396755, 14.0722) (0.0481134, 22.7224) (0.059347, 38.6962) (0.0757374, 74.6161) (0.0994345, 162.909) (0.110748, 216.401) (0.130546, 319.755) (0.147894, 472.47) (0.164721, 605.722) (0.183462, 848.612) (0.194168, 1013.4) (0.210213, 1167.99) (0.235462, 1607.55) (0.252045, 2024.69) (0.274425, 2333.54) (0.290439, 2939.06)} core_loss_curve{500kHz (0, 0) (0.0101716, 5.89811) (0.01199, 8.71505) (0.0149581, 13.5815) (0.0170423, 18.6929) (0.0202031, 30.1834) (0.0235462, 38.6962) (0.0266752, 55.1837) (0.0309135, 72.0142) (0.0356225, 99.1166) (0.0401281, 129.346) (0.0465037, 187.76) (0.0515018, 236.481) (0.0580159, 319.755) (0.067616, 447.974) (0.0761681, 574.318) (0.0892769, 776.557) (0.101141, 1068.81) (0.1199, 1524.21) (0.142138, 2292.49) (0.174333, 3327.81) (0.199753, 5186.04) (0.22248, 6531.74) (0.249202, 8373.92)} permittivity=12 permeability=1000 conductivity=0.25 core_loss_type="Power Ferrite" core_loss_cm=0.062032234 core_loss_x=1.7066326 core_loss_y=2.5354555 mass_density=4800 core_loss_equiv_cut_depth=0.001meter

design Maxwell2DDesign1 (Maxwell 2D, EddyCurrent, XY geometry, model units mm)
options: ModelDepth=1meter
geometry:
  Rectangle1 [copper] = rectangle(corner=(-0.004mm, -0.002mm, 0mm), x_size=0.3mm, y_size=6.5mm)
  Rectangle2 [copper] = rectangle(corner=(-0.004mm, -0.002mm, 0mm), x_size=0.3mm, y_size=6.5mm)
  Rectangle2.move(0.4mm, 0mm, 0mm)
  Region [vacuum] = region(percentage_offset=0 on all sides)
boundaries and excitations:
  Balloon1: Balloon Edges=Region.edge(all 4)
  Current1: Current Objects=Rectangle1 Phase=0deg Current=1A IsSolid=true IsPositive=true
  Current2: Current Objects=Rectangle2 Phase=0deg Current=-1A IsSolid=true IsPositive=true
mesh:
  Length1: LengthBased Objects=[Rectangle1, Rectangle2] MaxLength=0.1mm
  initial mesh: GlobalSurfApproximation{CurvedSurfaceApproxChoice=UseSlider SliderMeshSettings=9}
setups:
  Setup1: EddyCurrent MaximumPasses=20 MinimumPasses=2 MinimumConvergedPasses=1 PercentRefinement=30 PercentError=1 NonLinearResidual=0.0001 Frequency=28.5kHz
field plots:
  JAtPhase1: J over Rectangle1, Rectangle2 on Setup1 : LastAdaptive at Freq=28.5kHz Phase=45deg

design Maxwell2DDesign2 (Maxwell 2D, EddyCurrent, XY geometry, model units mm)
options: ModelDepth=1meter
geometry:
  Rectangle1 [copper] = rectangle(corner=(-0.004mm, -0.002mm, 0mm), x_size=0.3mm, y_size=6.5mm)
  Rectangle2 [copper] = rectangle(corner=(-0.004mm, -0.002mm, 0mm), x_size=0.3mm, y_size=6.5mm)
  Rectangle2.move(0.4mm, 0mm, 0mm)
  [Rectangle1, Rectangle2].rotate(axis=Z, angle=90deg)
  Rectangle3 [vacuum] = rectangle(corner=(-8mm, 2.5mm, 0mm), x_size=9.5mm, y_size=-4mm)
boundaries and excitations:
  Balloon1: Balloon Edges=Rectangle3.edge(all 4)
  Current1: Current Objects=Rectangle1 Phase=0deg Current=1A IsSolid=true IsPositive=true
  Current2: Current Objects=Rectangle2 Phase=180deg Current=1A IsSolid=true IsPositive=true
mesh:
  Length1: LengthBased Objects=[Rectangle1, Rectangle2] MaxLength=0.1mm
  initial mesh: GlobalSurfApproximation{CurvedSurfaceApproxChoice=UseSlider SliderMeshSettings=9}
setups:
  Setup1: EddyCurrent MaximumPasses=20 MinimumPasses=2 MinimumConvergedPasses=1 PercentRefinement=30 PercentError=1 NonLinearResidual=0.0001 Frequency=28.5kHz
field plots:
  JAtPhase1: J over Rectangle2, Rectangle1 on Setup1 : LastAdaptive at Freq=28.5kHz Phase=45deg

design Edgewise (Maxwell 2D, EddyCurrent, XY geometry, model units mm)
options: ModelDepth=1meter
geometry:
  Region [vacuum] = region(percentage_offset: +X=100, -X=0, +Y=100, -Y=100, +Z=0, -Z=0)
  Np1#25790, Np2#25842, Np3#25894, Np4#25946, Np5#25998, Np6#26050, Np7#26102, Np8#26154, Ns1#26206, Ns2#26258, Ns3#26310, Ns4#26362, Ns5#26414, Ns6#26466, Ns7#26518, Ns8#26570, plate1#26622, plate2#26674, Body1#26726, Body1_3#26906 = imported_body(C:\Users\karlr\Documents\ICMaSS_sweeping\edgewise_0.1_0.3.step)
  [Np1#25790, Np2#25842, Np3#25894, Np4#25946, Np5#25998, Np6#26050, Np7#26102, Np8#26154, Ns1#26206, Ns2#26258, Ns3#26310, Ns4#26362, Ns5#26414, Ns6#26466, Ns7#26518, Ns8#26570, plate1#26622, plate2#26674, Body1#26726, Body1_3#26906].move(-18.666667mm, -25.43mm, -1.6666613e-08mm)
  Np1 [copper] = Np1#25790.section(plane=ZX)
  Np1#25790.delete()
  Np1.rotate(axis=X, angle=-90deg)
  Np2 [copper] = Np2#25842.section(plane=ZX)
  Np2#25842.delete()
  Np2.rotate(axis=X, angle=-90deg)
  Np3 [copper] = Np3#25894.section(plane=ZX)
  Np3#25894.delete()
  Np3.rotate(axis=X, angle=-90deg)
  Np4 [copper] = Np4#25946.section(plane=ZX)
  Np4#25946.delete()
  Np4.rotate(axis=X, angle=-90deg)
  Np5 [copper] = Np5#25998.section(plane=ZX)
  Np5#25998.delete()
  Np5.rotate(axis=X, angle=-90deg)
  Np6 [copper] = Np6#26050.section(plane=ZX)
  Np6#26050.delete()
  Np6.rotate(axis=X, angle=-90deg)
  Np7 [copper] = Np7#26102.section(plane=ZX)
  Np7#26102.delete()
  Np7.rotate(axis=X, angle=-90deg)
  Np8 [copper] = Np8#26154.section(plane=ZX)
  Np8#26154.delete()
  Np8.rotate(axis=X, angle=-90deg)
  Ns1 [copper] = Ns1#26206.section(plane=ZX)
  Ns1#26206.delete()
  Ns1.rotate(axis=X, angle=-90deg)
  Ns2 [copper] = Ns2#26258.section(plane=ZX)
  Ns2#26258.delete()
  Ns2.rotate(axis=X, angle=-90deg)
  Ns3 [copper] = Ns3#26310.section(plane=ZX)
  Ns3#26310.delete()
  Ns3.rotate(axis=X, angle=-90deg)
  Ns4 [copper] = Ns4#26362.section(plane=ZX)
  Ns4#26362.delete()
  Ns4.rotate(axis=X, angle=-90deg)
  Ns5 [copper] = Ns5#26414.section(plane=ZX)
  Ns5#26414.delete()
  Ns5.rotate(axis=X, angle=-90deg)
  Ns6 [copper] = Ns6#26466.section(plane=ZX)
  Ns6#26466.delete()
  Ns6.rotate(axis=X, angle=-90deg)
  Ns7 [copper] = Ns7#26518.section(plane=ZX)
  Ns7#26518.delete()
  Ns7.rotate(axis=X, angle=-90deg)
  Ns8 [copper] = Ns8#26570.section(plane=ZX)
  Ns8#26570.delete()
  Ns8.rotate(axis=X, angle=-90deg)
  plate1 [silicon - Copy] = plate1#26622.section(plane=ZX)
  plate1#26622.delete()
  plate1.rotate(axis=X, angle=-90deg)
  plate2 [silicon - Copy] = plate2#26674.section(plane=ZX)
  plate2#26674.delete()
  plate2.rotate(axis=X, angle=-90deg)
  Body1 [ferrite - Copy (2)] = Body1#26726.section(plane=ZX)
  Body1#26726.delete()
  Body1.rotate(axis=X, angle=-90deg)
  Body1_3 [ferrite - Copy (2)] = Body1_3#26906.section(plane=ZX)
  Body1_3#26906.delete()
  Body1_3.rotate(axis=X, angle=-90deg)
  [Np1..Np8, Ns1..Ns8, plate1, plate2, Body1, Body1_3].split(plane=YZ, keep=PositiveOnly)
  group core_assembled_edgewise2 = Np1..Np8, Ns1..Ns8, plate1, plate2
  group core_together_3 = Body1
  group core_together2 = Body1_3
boundaries and excitations:
  Balloon1: Balloon Edges=Region.edge(at (18.6667, 36.6, 0), at (37.3333, 9.15, 0), at (18.6667, -18.3, 0))
  Symmetry1: Symmetry Edges=Region.edge(at (0, 9.15, 0)) IsOdd=true
  Current_1: Current Objects=Np1 Phase=0deg Current=1A IsSolid=true IsPositive=true
  Current_2: Current Objects=Np2 Phase=0deg Current=1A IsSolid=true IsPositive=true
  Current_3: Current Objects=Np3 Phase=0deg Current=1A IsSolid=true IsPositive=true
  Current_4: Current Objects=Np4 Phase=0deg Current=1A IsSolid=true IsPositive=true
  Current_5: Current Objects=Np5 Phase=0deg Current=1A IsSolid=true IsPositive=true
  Current_6: Current Objects=Np6 Phase=0deg Current=1A IsSolid=true IsPositive=true
  Current_7: Current Objects=Np7 Phase=0deg Current=1A IsSolid=true IsPositive=true
  Current_8: Current Objects=Np8 Phase=0deg Current=1A IsSolid=true IsPositive=true
  Current_9: Current Objects=Ns1 Phase=180deg Current=1A IsSolid=true IsPositive=true
  Current_10: Current Objects=Ns2 Phase=180deg Current=1A IsSolid=true IsPositive=true
  Current_11: Current Objects=Ns3 Phase=180deg Current=1A IsSolid=true IsPositive=true
  Current_12: Current Objects=Ns4 Phase=180deg Current=1A IsSolid=true IsPositive=true
  Current_13: Current Objects=Ns5 Phase=180deg Current=1A IsSolid=true IsPositive=true
  Current_14: Current Objects=Ns6 Phase=180deg Current=1A IsSolid=true IsPositive=true
  Current_15: Current Objects=Ns7 Phase=180deg Current=1A IsSolid=true IsPositive=true
  Current_16: Current Objects=Ns8 Phase=180deg Current=1A IsSolid=true IsPositive=true
  eddy effects on: Np1..Np8, Ns1..Ns8
mesh:
  SkinDepth1: SkinDepthLayers Edges=Np1.edge(all 4) Np2.edge(all 4) Np3.edge(all 4) Np4.edge(all 4) Np5.edge(all 4) Np6.edge(all 4) Np7.edge(all 4) Np8.edge(all 4) Ns1.edge(all 4) Ns2.edge(all 4) Ns3.edge(all 4) Ns4.edge(all 4) Ns5.edge(all 4) Ns6.edge(all 4) Ns7.edge(all 4) Ns8.edge(all 4) SkinDepth=0.05mm NumLayers=4 NumMaxElem=1000 SurfTriMaxLength=1.3333333mm
setups:
  Setup1: EddyCurrent MaximumPasses=20 MinimumPasses=2 MinimumConvergedPasses=1 PercentRefinement=30 PercentError=1 NonLinearResidual=0.0001 Frequency=100kHz
field plots:
  JAtPhase1: J over Np1..Np8, Ns1..Ns8 on Setup1 : LastAdaptive at Freq=100kHz Phase=45deg

design Flatwise (Maxwell 2D, EddyCurrent, XY geometry, model units mm)
options: ModelDepth=1meter
geometry:
  Region [vacuum] = region(percentage_offset: +X=100, -X=0, +Y=100, -Y=100, +Z=0, -Z=0)
  Np1#30839, Np2#30891, Np3#30943, Np4#30995, Np5#31047, Np6#31099, Np7#31151, Np8#31203, Ns1#31255, Ns2#31307, Ns3#31359, Ns4#31411, Ns5#31463, Ns6#31515, Ns7#31567, Ns8#31619, plate_1#31671, plate_2#31723, Body1#31775, Body1_3#31955 = imported_body(C:\Users\karlr\Documents\ICMaSS_sweeping\flatwise_0.1_0.3.step)
  [Np1#30839, Np2#30891, Np3#30943, Np4#30995, Np5#31047, Np6#31099, Np7#31151, Np8#31203, Ns1#31255, Ns2#31307, Ns3#31359, Ns4#31411, Ns5#31463, Ns6#31515, Ns7#31567, Ns8#31619, plate_1#31671, plate_2#31723, Body1#31775, Body1_3#31955].move(-18.3mm, -25.43mm, -9.2833333mm)
  Np1 [copper] = Np1#30839.section(plane=ZX)
  Np1#30839.delete()
  Np1.rotate(axis=X, angle=-90deg)
  Np2 [copper] = Np2#30891.section(plane=ZX)
  Np2#30891.delete()
  Np2.rotate(axis=X, angle=-90deg)
  Np3 [copper] = Np3#30943.section(plane=ZX)
  Np3#30943.delete()
  Np3.rotate(axis=X, angle=-90deg)
  Np4 [copper] = Np4#30995.section(plane=ZX)
  Np4#30995.delete()
  Np4.rotate(axis=X, angle=-90deg)
  Np5 [copper] = Np5#31047.section(plane=ZX)
  Np5#31047.delete()
  Np5.rotate(axis=X, angle=-90deg)
  Np6 [copper] = Np6#31099.section(plane=ZX)
  Np6#31099.delete()
  Np6.rotate(axis=X, angle=-90deg)
  Np7 [copper] = Np7#31151.section(plane=ZX)
  Np7#31151.delete()
  Np7.rotate(axis=X, angle=-90deg)
  Np8 [copper] = Np8#31203.section(plane=ZX)
  Np8#31203.delete()
  Np8.rotate(axis=X, angle=-90deg)
  Ns1 [copper] = Ns1#31255.section(plane=ZX)
  Ns1#31255.delete()
  Ns1.rotate(axis=X, angle=-90deg)
  Ns2 [copper] = Ns2#31307.section(plane=ZX)
  Ns2#31307.delete()
  Ns2.rotate(axis=X, angle=-90deg)
  Ns3 [copper] = Ns3#31359.section(plane=ZX)
  Ns3#31359.delete()
  Ns3.rotate(axis=X, angle=-90deg)
  Ns4 [copper] = Ns4#31411.section(plane=ZX)
  Ns4#31411.delete()
  Ns4.rotate(axis=X, angle=-90deg)
  Ns5 [copper] = Ns5#31463.section(plane=ZX)
  Ns5#31463.delete()
  Ns5.rotate(axis=X, angle=-90deg)
  Ns6 [copper] = Ns6#31515.section(plane=ZX)
  Ns6#31515.delete()
  Ns6.rotate(axis=X, angle=-90deg)
  Ns7 [copper] = Ns7#31567.section(plane=ZX)
  Ns7#31567.delete()
  Ns7.rotate(axis=X, angle=-90deg)
  Ns8 [copper] = Ns8#31619.section(plane=ZX)
  Ns8#31619.delete()
  Ns8.rotate(axis=X, angle=-90deg)
  plate_1 [silicon - Copy] = plate_1#31671.section(plane=ZX)
  plate_1#31671.delete()
  plate_1.rotate(axis=X, angle=-90deg)
  plate_2 [silicon - Copy] = plate_2#31723.section(plane=ZX)
  plate_2#31723.delete()
  plate_2.rotate(axis=X, angle=-90deg)
  Body1 [ferrite - Copy (2)] = Body1#31775.section(plane=ZX)
  Body1#31775.delete()
  Body1.rotate(axis=X, angle=-90deg)
  Body1_3 [ferrite - Copy (2)] = Body1_3#31955.section(plane=ZX)
  Body1_3#31955.delete()
  Body1_3.rotate(axis=X, angle=-90deg)
  [Np1..Np8, Ns1..Ns8, plate_1, plate_2, Body1, Body1_3].split(plane=YZ, keep=PositiveOnly)
  Body1_3.move(0mm, 0mm, -1mm)
  Body1_3.move(0mm, -1mm, 0mm)
  Body1.move(0mm, 1mm, 0mm)
  Body1_3.move(-1.0125234e-13mm, 1mm, 0mm)
  Body1.move(-1.8296475e-13mm, -1mm, 0mm)
  Body1_3.move(0mm, 1mm, 0mm)
  Body1_3.move(0mm, 0mm, 1mm)
  Body1_3.move(0mm, -2mm, 0mm)
  Body1_3.move(0mm, 1mm, 0mm)
  Rectangle1 [vacuum, non-model] = rectangle(corner=(0mm, 9.3833333mm, 0mm), x_size=18.3mm, y_size=-18.666667mm)
  group core_assembled_flatwise = Np1..Np8, Ns1..Ns8, plate_1, plate_2
  group core_together_1 = Body1
  group core_together = Body1_3
boundaries and excitations:
  Balloon1: Balloon Edges=Region.edge(at (18.3, 28.05, 0), at (36.6, 0.05, 0), at (18.3, -27.95, 0))
  Symmetry1: Symmetry Edges=Region.edge(at (0, 0.05, 0)) IsOdd=true
  Current_1: Current Objects=Np1 Phase=0deg Current=1A IsSolid=true IsPositive=true
  Current_2: Current Objects=Np2 Phase=0deg Current=1A IsSolid=true IsPositive=true
  Current_3: Current Objects=Np3 Phase=0deg Current=1A IsSolid=true IsPositive=true
  Current_4: Current Objects=Np4 Phase=0deg Current=1A IsSolid=true IsPositive=true
  Current_5: Current Objects=Np5 Phase=0deg Current=1A IsSolid=true IsPositive=true
  Current_6: Current Objects=Np6 Phase=0deg Current=1A IsSolid=true IsPositive=true
  Current_7: Current Objects=Np7 Phase=0deg Current=1A IsSolid=true IsPositive=true
  Current_8: Current Objects=Np8 Phase=0deg Current=1A IsSolid=true IsPositive=true
  Current_9: Current Objects=Ns1 Phase=180deg Current=1A IsSolid=true IsPositive=true
  Current_10: Current Objects=Ns2 Phase=180deg Current=1A IsSolid=true IsPositive=true
  Current_11: Current Objects=Ns3 Phase=180deg Current=1A IsSolid=true IsPositive=true
  Current_12: Current Objects=Ns4 Phase=180deg Current=1A IsSolid=true IsPositive=true
  Current_13: Current Objects=Ns5 Phase=180deg Current=1A IsSolid=true IsPositive=true
  Current_14: Current Objects=Ns6 Phase=180deg Current=1A IsSolid=true IsPositive=true
  Current_15: Current Objects=Ns7 Phase=180deg Current=1A IsSolid=true IsPositive=true
  Current_16: Current Objects=Ns8 Phase=180deg Current=1A IsSolid=true IsPositive=true
mesh:
  SkinDepth1: SkinDepthLayers Edges=Np1.edge(all 4) Np2.edge(all 4) Np3.edge(all 4) Np4.edge(all 4) Np5.edge(all 4) Np6.edge(all 4) Np7.edge(all 4) Np8.edge(all 4) Ns1.edge(all 4) Ns2.edge(all 4) Ns3.edge(all 4) Ns4.edge(all 4) Ns5.edge(all 4) Ns6.edge(all 4) Ns7.edge(all 4) Ns8.edge(all 4) SkinDepth=0.05mm NumLayers=2 NumMaxElem=1000 SurfTriMaxLength=1.3333333mm
  Length1: LengthBased Objects=[Body1, Body1_3] MaxLength=0.1
  initial mesh: GlobalSurfApproximation{CurvedSurfaceApproxChoice=UseSlider SliderMeshSettings=9}
setups:
  Setup1: EddyCurrent MaximumPasses=20 MinimumPasses=2 MinimumConvergedPasses=1 PercentRefinement=30 PercentError=0.5 NonLinearResidual=0.0001 Frequency=100kHz
field plots:
  JAtPhase1: J over Np1..Np8, Ns1..Ns8 on Setup1 : LastAdaptive at Freq=100kHz Phase=45deg
  Mag_H1: H over a plane on Setup1 : LastAdaptive at Freq=100kHz Phase=0deg

design Edgewise_NoInterleaving (Maxwell 2D, EddyCurrent, XY geometry, model units mm)
options: ModelDepth=1meter
geometry:
  Region [vacuum] = region(percentage_offset: +X=100, -X=0, +Y=100, -Y=100, +Z=0, -Z=0)
  Np1#25790, Np2#25842, Np3#25894, Np4#25946, Np5#25998, Np6#26050, Np7#26102, Np8#26154, Ns1#26206, Ns2#26258, Ns3#26310, Ns4#26362, Ns5#26414, Ns6#26466, Ns7#26518, Ns8#26570, plate1#26622, plate2#26674, Body1#26726, Body1_3#26906 = imported_body(C:\Users\karlr\Documents\ICMaSS_sweeping\edgewise_0.1_0.3.step)
  [Np1#25790, Np2#25842, Np3#25894, Np4#25946, Np5#25998, Np6#26050, Np7#26102, Np8#26154, Ns1#26206, Ns2#26258, Ns3#26310, Ns4#26362, Ns5#26414, Ns6#26466, Ns7#26518, Ns8#26570, plate1#26622, plate2#26674, Body1#26726, Body1_3#26906].move(-18.666667mm, -25.43mm, -1.6666613e-08mm)
  Np1 [copper] = Np1#25790.section(plane=ZX)
  Np1#25790.delete()
  Np1.rotate(axis=X, angle=-90deg)
  Np2 [copper] = Np2#25842.section(plane=ZX)
  Np2#25842.delete()
  Np2.rotate(axis=X, angle=-90deg)
  Np3 [copper] = Np3#25894.section(plane=ZX)
  Np3#25894.delete()
  Np3.rotate(axis=X, angle=-90deg)
  Np4 [copper] = Np4#25946.section(plane=ZX)
  Np4#25946.delete()
  Np4.rotate(axis=X, angle=-90deg)
  Np5 [copper] = Np5#25998.section(plane=ZX)
  Np5#25998.delete()
  Np5.rotate(axis=X, angle=-90deg)
  Np6 [copper] = Np6#26050.section(plane=ZX)
  Np6#26050.delete()
  Np6.rotate(axis=X, angle=-90deg)
  Np7 [copper] = Np7#26102.section(plane=ZX)
  Np7#26102.delete()
  Np7.rotate(axis=X, angle=-90deg)
  Np8 [copper] = Np8#26154.section(plane=ZX)
  Np8#26154.delete()
  Np8.rotate(axis=X, angle=-90deg)
  Ns1 [copper] = Ns1#26206.section(plane=ZX)
  Ns1#26206.delete()
  Ns1.rotate(axis=X, angle=-90deg)
  Ns2 [copper] = Ns2#26258.section(plane=ZX)
  Ns2#26258.delete()
  Ns2.rotate(axis=X, angle=-90deg)
  Ns3 [copper] = Ns3#26310.section(plane=ZX)
  Ns3#26310.delete()
  Ns3.rotate(axis=X, angle=-90deg)
  Ns4 [copper] = Ns4#26362.section(plane=ZX)
  Ns4#26362.delete()
  Ns4.rotate(axis=X, angle=-90deg)
  Ns5 [copper] = Ns5#26414.section(plane=ZX)
  Ns5#26414.delete()
  Ns5.rotate(axis=X, angle=-90deg)
  Ns6 [copper] = Ns6#26466.section(plane=ZX)
  Ns6#26466.delete()
  Ns6.rotate(axis=X, angle=-90deg)
  Ns7 [copper] = Ns7#26518.section(plane=ZX)
  Ns7#26518.delete()
  Ns7.rotate(axis=X, angle=-90deg)
  Ns8 [copper] = Ns8#26570.section(plane=ZX)
  Ns8#26570.delete()
  Ns8.rotate(axis=X, angle=-90deg)
  plate1 [silicon - Copy] = plate1#26622.section(plane=ZX)
  plate1#26622.delete()
  plate1.rotate(axis=X, angle=-90deg)
  plate2 [silicon - Copy] = plate2#26674.section(plane=ZX)
  plate2#26674.delete()
  plate2.rotate(axis=X, angle=-90deg)
  Body1 [ferrite - Copy (3)] = Body1#26726.section(plane=ZX)
  Body1#26726.delete()
  Body1.rotate(axis=X, angle=-90deg)
  Body1_3 [ferrite - Copy (3)] = Body1_3#26906.section(plane=ZX)
  Body1_3#26906.delete()
  Body1_3.rotate(axis=X, angle=-90deg)
  [Np1..Np8, Ns1..Ns8, plate1, plate2, Body1, Body1_3].split(plane=YZ, keep=PositiveOnly)
  group core_assembled_edgewise2 = Np1..Np8, Ns1..Ns8, plate1, plate2
  group core_together_3 = Body1
  group core_together2 = Body1_3
boundaries and excitations:
  Balloon1: Balloon Edges=Region.edge(at (18.6667, 36.6, 0), at (37.3333, 9.15, 0), at (18.6667, -18.3, 0))
  Symmetry1: Symmetry Edges=Region.edge(at (0, 9.15, 0)) IsOdd=true
  Current_1: Current Objects=Np1 Phase=0deg Current=1A IsSolid=true IsPositive=true
  Current_2: Current Objects=Np2 Phase=0deg Current=1A IsSolid=true IsPositive=true
  Current_3: Current Objects=Np3 Phase=0deg Current=1A IsSolid=true IsPositive=true
  Current_4: Current Objects=Np4 Phase=0deg Current=1A IsSolid=true IsPositive=true
  Current_5: Current Objects=Np5 Phase=0deg Current=1A IsSolid=true IsPositive=true
  Current_6: Current Objects=Np6 Phase=0deg Current=1A IsSolid=true IsPositive=true
  Current_7: Current Objects=Np7 Phase=0deg Current=1A IsSolid=true IsPositive=true
  Current_8: Current Objects=Np8 Phase=0deg Current=1A IsSolid=true IsPositive=true
  Current_9: Current Objects=Ns1 Phase=0deg Current=-1A IsSolid=true IsPositive=true
  Current_10: Current Objects=Ns2 Phase=0deg Current=-1A IsSolid=true IsPositive=true
  Current_11: Current Objects=Ns3 Phase=0deg Current=-1A IsSolid=true IsPositive=true
  Current_12: Current Objects=Ns4 Phase=0deg Current=-1A IsSolid=true IsPositive=true
  Current_13: Current Objects=Ns5 Phase=0deg Current=-1A IsSolid=true IsPositive=true
  Current_14: Current Objects=Ns6 Phase=0deg Current=-1A IsSolid=true IsPositive=true
  Current_15: Current Objects=Ns7 Phase=0deg Current=-1A IsSolid=true IsPositive=true
  Current_16: Current Objects=Ns8 Phase=0deg Current=-1A IsSolid=true IsPositive=true
  eddy effects on: Np1..Np8, Ns1..Ns8
mesh:
  SkinDepth1: SkinDepthLayers Edges=Np1.edge(all 4) Np2.edge(all 4) Np3.edge(all 4) Np4.edge(all 4) Np5.edge(all 4) Np6.edge(all 4) Np7.edge(all 4) Np8.edge(all 4) Ns1.edge(all 4) Ns2.edge(all 4) Ns3.edge(all 4) Ns4.edge(all 4) Ns5.edge(all 4) Ns6.edge(all 4) Ns7.edge(all 4) Ns8.edge(all 4) SkinDepth=0.066085789mm NumLayers=4 NumMaxElem=1000 SurfTriMaxLength=1.3333333mm
setups:
  Setup1: EddyCurrent MaximumPasses=20 MinimumPasses=2 MinimumConvergedPasses=1 PercentRefinement=30 PercentError=1 NonLinearResidual=0.0001 Frequency=100kHz
field plots:
  JAtPhase1: J over Np1..Np8, Ns1..Ns8 on Setup1 : LastAdaptive at Freq=100kHz Phase=45deg

design Flatwise_NoInterleaving (Maxwell 2D, EddyCurrent, XY geometry, model units mm)
options: ModelDepth=1meter
geometry:
  Region [vacuum] = region(percentage_offset: +X=100, -X=0, +Y=100, -Y=100, +Z=0, -Z=0)
  Np1#30839, Np2#30891, Np3#30943, Np4#30995, Np5#31047, Np6#31099, Np7#31151, Np8#31203, Ns1#31255, Ns2#31307, Ns3#31359, Ns4#31411, Ns5#31463, Ns6#31515, Ns7#31567, Ns8#31619, plate_1#31671, plate_2#31723, Body1#31775, Body1_3#31955 = imported_body(C:\Users\karlr\Documents\ICMaSS_sweeping\flatwise_0.1_0.3.step)
  [Np1#30839, Np2#30891, Np3#30943, Np4#30995, Np5#31047, Np6#31099, Np7#31151, Np8#31203, Ns1#31255, Ns2#31307, Ns3#31359, Ns4#31411, Ns5#31463, Ns6#31515, Ns7#31567, Ns8#31619, plate_1#31671, plate_2#31723, Body1#31775, Body1_3#31955].move(-18.3mm, -25.43mm, -9.2833333mm)
  Np1 [copper] = Np1#30839.section(plane=ZX)
  Np1#30839.delete()
  Np1.rotate(axis=X, angle=-90deg)
  Np2 [copper] = Np2#30891.section(plane=ZX)
  Np2#30891.delete()
  Np2.rotate(axis=X, angle=-90deg)
  Np3 [copper] = Np3#30943.section(plane=ZX)
  Np3#30943.delete()
  Np3.rotate(axis=X, angle=-90deg)
  Np4 [copper] = Np4#30995.section(plane=ZX)
  Np4#30995.delete()
  Np4.rotate(axis=X, angle=-90deg)
  Np5 [copper] = Np5#31047.section(plane=ZX)
  Np5#31047.delete()
  Np5.rotate(axis=X, angle=-90deg)
  Np6 [copper] = Np6#31099.section(plane=ZX)
  Np6#31099.delete()
  Np6.rotate(axis=X, angle=-90deg)
  Np7 [copper] = Np7#31151.section(plane=ZX)
  Np7#31151.delete()
  Np7.rotate(axis=X, angle=-90deg)
  Np8 [copper] = Np8#31203.section(plane=ZX)
  Np8#31203.delete()
  Np8.rotate(axis=X, angle=-90deg)
  Ns1 [copper] = Ns1#31255.section(plane=ZX)
  Ns1#31255.delete()
  Ns1.rotate(axis=X, angle=-90deg)
  Ns2 [copper] = Ns2#31307.section(plane=ZX)
  Ns2#31307.delete()
  Ns2.rotate(axis=X, angle=-90deg)
  Ns3 [copper] = Ns3#31359.section(plane=ZX)
  Ns3#31359.delete()
  Ns3.rotate(axis=X, angle=-90deg)
  Ns4 [copper] = Ns4#31411.section(plane=ZX)
  Ns4#31411.delete()
  Ns4.rotate(axis=X, angle=-90deg)
  Ns5 [copper] = Ns5#31463.section(plane=ZX)
  Ns5#31463.delete()
  Ns5.rotate(axis=X, angle=-90deg)
  Ns6 [copper] = Ns6#31515.section(plane=ZX)
  Ns6#31515.delete()
  Ns6.rotate(axis=X, angle=-90deg)
  Ns7 [copper] = Ns7#31567.section(plane=ZX)
  Ns7#31567.delete()
  Ns7.rotate(axis=X, angle=-90deg)
  Ns8 [copper] = Ns8#31619.section(plane=ZX)
  Ns8#31619.delete()
  Ns8.rotate(axis=X, angle=-90deg)
  plate_1 [silicon - Copy] = plate_1#31671.section(plane=ZX)
  plate_1#31671.delete()
  plate_1.rotate(axis=X, angle=-90deg)
  plate_2 [silicon - Copy] = plate_2#31723.section(plane=ZX)
  plate_2#31723.delete()
  plate_2.rotate(axis=X, angle=-90deg)
  Body1 [ferrite - Copy (3)] = Body1#31775.section(plane=ZX)
  Body1#31775.delete()
  Body1.rotate(axis=X, angle=-90deg)
  Body1_3 [ferrite - Copy (3)] = Body1_3#31955.section(plane=ZX)
  Body1_3#31955.delete()
  Body1_3.rotate(axis=X, angle=-90deg)
  [Np1..Np8, Ns1..Ns8, plate_1, plate_2, Body1, Body1_3].split(plane=YZ, keep=PositiveOnly)
  Body1_3.move(0mm, 0mm, -1mm)
  Body1_3.move(0mm, -1mm, 0mm)
  Body1.move(0mm, 1mm, 0mm)
  Body1_3.move(-1.0125234e-13mm, 1mm, 0mm)
  Body1.move(-1.8296475e-13mm, -1mm, 0mm)
  Body1_3.move(0mm, 1mm, 0mm)
  Body1_3.move(0mm, 0mm, 1mm)
  Body1_3.move(0mm, -2mm, 0mm)
  Body1_3.move(0mm, 1mm, 0mm)
  group core_assembled_flatwise = Np1..Np8, Ns1..Ns8, plate_1, plate_2
  group core_together_1 = Body1
  group core_together = Body1_3
boundaries and excitations:
  Balloon1: Balloon Edges=Region.edge(at (18.3, 28.05, 0), at (36.6, 0.05, 0), at (18.3, -27.95, 0))
  Symmetry1: Symmetry Edges=Region.edge(at (0, 0.05, 0)) IsOdd=true
  Current_1: Current Objects=Np1 Phase=0deg Current=1A IsSolid=true IsPositive=true
  Current_2: Current Objects=Np2 Phase=0deg Current=1A IsSolid=true IsPositive=true
  Current_3: Current Objects=Np3 Phase=0deg Current=1A IsSolid=true IsPositive=true
  Current_4: Current Objects=Np4 Phase=0deg Current=1A IsSolid=true IsPositive=true
  Current_5: Current Objects=Ns1 Phase=0deg Current=1A IsSolid=true IsPositive=true
  Current_6: Current Objects=Ns2 Phase=0deg Current=1A IsSolid=true IsPositive=true
  Current_7: Current Objects=Ns3 Phase=0deg Current=1A IsSolid=true IsPositive=true
  Current_8: Current Objects=Ns4 Phase=0deg Current=1A IsSolid=true IsPositive=true
  Current_9: Current Objects=Np5 Phase=0deg Current=-1A IsSolid=true IsPositive=true
  Current_10: Current Objects=Np6 Phase=0deg Current=-1A IsSolid=true IsPositive=true
  Current_11: Current Objects=Np7 Phase=0deg Current=-1A IsSolid=true IsPositive=true
  Current_12: Current Objects=Np8 Phase=0deg Current=-1A IsSolid=true IsPositive=true
  Current_13: Current Objects=Ns5 Phase=0deg Current=-1A IsSolid=true IsPositive=true
  Current_14: Current Objects=Ns6 Phase=0deg Current=-1A IsSolid=true IsPositive=true
  Current_15: Current Objects=Ns7 Phase=0deg Current=-1A IsSolid=true IsPositive=true
  Current_16: Current Objects=Ns8 Phase=0deg Current=-1A IsSolid=true IsPositive=true
mesh:
  SkinDepth1: SkinDepthLayers Edges=Np1.edge(all 4) Np2.edge(all 4) Np3.edge(all 4) Np4.edge(all 4) Np5.edge(all 4) Np6.edge(all 4) Np7.edge(all 4) Np8.edge(all 4) Ns1.edge(all 4) Ns2.edge(all 4) Ns3.edge(all 4) Ns4.edge(all 4) Ns5.edge(all 4) Ns6.edge(all 4) Ns7.edge(all 4) Ns8.edge(all 4) SkinDepth=0.020898162mm NumLayers=2 NumMaxElem=1000 SurfTriMaxLength=1.3333333mm
  Length1: LengthBased Objects=[Body1, Body1_3] MaxLength=0.1
  initial mesh: GlobalSurfApproximation{CurvedSurfaceApproxChoice=UseSlider SliderMeshSettings=9}
setups:
  Setup1: EddyCurrent MaximumPasses=20 MinimumPasses=2 MinimumConvergedPasses=1 PercentRefinement=30 PercentError=0.5 NonLinearResidual=0.0001 Frequency=100kHz
field plots:
  JAtPhase1: J over Np1..Np8, Ns1..Ns8 on Setup1 : LastAdaptive at Freq=100kHz Phase=45deg

design Edgewise1 (Maxwell 2D, EddyCurrent, XY geometry, model units mm)
options: ModelDepth=1meter
geometry:
  Region [vacuum] = region(percentage_offset: +X=100, -X=0, +Y=100, -Y=100, +Z=0, -Z=0)
  Np1#25790, Np2#25842, Np3#25894, Np4#25946, Np5#25998, Np6#26050, Np7#26102, Np8#26154, Ns1#26206, Ns2#26258, Ns3#26310, Ns4#26362, Ns5#26414, Ns6#26466, Ns7#26518, Ns8#26570, Body1#26726, Body1_3#26906 = imported_body(C:\Users\karlr\Documents\ICMaSS_sweeping\edgewise_0.1_0.3.step)
  [Np1#25790, Np2#25842, Np3#25894, Np4#25946, Np5#25998, Np6#26050, Np7#26102, Np8#26154, Ns1#26206, Ns2#26258, Ns3#26310, Ns4#26362, Ns5#26414, Ns6#26466, Ns7#26518, Ns8#26570, Body1#26726, Body1_3#26906].move(-18.666667mm, -25.43mm, -1.6666613e-08mm)
  Np1 [copper] = Np1#25790.section(plane=ZX)
  Np1#25790.delete()
  Np1.rotate(axis=X, angle=-90deg)
  Np2 [copper] = Np2#25842.section(plane=ZX)
  Np2#25842.delete()
  Np2.rotate(axis=X, angle=-90deg)
  Np3 [copper] = Np3#25894.section(plane=ZX)
  Np3#25894.delete()
  Np3.rotate(axis=X, angle=-90deg)
  Np4 [copper] = Np4#25946.section(plane=ZX)
  Np4#25946.delete()
  Np4.rotate(axis=X, angle=-90deg)
  Np5 [copper] = Np5#25998.section(plane=ZX)
  Np5#25998.delete()
  Np5.rotate(axis=X, angle=-90deg)
  Np6 [copper] = Np6#26050.section(plane=ZX)
  Np6#26050.delete()
  Np6.rotate(axis=X, angle=-90deg)
  Np7 [copper] = Np7#26102.section(plane=ZX)
  Np7#26102.delete()
  Np7.rotate(axis=X, angle=-90deg)
  Np8 [copper] = Np8#26154.section(plane=ZX)
  Np8#26154.delete()
  Np8.rotate(axis=X, angle=-90deg)
  Ns1 [copper] = Ns1#26206.section(plane=ZX)
  Ns1#26206.delete()
  Ns1.rotate(axis=X, angle=-90deg)
  Ns2 [copper] = Ns2#26258.section(plane=ZX)
  Ns2#26258.delete()
  Ns2.rotate(axis=X, angle=-90deg)
  Ns3 [copper] = Ns3#26310.section(plane=ZX)
  Ns3#26310.delete()
  Ns3.rotate(axis=X, angle=-90deg)
  Ns4 [copper] = Ns4#26362.section(plane=ZX)
  Ns4#26362.delete()
  Ns4.rotate(axis=X, angle=-90deg)
  Ns5 [copper] = Ns5#26414.section(plane=ZX)
  Ns5#26414.delete()
  Ns5.rotate(axis=X, angle=-90deg)
  Ns6 [copper] = Ns6#26466.section(plane=ZX)
  Ns6#26466.delete()
  Ns6.rotate(axis=X, angle=-90deg)
  Ns7 [copper] = Ns7#26518.section(plane=ZX)
  Ns7#26518.delete()
  Ns7.rotate(axis=X, angle=-90deg)
  Ns8 [copper] = Ns8#26570.section(plane=ZX)
  Ns8#26570.delete()
  Ns8.rotate(axis=X, angle=-90deg)
  Body1 [ferrite - Copy (2)] = Body1#26726.section(plane=ZX)
  Body1#26726.delete()
  Body1.rotate(axis=X, angle=-90deg)
  Body1_3 [ferrite - Copy (2)] = Body1_3#26906.section(plane=ZX)
  Body1_3#26906.delete()
  Body1_3.rotate(axis=X, angle=-90deg)
  [Np1..Np8, Ns1..Ns8, Body1, Body1_3].split(plane=YZ, keep=PositiveOnly)
  group core_assembled_edgewise2 = Np1..Np8, Ns1..Ns8
  group core_together_3 = Body1
  group core_together2 = Body1_3
boundaries and excitations:
  Balloon1: Balloon Edges=Region.edge(at (18.6667, 36.6, 0), at (37.3333, 9.15, 0), at (18.6667, -18.3, 0))
  Symmetry1: Symmetry Edges=Region.edge(at (0, 9.15, 0)) IsOdd=true
  Current_1: Current Objects=Np1 Phase=0deg Current=1A IsSolid=true IsPositive=true
  Current_2: Current Objects=Np2 Phase=0deg Current=1A IsSolid=true IsPositive=true
  Current_3: Current Objects=Np3 Phase=0deg Current=1A IsSolid=true IsPositive=true
  Current_4: Current Objects=Np4 Phase=0deg Current=1A IsSolid=true IsPositive=true
  Current_5: Current Objects=Np5 Phase=0deg Current=1A IsSolid=true IsPositive=true
  Current_6: Current Objects=Np6 Phase=0deg Current=1A IsSolid=true IsPositive=true
  Current_7: Current Objects=Np7 Phase=0deg Current=1A IsSolid=true IsPositive=true
  Current_8: Current Objects=Np8 Phase=0deg Current=1A IsSolid=true IsPositive=true
  Current_9: Current Objects=Ns1 Phase=180deg Current=1A IsSolid=true IsPositive=true
  Current_10: Current Objects=Ns2 Phase=180deg Current=1A IsSolid=true IsPositive=true
  Current_11: Current Objects=Ns3 Phase=180deg Current=1A IsSolid=true IsPositive=true
  Current_12: Current Objects=Ns4 Phase=180deg Current=1A IsSolid=true IsPositive=true
  Current_13: Current Objects=Ns5 Phase=180deg Current=1A IsSolid=true IsPositive=true
  Current_14: Current Objects=Ns6 Phase=180deg Current=1A IsSolid=true IsPositive=true
  Current_15: Current Objects=Ns7 Phase=180deg Current=1A IsSolid=true IsPositive=true
  Current_16: Current Objects=Ns8 Phase=180deg Current=1A IsSolid=true IsPositive=true
  eddy effects on: Np1..Np8, Ns1..Ns8
mesh:
  SkinDepth1: SkinDepthLayers Edges=Np1.edge(all 4) Np2.edge(all 4) Np3.edge(all 4) Np4.edge(all 4) Np5.edge(all 4) Np6.edge(all 4) Np7.edge(all 4) Np8.edge(all 4) Ns1.edge(all 4) Ns2.edge(all 4) Ns3.edge(all 4) Ns4.edge(all 4) Ns5.edge(all 4) Ns6.edge(all 4) Ns7.edge(all 4) Ns8.edge(all 4) SkinDepth=0.05mm NumLayers=4 NumMaxElem=1000 SurfTriMaxLength=1.3333333mm
setups:
  Setup1: EddyCurrent MaximumPasses=20 MinimumPasses=2 MinimumConvergedPasses=1 PercentRefinement=30 PercentError=1 NonLinearResidual=0.0001 Frequency=100kHz
field plots:
  JAtPhase1: J over Np1..Np8, Ns1..Ns8 on Setup1 : LastAdaptive at Freq=100kHz Phase=45deg

design Flatwise1 (Maxwell 2D, EddyCurrent, XY geometry, model units mm)
options: ModelDepth=1meter
geometry:
  Region [vacuum] = region(percentage_offset: +X=100, -X=0, +Y=100, -Y=100, +Z=0, -Z=0)
  Np1#30839, Np2#30891, Np3#30943, Np4#30995, Np5#31047, Np6#31099, Np7#31151, Np8#31203, Ns1#31255, Ns2#31307, Ns3#31359, Ns4#31411, Ns5#31463, Ns6#31515, Ns7#31567, Ns8#31619, Body1#31775, Body1_3#31955 = imported_body(C:\Users\karlr\Documents\ICMaSS_sweeping\flatwise_0.1_0.3.step)
  [Np1#30839, Np2#30891, Np3#30943, Np4#30995, Np5#31047, Np6#31099, Np7#31151, Np8#31203, Ns1#31255, Ns2#31307, Ns3#31359, Ns4#31411, Ns5#31463, Ns6#31515, Ns7#31567, Ns8#31619, Body1#31775, Body1_3#31955].move(-18.3mm, -25.43mm, -9.2833333mm)
  Np1 [copper] = Np1#30839.section(plane=ZX)
  Np1#30839.delete()
  Np1.rotate(axis=X, angle=-90deg)
  Np2 [copper] = Np2#30891.section(plane=ZX)
  Np2#30891.delete()
  Np2.rotate(axis=X, angle=-90deg)
  Np3 [copper] = Np3#30943.section(plane=ZX)
  Np3#30943.delete()
  Np3.rotate(axis=X, angle=-90deg)
  Np4 [copper] = Np4#30995.section(plane=ZX)
  Np4#30995.delete()
  Np4.rotate(axis=X, angle=-90deg)
  Np5 [copper] = Np5#31047.section(plane=ZX)
  Np5#31047.delete()
  Np5.rotate(axis=X, angle=-90deg)
  Np6 [copper] = Np6#31099.section(plane=ZX)
  Np6#31099.delete()
  Np6.rotate(axis=X, angle=-90deg)
  Np7 [copper] = Np7#31151.section(plane=ZX)
  Np7#31151.delete()
  Np7.rotate(axis=X, angle=-90deg)
  Np8 [copper] = Np8#31203.section(plane=ZX)
  Np8#31203.delete()
  Np8.rotate(axis=X, angle=-90deg)
  Ns1 [copper] = Ns1#31255.section(plane=ZX)
  Ns1#31255.delete()
  Ns1.rotate(axis=X, angle=-90deg)
  Ns2 [copper] = Ns2#31307.section(plane=ZX)
  Ns2#31307.delete()
  Ns2.rotate(axis=X, angle=-90deg)
  Ns3 [copper] = Ns3#31359.section(plane=ZX)
  Ns3#31359.delete()
  Ns3.rotate(axis=X, angle=-90deg)
  Ns4 [copper] = Ns4#31411.section(plane=ZX)
  Ns4#31411.delete()
  Ns4.rotate(axis=X, angle=-90deg)
  Ns5 [copper] = Ns5#31463.section(plane=ZX)
  Ns5#31463.delete()
  Ns5.rotate(axis=X, angle=-90deg)
  Ns6 [copper] = Ns6#31515.section(plane=ZX)
  Ns6#31515.delete()
  Ns6.rotate(axis=X, angle=-90deg)
  Ns7 [copper] = Ns7#31567.section(plane=ZX)
  Ns7#31567.delete()
  Ns7.rotate(axis=X, angle=-90deg)
  Ns8 [copper] = Ns8#31619.section(plane=ZX)
  Ns8#31619.delete()
  Ns8.rotate(axis=X, angle=-90deg)
  Body1 [ferrite - Copy (2)] = Body1#31775.section(plane=ZX)
  Body1#31775.delete()
  Body1.rotate(axis=X, angle=-90deg)
  Body1_3 [ferrite - Copy (2)] = Body1_3#31955.section(plane=ZX)
  Body1_3#31955.delete()
  Body1_3.rotate(axis=X, angle=-90deg)
  [Np1..Np8, Ns1..Ns8, Body1, Body1_3].split(plane=YZ, keep=PositiveOnly)
  Body1_3.move(0mm, 0mm, -1mm)
  Body1_3.move(0mm, -1mm, 0mm)
  Body1.move(0mm, 1mm, 0mm)
  Body1_3.move(-1.0125234e-13mm, 1mm, 0mm)
  Body1.move(-1.8296475e-13mm, -1mm, 0mm)
  Body1_3.move(0mm, 1mm, 0mm)
  Body1_3.move(0mm, 0mm, 1mm)
  Body1_3.move(0mm, -2mm, 0mm)
  Body1_3.move(0mm, 1mm, 0mm)
  group core_assembled_flatwise = Np1..Np8, Ns1..Ns8
  group core_together_1 = Body1
  group core_together = Body1_3
boundaries and excitations:
  Balloon1: Balloon Edges=Region.edge(at (18.3, 28.05, 0), at (36.6, 0.05, 0), at (18.3, -27.95, 0))
  Symmetry1: Symmetry Edges=Region.edge(at (0, 0.05, 0)) IsOdd=true
  Current_1: Current Objects=Np1 Phase=0deg Current=1A IsSolid=true IsPositive=true
  Current_2: Current Objects=Np2 Phase=0deg Current=1A IsSolid=true IsPositive=true
  Current_3: Current Objects=Np3 Phase=0deg Current=1A IsSolid=true IsPositive=true
  Current_4: Current Objects=Np4 Phase=0deg Current=1A IsSolid=true IsPositive=true
  Current_5: Current Objects=Np5 Phase=0deg Current=1A IsSolid=true IsPositive=true
  Current_6: Current Objects=Np6 Phase=0deg Current=1A IsSolid=true IsPositive=true
  Current_7: Current Objects=Np7 Phase=0deg Current=1A IsSolid=true IsPositive=true
  Current_8: Current Objects=Np8 Phase=0deg Current=1A IsSolid=true IsPositive=true
  Current_9: Current Objects=Ns1 Phase=180deg Current=1A IsSolid=true IsPositive=true
  Current_10: Current Objects=Ns2 Phase=180deg Current=1A IsSolid=true IsPositive=true
  Current_11: Current Objects=Ns3 Phase=180deg Current=1A IsSolid=true IsPositive=true
  Current_12: Current Objects=Ns4 Phase=180deg Current=1A IsSolid=true IsPositive=true
  Current_13: Current Objects=Ns5 Phase=180deg Current=1A IsSolid=true IsPositive=true
  Current_14: Current Objects=Ns6 Phase=180deg Current=1A IsSolid=true IsPositive=true
  Current_15: Current Objects=Ns7 Phase=180deg Current=1A IsSolid=true IsPositive=true
  Current_16: Current Objects=Ns8 Phase=180deg Current=1A IsSolid=true IsPositive=true
mesh:
  SkinDepth1: SkinDepthLayers Edges=Np1.edge(all 4) Np2.edge(all 4) Np3.edge(all 4) Np4.edge(all 4) Np5.edge(all 4) Np6.edge(all 4) Np7.edge(all 4) Np8.edge(all 4) Ns1.edge(all 4) Ns2.edge(all 4) Ns3.edge(all 4) Ns4.edge(all 4) Ns5.edge(all 4) Ns6.edge(all 4) Ns7.edge(all 4) Ns8.edge(all 4) SkinDepth=0.05mm NumLayers=2 NumMaxElem=1000 SurfTriMaxLength=1.3333333mm
  Length1: LengthBased Objects=[Body1, Body1_3] MaxLength=0.1
  initial mesh: GlobalSurfApproximation{CurvedSurfaceApproxChoice=UseSlider SliderMeshSettings=9}
setups:
  Setup1: EddyCurrent MaximumPasses=20 MinimumPasses=2 MinimumConvergedPasses=1 PercentRefinement=30 PercentError=0.5 NonLinearResidual=0.0001 Frequency=100kHz
field plots:
  JAtPhase1: J over Np1..Np8, Ns1..Ns8 on Setup1 : LastAdaptive at Freq=100kHz Phase=45deg
