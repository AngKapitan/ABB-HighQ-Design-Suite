# Ansys Electronics Desktop project, version 2023.1
materials:
  aluminum: permeability=1.000021 conductivity=38000000 thermal_conductivity=237.5 mass_density=2689 specific_heat=951 youngs_modulus=69000000000 poissons_ratio=0.31 thermal_expansion_coefficient=2.33e-05
  copper: permeability=0.999991 conductivity=58000000 thermal_conductivity=400 mass_density=8933 specific_heat=385 youngs_modulus=120000000000 poissons_ratio=0.38 thermal_expansion_coefficient=1.77e-05
  ferrite - Copy (2): core_loss_curve{25kHz (0, 0) (0.050633, 1) (0.0590114, 1.50406) (0.0691674, 2.34392) (0.0792528, 3.65275) (0.088772, 5.02746) (0.0939521, 6.11121) (0.1, 7.16954) (0.109499, 8.56175) (0.121957, 11.5767) (0.138164, 16.5092) (0.153013, 23.1293) (0.173347, 32.9841) (0.195272, 44.5991) (0.21382, 61.3838) (0.235462, 78.6962) (0.259294, 104.536) (0.280722, 138.862) (0.295422, 151.746)} core_loss_curve{100kHz (0, 0) (0.0263744, 1.03613) (0.0293752, 1.42608) (0.0332788, 2.03369) (0.0396755, 3.1693) (0.0449479, 4.44016) (0.0523856, 6.91954) (0.0628101, 11.373) (0.0753091, 20.068) (0.0882699, 32.4039) (0.103461, 49.6099) (0.118547, 74.6161) (0.142138, 118.363) (0.165658, 191.122) (0.184506, 245.025) (0.1975, 325.48) (0.215037, 409.937) (0.242235, 554.291) (0.26827, 762.898) (0.287163, 911.04)} core_loss_curve{200kHz (0, 0) (0.0153013, 1.07357) (0.0196383, 2.03369) (0.0260769, 4.28533) (0.0305648, 7.42858) (0.0396755, 14.0722) (0.0481134, 22.7224) (0.059347, 38.6962) (0.0757374, 74.6161) (0.0994345, 162.909) (0.110748, 216.401) (0.130546, 319.755) (0.147894, 472.47) (0.164721, 605.722) (0.183462, 848.612) (0.194168, 1013.4) (0.210213, 1167.99) (0.235462, 1607.55) (0.252045, 2024.69) (0.274425, 2333.54) (0.290439, 2939.06)} core_loss_curve{500kHz (0, 0) (0.0101716, 5.89811) (0.01199, 8.71505) (0.0149581, 13.5815) (0.0170423, 18.6929) (0.0202031, 30.1834) (0.0235462, 38.6962) (0.0266752, 55.1837) (0.0309135, 72.0142) (0.0356225, 99.1166) (0.0401281, 129.346) (0.0465037, 187.76) (0.0515018, 236.481) (0.0580159, 319.755) (0.067616, 447.974) (0.0761681, 574.318) (0.0892769, 776.557) (0.101141, 1068.81) (0.1199, 1524.21) (0.142138, 2292.49) (0.174333, 3327.81) (0.199753, 5186.04) (0.22248, 6531.74) (0.249202, 8373.92)} permittivity=12 permeability=3400 conductivity=0.25 thermal_conductivity=4 core_loss_type="Power Ferrite" core_loss_cm=0.062032234 core_loss_x=1.7066326 core_loss_y=2.5354555 mass_density=4800 specific_heat=750 youngs_modulus=119000000000 thermal_expansion_coefficient=1e-05 core_loss_equiv_cut_depth=0.001meter
  silicon - Copy: permittivity=9 thermal_conductivity=148 mass_density=3400 specific_heat=712 youngs_modulus=135000000000 poissons_ratio=0.25 thermal_expansion_coefficient=2.54e-06
  vacuum: permittivity=1
  air: permittivity=1.0006 permeability=1.0000004 thermal_conductivity=0.0261 mass_density=1.1614 specific_heat=1005 thermal_expansion_coefficient=0.00333 thermal_material_type=Fluid diffusivity=2.88e-05 molecular_mass=0.028966 viscosity=1.84e-05 material_refractive_index=1.000293
  Al-Extruded: thermal_conductivity=205 mass_density=2800 specific_heat=900 youngs_modulus=69000000000 poissons_ratio=0.33 thermal_expansion_coefficient=2.277e-06 thermal_material_type=Solid
surface materials:
  Steel-oxidised-surface: surface_emissivity=0.8

design Edgewise_0.1_interleaved_full (Maxwell 3D, EddyCurrent, model units mm)
variables:
  freq_hz = 28500Hz
  volt_ac = 141/28500*Freq
geometry:
  Region [vacuum] = region(percentage_offset=0 on all sides)
  Np1..Np8, Ns1..Ns8 [copper] = imported_body(C:\Users\karlr\Documents\edgewise_0.1_sweep.step)
  plate1, plate2 [silicon - Copy] = imported_body(C:\Users\karlr\Documents\edgewise_0.1_sweep.step)
  Body1 [ferrite - Copy (2)] = imported_body(C:\Users\karlr\Documents\edgewise_0.1_sweep.step)
  Body1_1, Body1_2 [aluminum] = imported_body(C:\Users\karlr\Documents\edgewise_0.1_sweep.step)
  Body1_3 [ferrite - Copy (2)] = imported_body(C:\Users\karlr\Documents\edgewise_0.1_sweep.step)
  Body1_4, Body1_5 [aluminum] = imported_body(C:\Users\karlr\Documents\edgewise_0.1_sweep.step)
  Np1_Section1 = Np1.section(plane=ZX)
  Np2_Section1 [copper] = Np2.section(plane=ZX)
  Np3_Section1 [copper] = Np3.section(plane=ZX)
  Np4_Section1 [copper] = Np4.section(plane=ZX)
  Np5_Section1 [copper] = Np5.section(plane=ZX)
  Np6_Section1 [copper] = Np6.section(plane=ZX)
  Np7_Section1 [copper] = Np7.section(plane=ZX)
  Np8_Section1 [copper] = Np8.section(plane=ZX)
  Ns1_Section1 [copper] = Ns1.section(plane=ZX)
  Ns2_Section1 [copper] = Ns2.section(plane=ZX)
  Ns3_Section1 [copper] = Ns3.section(plane=ZX)
  Ns4_Section1 [copper] = Ns4.section(plane=ZX)
  Ns5_Section1 [copper] = Ns5.section(plane=ZX)
  Ns6_Section1 [copper] = Ns6.section(plane=ZX)
  Ns7_Section1 [copper] = Ns7.section(plane=ZX)
  Ns8_Section1 = Ns8.section(plane=ZX)
  Np1_Section1_Separate1 [copper] = Np1_Section1.separate_bodies()
  Np1_Section1.delete()
  Np2_Section1.separate_bodies()
  Np3_Section1.separate_bodies()
  Np4_Section1.separate_bodies()
  Np5_Section1.separate_bodies()
  Np6_Section1.separate_bodies()
  Np7_Section1.separate_bodies()
  Np8_Section1.separate_bodies()
  Ns1_Section1.separate_bodies()
  Ns2_Section1.separate_bodies()
  Ns3_Section1.separate_bodies()
  Ns4_Section1.separate_bodies()
  Ns5_Section1.separate_bodies()
  Ns6_Section1.separate_bodies()
  Ns7_Section1.separate_bodies()
  Ns8_Section1_Separate1 [copper] = Ns8_Section1.separate_bodies()
  Ns8_Section1.delete()
  group core_assembled_edgewise = Np1..Np8, Ns1..Ns8, plate1, plate2, Np2_Section1, Np3_Section1, Np4_Section1, Np5_Section1, Np6_Section1, Np7_Section1, Np8_Section1, Ns1_Section1, Ns2_Section1, Ns3_Section1, Ns4_Section1, Ns5_Section1, Ns6_Section1, Ns7_Section1, Np1_Section1_Separate1, Ns8_Section1_Separate1
  group core_together_1 = Body1, Body1_1, Body1_2
  group core_together = Body1_3, Body1_4, Body1_5
boundaries and excitations:
  Np_1: Coil Terminal Objects=Np1_Section1_Separate1 Conductor_number=1 Winding=Np Point_out_of_terminal=false
  Np_2: Coil Terminal Objects=Np2_Section1 Conductor_number=1 Winding=Np Point_out_of_terminal=false
  Np_3: Coil Terminal Objects=Np3_Section1 Conductor_number=1 Winding=Np Point_out_of_terminal=false
  Np_4: Coil Terminal Objects=Np4_Section1 Conductor_number=1 Winding=Np Point_out_of_terminal=false
  Np_5: Coil Terminal Objects=Np5_Section1 Conductor_number=1 Winding=Np Point_out_of_terminal=false
  Np_6: Coil Terminal Objects=Np6_Section1 Conductor_number=1 Winding=Np Point_out_of_terminal=false
  Np_7: Coil Terminal Objects=Np7_Section1 Conductor_number=1 Winding=Np Point_out_of_terminal=false
  Np_8: Coil Terminal Objects=Np8_Section1 Conductor_number=1 Winding=Np Point_out_of_terminal=false
  Ns_1: Coil Terminal Objects=Ns1_Section1 Conductor_number=1 Winding=Ns Point_out_of_terminal=true
  Ns_2: Coil Terminal Objects=Ns2_Section1 Conductor_number=1 Winding=Ns Point_out_of_terminal=true
  Ns_3: Coil Terminal Objects=Ns3_Section1 Conductor_number=1 Winding=Ns Point_out_of_terminal=true
  Ns_4: Coil Terminal Objects=Ns4_Section1 Conductor_number=1 Winding=Ns Point_out_of_terminal=true
  Ns_5: Coil Terminal Objects=Ns5_Section1 Conductor_number=1 Winding=Ns Point_out_of_terminal=true
  Ns_6: Coil Terminal Objects=Ns6_Section1 Conductor_number=1 Winding=Ns Point_out_of_terminal=true
  Ns_7: Coil Terminal Objects=Ns7_Section1 Conductor_number=1 Winding=Ns Point_out_of_terminal=true
  Ns_8: Coil Terminal Objects=Ns8_Section1_Separate1 Conductor_number=1 Winding=Ns Point_out_of_terminal=true
  Np: Winding Group Type=Voltage IsSolid=true Current=16.36A Resistance=0ohm Inductance=0nH Voltage=volt_ac ParallelBranchesNum=1 Phase=0rad
  Ns: Winding Group Type=Current IsSolid=true Current=1000*1.41/volt_ac*1.414 ParallelBranchesNum=1 Phase=0.1522rad
  core loss on: Body1, Body1_3
parameters:
  Matrix1: Matrix Np, Ns:
mesh:
  Length1: LengthBased Objects=[Np1..Np8, Ns1..Ns8, plate1, plate2] MaxLength=2mm
  Length2: LengthBased Objects=[Body1, Body1_1..Body1_5] MaxLength=5mm
  initial mesh: GlobalSurfApproximation{CurvedSurfaceApproxChoice=UseSlider SliderMeshSettings=9} GlobalCurvilinear{Apply}
setups:
  Setup1: EddyCurrent MaximumPasses=20 MinimumPasses=2 MinimumConvergedPasses=1 PercentRefinement=30 PercentError=1 NonLinearResidual=0.0001 SmoothBHCurve Frequency=28.5kHz SweepRanges{0.1Hz to 1Hz, log, 10 per decade 1Hz to 1000Hz, log, 10 per decade 1000Hz to 10000Hz, log, 10 per decade 10000Hz to 100000Hz, log, 10 per decade 100000Hz to 1000000Hz, log, 10 per decade 1000000Hz to 10000000Hz, log, 10 per decade} SaveAllFields

design Edgewise_0.2_interleaved_full (Maxwell 3D, EddyCurrent, model units mm)
variables:
  freq_hz = 28500Hz
  volt_ac = 141/28500*Freq
geometry:
  Region [vacuum] = region(percentage_offset=0 on all sides)
  Np1..Np8, Ns1..Ns8 [copper] = imported_body(C:\Users\karlr\Documents\edgewise_0.2_sweep.step)
  plate1, plate2 [silicon - Copy] = imported_body(C:\Users\karlr\Documents\edgewise_0.2_sweep.step)
  Body1 [ferrite - Copy (2)] = imported_body(C:\Users\karlr\Documents\edgewise_0.2_sweep.step)
  Body1_1, Body1_2 [aluminum] = imported_body(C:\Users\karlr\Documents\edgewise_0.2_sweep.step)
  Body1_3 [ferrite - Copy (2)] = imported_body(C:\Users\karlr\Documents\edgewise_0.2_sweep.step)
  Body1_4, Body1_5 [aluminum] = imported_body(C:\Users\karlr\Documents\edgewise_0.2_sweep.step)
  Ns8_Section1 = Ns8.section(plane=ZX)
  Np1_Section1 = Np1.section(plane=ZX)
  Np2_Section1 [copper] = Np2.section(plane=ZX)
  Np3_Section1 [copper] = Np3.section(plane=ZX)
  Np4_Section1 [copper] = Np4.section(plane=ZX)
  Np5_Section1 [copper] = Np5.section(plane=ZX)
  Np6_Section1 [copper] = Np6.section(plane=ZX)
  Np7_Section1 [copper] = Np7.section(plane=ZX)
  Np8_Section1 [copper] = Np8.section(plane=ZX)
  Ns1_Section1 [copper] = Ns1.section(plane=ZX)
  Ns2_Section1 [copper] = Ns2.section(plane=ZX)
  Ns3_Section1 [copper] = Ns3.section(plane=ZX)
  Ns4_Section1 [copper] = Ns4.section(plane=ZX)
  Ns5_Section1 [copper] = Ns5.section(plane=ZX)
  Ns6_Section1 [copper] = Ns6.section(plane=ZX)
  Ns7_Section1 [copper] = Ns7.section(plane=ZX)
  Ns8_Section1_Separate1 [copper] = Ns8_Section1.separate_bodies()
  Ns8_Section1.delete()
  Np1_Section1_Separate1 [copper] = Np1_Section1.separate_bodies()
  Np1_Section1.delete()
  Np2_Section1.separate_bodies()
  Np3_Section1.separate_bodies()
  Np4_Section1.separate_bodies()
  Np5_Section1.separate_bodies()
  Np6_Section1.separate_bodies()
  Np7_Section1.separate_bodies()
  Np8_Section1.separate_bodies()
  Ns1_Section1.separate_bodies()
  Ns2_Section1.separate_bodies()
  Ns3_Section1.separate_bodies()
  Ns4_Section1.separate_bodies()
  Ns5_Section1.separate_bodies()
  Ns6_Section1.separate_bodies()
  Ns7_Section1.separate_bodies()
  group core_assembled_edgewise = Np1..Np8, Ns1..Ns8, plate1, plate2, Np2_Section1, Np3_Section1, Np4_Section1, Np5_Section1, Np6_Section1, Np7_Section1, Np8_Section1, Ns1_Section1, Ns2_Section1, Ns3_Section1, Ns4_Section1, Ns5_Section1, Ns6_Section1, Ns7_Section1, Ns8_Section1_Separate1, Np1_Section1_Separate1
  group core_together_1 = Body1, Body1_1, Body1_2
  group core_together = Body1_3, Body1_4, Body1_5
boundaries and excitations:
  Np_1: Coil Terminal Objects=Np1_Section1_Separate1 Conductor_number=1 Winding=Np Point_out_of_terminal=false
  Np_2: Coil Terminal Objects=Np2_Section1 Conductor_number=1 Winding=Np Point_out_of_terminal=false
  Np_3: Coil Terminal Objects=Np3_Section1 Conductor_number=1 Winding=Np Point_out_of_terminal=false
  Np_4: Coil Terminal Objects=Np4_Section1 Conductor_number=1 Winding=Np Point_out_of_terminal=false
  Np_5: Coil Terminal Objects=Np5_Section1 Conductor_number=1 Winding=Np Point_out_of_terminal=false
  Np_6: Coil Terminal Objects=Np6_Section1 Conductor_number=1 Winding=Np Point_out_of_terminal=false
  Np_7: Coil Terminal Objects=Np7_Section1 Conductor_number=1 Winding=Np Point_out_of_terminal=false
  Np_8: Coil Terminal Objects=Np8_Section1 Conductor_number=1 Winding=Np Point_out_of_terminal=false
  Ns_1: Coil Terminal Objects=Ns1_Section1 Conductor_number=1 Winding=Ns Point_out_of_terminal=true
  Ns_2: Coil Terminal Objects=Ns2_Section1 Conductor_number=1 Winding=Ns Point_out_of_terminal=true
  Ns_3: Coil Terminal Objects=Ns3_Section1 Conductor_number=1 Winding=Ns Point_out_of_terminal=true
  Ns_4: Coil Terminal Objects=Ns4_Section1 Conductor_number=1 Winding=Ns Point_out_of_terminal=true
  Ns_5: Coil Terminal Objects=Ns5_Section1 Conductor_number=1 Winding=Ns Point_out_of_terminal=true
  Ns_6: Coil Terminal Objects=Ns6_Section1 Conductor_number=1 Winding=Ns Point_out_of_terminal=true
  Ns_7: Coil Terminal Objects=Ns7_Section1 Conductor_number=1 Winding=Ns Point_out_of_terminal=true
  Ns_8: Coil Terminal Objects=Ns8_Section1_Separate1 Conductor_number=1 Winding=Ns Point_out_of_terminal=true
  Np: Winding Group Type=Voltage IsSolid=true Current=16.36A Resistance=0ohm Inductance=0nH Voltage=volt_ac ParallelBranchesNum=1 Phase=0rad
  Ns: Winding Group Type=Current IsSolid=true Current=1000*1.41/volt_ac*1.414 ParallelBranchesNum=1 Phase=0.1522rad
  core loss on: Body1, Body1_3
parameters:
  Matrix1: Matrix Np, Ns:
mesh:
  Length1: LengthBased Objects=[Np1..Np8, Ns1..Ns8, plate1, plate2] MaxLength=2mm
  Length2: LengthBased Objects=[Body1, Body1_1..Body1_5] MaxLength=5mm
  initial mesh: GlobalSurfApproximation{CurvedSurfaceApproxChoice=UseSlider SliderMeshSettings=9} GlobalCurvilinear{Apply}
setups:
  Setup1: EddyCurrent MaximumPasses=20 MinimumPasses=2 MinimumConvergedPasses=1 PercentRefinement=30 PercentError=1 NonLinearResidual=0.0001 SmoothBHCurve Frequency=28.5kHz SweepRanges{0.1Hz to 1Hz, log, 10 per decade 1Hz to 1000Hz, log, 10 per decade 1000Hz to 10000Hz, log, 10 per decade 10000Hz to 100000Hz, log, 10 per decade 100000Hz to 1000000Hz, log, 10 per decade 1000000Hz to 10000000Hz, log, 10 per decade} SaveAllFields

design Edgewise_0.3_interleaved_full (Maxwell 3D, EddyCurrent, model units mm)
variables:
  freq_hz = 28500Hz
  volt_ac = 141/28500*Freq
geometry:
  Region [vacuum] = region(percentage_offset=0 on all sides)
  Np1..Np8, Ns1..Ns8 [copper] = imported_body(C:\Users\karlr\Documents\edgewise_0.3_sweep.step)
  plate1, plate2 [silicon - Copy] = imported_body(C:\Users\karlr\Documents\edgewise_0.3_sweep.step)
  Body1 [ferrite - Copy (2)] = imported_body(C:\Users\karlr\Documents\edgewise_0.3_sweep.step)
  Body1_1, Body1_2 [aluminum] = imported_body(C:\Users\karlr\Documents\edgewise_0.3_sweep.step)
  Body1_3 [ferrite - Copy (2)] = imported_body(C:\Users\karlr\Documents\edgewise_0.3_sweep.step)
  Body1_4, Body1_5 [aluminum] = imported_body(C:\Users\karlr\Documents\edgewise_0.3_sweep.step)
  Np1_Section1 = Np1.section(plane=ZX)
  Np2_Section1 [copper] = Np2.section(plane=ZX)
  Np3_Section1 [copper] = Np3.section(plane=ZX)
  Np4_Section1 [copper] = Np4.section(plane=ZX)
  Np5_Section1 [copper] = Np5.section(plane=ZX)
  Np6_Section1 [copper] = Np6.section(plane=ZX)
  Np7_Section1 [copper] = Np7.section(plane=ZX)
  Np8_Section1 [copper] = Np8.section(plane=ZX)
  Ns1_Section1 [copper] = Ns1.section(plane=ZX)
  Ns2_Section1 [copper] = Ns2.section(plane=ZX)
  Ns3_Section1 [copper] = Ns3.section(plane=ZX)
  Ns4_Section1 [copper] = Ns4.section(plane=ZX)
  Ns5_Section1 [copper] = Ns5.section(plane=ZX)
  Ns6_Section1 [copper] = Ns6.section(plane=ZX)
  Ns7_Section1 [copper] = Ns7.section(plane=ZX)
  Ns8_Section1 = Ns8.section(plane=ZX)
  Np1_Section1_Separate1 [copper] = Np1_Section1.separate_bodies()
  Np1_Section1.delete()
  Np2_Section1.separate_bodies()
  Np3_Section1.separate_bodies()
  Np4_Section1.separate_bodies()
  Np5_Section1.separate_bodies()
  Np6_Section1.separate_bodies()
  Np7_Section1.separate_bodies()
  Np8_Section1.separate_bodies()
  Ns1_Section1.separate_bodies()
  Ns2_Section1.separate_bodies()
  Ns3_Section1.separate_bodies()
  Ns4_Section1.separate_bodies()
  Ns5_Section1.separate_bodies()
  Ns6_Section1.separate_bodies()
  Ns7_Section1.separate_bodies()
  Ns8_Section1_Separate1 [copper] = Ns8_Section1.separate_bodies()
  Ns8_Section1.delete()
  group core_assembled_edgewise1 = Np1..Np8, Ns1..Ns8, plate1, plate2, Np2_Section1, Np3_Section1, Np4_Section1, Np5_Section1, Np6_Section1, Np7_Section1, Np8_Section1, Ns1_Section1, Ns2_Section1, Ns3_Section1, Ns4_Section1, Ns5_Section1, Ns6_Section1, Ns7_Section1, Np1_Section1_Separate1, Ns8_Section1_Separate1
  group core_together_2 = Body1, Body1_1, Body1_2
  group core_together1 = Body1_3, Body1_4, Body1_5
boundaries and excitations:
  Ns_1: Coil Terminal Objects=Ns8_Section1_Separate1 Conductor_number=1 Winding=Ns Point_out_of_terminal=true
  Ns_2: Coil Terminal Objects=Ns1_Section1 Conductor_number=1 Winding=Ns Point_out_of_terminal=true
  Ns_3: Coil Terminal Objects=Ns2_Section1 Conductor_number=1 Winding=Ns Point_out_of_terminal=true
  Ns_4: Coil Terminal Objects=Ns3_Section1 Conductor_number=1 Winding=Ns Point_out_of_terminal=true
  Ns_5: Coil Terminal Objects=Ns4_Section1 Conductor_number=1 Winding=Ns Point_out_of_terminal=true
  Ns_6: Coil Terminal Objects=Ns5_Section1 Conductor_number=1 Winding=Ns Point_out_of_terminal=true
  Ns_7: Coil Terminal Objects=Ns6_Section1 Conductor_number=1 Winding=Ns Point_out_of_terminal=true
  Ns_8: Coil Terminal Objects=Ns7_Section1 Conductor_number=1 Winding=Ns Point_out_of_terminal=true
  Np_1: Coil Terminal Objects=Np1_Section1_Separate1 Conductor_number=1 Winding=Np Point_out_of_terminal=false
  Np_2: Coil Terminal Objects=Np2_Section1 Conductor_number=1 Winding=Np Point_out_of_terminal=false
  Np_3: Coil Terminal Objects=Np3_Section1 Conductor_number=1 Winding=Np Point_out_of_terminal=false
  Np_4: Coil Terminal Objects=Np4_Section1 Conductor_number=1 Winding=Np Point_out_of_terminal=false
  Np_5: Coil Terminal Objects=Np5_Section1 Conductor_number=1 Winding=Np Point_out_of_terminal=false
  Np_6: Coil Terminal Objects=Np6_Section1 Conductor_number=1 Winding=Np Point_out_of_terminal=false
  Np_7: Coil Terminal Objects=Np7_Section1 Conductor_number=1 Winding=Np Point_out_of_terminal=false
  Np_8: Coil Terminal Objects=Np8_Section1 Conductor_number=1 Winding=Np Point_out_of_terminal=false
  Np: Winding Group Type=Voltage IsSolid=true Current=16.36A Resistance=0ohm Inductance=0nH Voltage=volt_ac ParallelBranchesNum=1 Phase=0rad
  Ns: Winding Group Type=Current IsSolid=true Current=1000*1.41/volt_ac*1.414 ParallelBranchesNum=1 Phase=0.1522rad
  core loss on: Body1, Body1_3
parameters:
  Matrix1: Matrix Np, Ns:
mesh:
  Length1: LengthBased Objects=[Np1..Np8, Ns1..Ns8, plate1, plate2] MaxLength=2mm
  Length2: LengthBased Objects=[Body1, Body1_1..Body1_5] MaxLength=5mm
  initial mesh: GlobalSurfApproximation{CurvedSurfaceApproxChoice=UseSlider SliderMeshSettings=9} GlobalCurvilinear{Apply}
setups:
  Setup1: EddyCurrent MaximumPasses=20 MinimumPasses=2 MinimumConvergedPasses=1 PercentRefinement=30 PercentError=1 NonLinearResidual=0.0001 SmoothBHCurve Frequency=28.5kHz SweepRanges{0.1Hz to 1Hz, log, 10 per decade 1Hz to 1000Hz, log, 10 per decade 1000Hz to 10000Hz, log, 10 per decade 10000Hz to 100000Hz, log, 10 per decade 100000Hz to 1000000Hz, log, 10 per decade 1000000Hz to 10000000Hz, log, 10 per decade} SaveAllFields

design Edgewise_0.4_interleaved_full (Maxwell 3D, EddyCurrent, model units mm)
variables:
  freq_hz = 28500Hz
  volt_ac = 141/28500*Freq
geometry:
  Region [vacuum] = region(percentage_offset=0 on all sides)
  Np1..Np8, Ns1..Ns8 [copper] = imported_body(C:\Users\karlr\Documents\edgewise_0.4_sweep.step)
  plate1, plate2 [silicon - Copy] = imported_body(C:\Users\karlr\Documents\edgewise_0.4_sweep.step)
  Body1 [ferrite - Copy (2)] = imported_body(C:\Users\karlr\Documents\edgewise_0.4_sweep.step)
  Body1_1, Body1_2 [aluminum] = imported_body(C:\Users\karlr\Documents\edgewise_0.4_sweep.step)
  Body1_3 [ferrite - Copy (2)] = imported_body(C:\Users\karlr\Documents\edgewise_0.4_sweep.step)
  Body1_4, Body1_5 [aluminum] = imported_body(C:\Users\karlr\Documents\edgewise_0.4_sweep.step)
  Np1_Section1 = Np1.section(plane=ZX)
  Np2_Section1 [copper] = Np2.section(plane=ZX)
  Np3_Section1 [copper] = Np3.section(plane=ZX)
  Np4_Section1 [copper] = Np4.section(plane=ZX)
  Np5_Section1 [copper] = Np5.section(plane=ZX)
  Np6_Section1 [copper] = Np6.section(plane=ZX)
  Np7_Section1 [copper] = Np7.section(plane=ZX)
  Np8_Section1 [copper] = Np8.section(plane=ZX)
  Ns1_Section1 [copper] = Ns1.section(plane=ZX)
  Ns2_Section1 [copper] = Ns2.section(plane=ZX)
  Ns3_Section1 [copper] = Ns3.section(plane=ZX)
  Ns4_Section1 [copper] = Ns4.section(plane=ZX)
  Ns5_Section1 [copper] = Ns5.section(plane=ZX)
  Ns6_Section1 [copper] = Ns6.section(plane=ZX)
  Ns7_Section1 [copper] = Ns7.section(plane=ZX)
  Ns8_Section1 = Ns8.section(plane=ZX)
  Np1_Section1_Separate1 [copper] = Np1_Section1.separate_bodies()
  Np1_Section1.delete()
  Np2_Section1.separate_bodies()
  Np3_Section1.separate_bodies()
  Np4_Section1.separate_bodies()
  Np5_Section1.separate_bodies()
  Np6_Section1.separate_bodies()
  Np7_Section1.separate_bodies()
  Np8_Section1.separate_bodies()
  Ns1_Section1.separate_bodies()
  Ns2_Section1.separate_bodies()
  Ns3_Section1.separate_bodies()
  Ns4_Section1.separate_bodies()
  Ns5_Section1.separate_bodies()
  Ns6_Section1.separate_bodies()
  Ns7_Section1.separate_bodies()
  Ns8_Section1_Separate1 [copper] = Ns8_Section1.separate_bodies()
  Ns8_Section1.delete()
  group core_assembled_edgewise1 = Np1..Np8, Ns1..Ns8, plate1, plate2, Np2_Section1, Np3_Section1, Np4_Section1, Np5_Section1, Np6_Section1, Np7_Section1, Np8_Section1, Ns1_Section1, Ns2_Section1, Ns3_Section1, Ns4_Section1, Ns5_Section1, Ns6_Section1, Ns7_Section1, Np1_Section1_Separate1, Ns8_Section1_Separate1
  group core_together_2 = Body1, Body1_1, Body1_2
  group core_together1 = Body1_3, Body1_4, Body1_5
boundaries and excitations:
  Np_1: Coil Terminal Objects=Np1_Section1_Separate1 Conductor_number=1 Winding=Np Point_out_of_terminal=false
  Np_2: Coil Terminal Objects=Np2_Section1 Conductor_number=1 Winding=Np Point_out_of_terminal=false
  Np_3: Coil Terminal Objects=Np3_Section1 Conductor_number=1 Winding=Np Point_out_of_terminal=false
  Np_4: Coil Terminal Objects=Np4_Section1 Conductor_number=1 Winding=Np Point_out_of_terminal=false
  Np_5: Coil Terminal Objects=Np5_Section1 Conductor_number=1 Winding=Np Point_out_of_terminal=false
  Np_6: Coil Terminal Objects=Np6_Section1 Conductor_number=1 Winding=Np Point_out_of_terminal=false
  Np_7: Coil Terminal Objects=Np7_Section1 Conductor_number=1 Winding=Np Point_out_of_terminal=false
  Np_8: Coil Terminal Objects=Np8_Section1 Conductor_number=1 Winding=Np Point_out_of_terminal=false
  Ns_1: Coil Terminal Objects=Ns1_Section1 Conductor_number=1 Winding=Ns Point_out_of_terminal=true
  Ns_2: Coil Terminal Objects=Ns2_Section1 Conductor_number=1 Winding=Ns Point_out_of_terminal=true
  Ns_3: Coil Terminal Objects=Ns3_Section1 Conductor_number=1 Winding=Ns Point_out_of_terminal=true
  Ns_4: Coil Terminal Objects=Ns4_Section1 Conductor_number=1 Winding=Ns Point_out_of_terminal=true
  Ns_5: Coil Terminal Objects=Ns5_Section1 Conductor_number=1 Winding=Ns Point_out_of_terminal=true
  Ns_6: Coil Terminal Objects=Ns6_Section1 Conductor_number=1 Winding=Ns Point_out_of_terminal=true
  Ns_7: Coil Terminal Objects=Ns7_Section1 Conductor_number=1 Winding=Ns Point_out_of_terminal=true
  Ns_8: Coil Terminal Objects=Ns8_Section1_Separate1 Conductor_number=1 Winding=Ns Point_out_of_terminal=true
  Np: Winding Group Type=Voltage IsSolid=true Current=16.36A Resistance=0ohm Inductance=0nH Voltage=volt_ac ParallelBranchesNum=1 Phase=0rad
  Ns: Winding Group Type=Current IsSolid=true Current=1000*1.41/volt_ac*1.414 ParallelBranchesNum=1 Phase=0.1522rad
  core loss on: Body1, Body1_3
parameters:
  Matrix1: Matrix Np, Ns:
mesh:
  Length1: LengthBased Objects=[Np1..Np8, Ns1..Ns8, plate1, plate2] MaxLength=2mm
  Length2: LengthBased Objects=[Body1, Body1_1..Body1_5] MaxLength=5mm
  initial mesh: GlobalSurfApproximation{CurvedSurfaceApproxChoice=UseSlider SliderMeshSettings=9} GlobalCurvilinear{Apply}
setups:
  Setup1: EddyCurrent MaximumPasses=20 MinimumPasses=2 MinimumConvergedPasses=1 PercentRefinement=30 PercentError=1 NonLinearResidual=0.0001 SmoothBHCurve Frequency=28.5kHz SweepRanges{0.1Hz to 1Hz, log, 10 per decade 1Hz to 1000Hz, log, 10 per decade 1000Hz to 10000Hz, log, 10 per decade 10000Hz to 100000Hz, log, 10 per decade 100000Hz to 1000000Hz, log, 10 per decade 1000000Hz to 10000000Hz, log, 10 per decade} SaveAllFields

design Edgewise_0.5_interleaved_full (Maxwell 3D, EddyCurrent, model units mm)
variables:
  freq_hz = 28500Hz
  volt_ac = 141/28500*Freq
geometry:
  Region [vacuum] = region(percentage_offset=0 on all sides)
  Np1..Np8, Ns1..Ns8 [copper] = imported_body(C:\Users\karlr\Documents\edgewise_0.5_sweep.step)
  plate1, plate2 [silicon - Copy] = imported_body(C:\Users\karlr\Documents\edgewise_0.5_sweep.step)
  Body1 [ferrite - Copy (2)] = imported_body(C:\Users\karlr\Documents\edgewise_0.5_sweep.step)
  Body1_1, Body1_2 [aluminum] = imported_body(C:\Users\karlr\Documents\edgewise_0.5_sweep.step)
  Body1_3 [ferrite - Copy (2)] = imported_body(C:\Users\karlr\Documents\edgewise_0.5_sweep.step)
  Body1_4, Body1_5 [aluminum] = imported_body(C:\Users\karlr\Documents\edgewise_0.5_sweep.step)
  Np1_Section1 = Np1.section(plane=ZX)
  Np2_Section1 [copper] = Np2.section(plane=ZX)
  Np3_Section1 [copper] = Np3.section(plane=ZX)
  Np4_Section1 [copper] = Np4.section(plane=ZX)
  Np5_Section1 [copper] = Np5.section(plane=ZX)
  Np6_Section1 [copper] = Np6.section(plane=ZX)
  Np7_Section1 [copper] = Np7.section(plane=ZX)
  Np8_Section1 [copper] = Np8.section(plane=ZX)
  Ns1_Section1 [copper] = Ns1.section(plane=ZX)
  Ns2_Section1 [copper] = Ns2.section(plane=ZX)
  Ns3_Section1 [copper] = Ns3.section(plane=ZX)
  Ns4_Section1 [copper] = Ns4.section(plane=ZX)
  Ns5_Section1 [copper] = Ns5.section(plane=ZX)
  Ns6_Section1 [copper] = Ns6.section(plane=ZX)
  Ns7_Section1 [copper] = Ns7.section(plane=ZX)
  Ns8_Section1 = Ns8.section(plane=ZX)
  Np1_Section1_Separate1 [copper] = Np1_Section1.separate_bodies()
  Np1_Section1.delete()
  Np2_Section1.separate_bodies()
  Np3_Section1.separate_bodies()
  Np4_Section1.separate_bodies()
  Np5_Section1.separate_bodies()
  Np6_Section1.separate_bodies()
  Np7_Section1.separate_bodies()
  Np8_Section1.separate_bodies()
  Ns1_Section1.separate_bodies()
  Ns2_Section1.separate_bodies()
  Ns3_Section1.separate_bodies()
  Ns4_Section1.separate_bodies()
  Ns5_Section1.separate_bodies()
  Ns6_Section1.separate_bodies()
  Ns7_Section1.separate_bodies()
  Ns8_Section1_Separate1 [copper] = Ns8_Section1.separate_bodies()
  Ns8_Section1.delete()
  group core_assembled_edgewise1 = Np1..Np8, Ns1..Ns8, plate1, plate2, Np2_Section1, Np3_Section1, Np4_Section1, Np5_Section1, Np6_Section1, Np7_Section1, Np8_Section1, Ns1_Section1, Ns2_Section1, Ns3_Section1, Ns4_Section1, Ns5_Section1, Ns6_Section1, Ns7_Section1, Np1_Section1_Separate1, Ns8_Section1_Separate1
  group core_together_2 = Body1, Body1_1, Body1_2
  group core_together1 = Body1_3, Body1_4, Body1_5
boundaries and excitations:
  Np_1: Coil Terminal Objects=Np1_Section1_Separate1 Conductor_number=1 Winding=Np Point_out_of_terminal=false
  Np_2: Coil Terminal Objects=Np2_Section1 Conductor_number=1 Winding=Np Point_out_of_terminal=false
  Np_3: Coil Terminal Objects=Np3_Section1 Conductor_number=1 Winding=Np Point_out_of_terminal=false
  Np_4: Coil Terminal Objects=Np4_Section1 Conductor_number=1 Winding=Np Point_out_of_terminal=false
  Np_5: Coil Terminal Objects=Np5_Section1 Conductor_number=1 Winding=Np Point_out_of_terminal=false
  Np_6: Coil Terminal Objects=Np6_Section1 Conductor_number=1 Winding=Np Point_out_of_terminal=false
  Np_7: Coil Terminal Objects=Np7_Section1 Conductor_number=1 Winding=Np Point_out_of_terminal=false
  Np_8: Coil Terminal Objects=Np8_Section1 Conductor_number=1 Winding=Np Point_out_of_terminal=false
  Ns_1: Coil Terminal Objects=Ns1_Section1 Conductor_number=1 Winding=Ns Point_out_of_terminal=true
  Ns_2: Coil Terminal Objects=Ns2_Section1 Conductor_number=1 Winding=Ns Point_out_of_terminal=true
  Ns_3: Coil Terminal Objects=Ns3_Section1 Conductor_number=1 Winding=Ns Point_out_of_terminal=true
  Ns_4: Coil Terminal Objects=Ns4_Section1 Conductor_number=1 Winding=Ns Point_out_of_terminal=true
  Ns_5: Coil Terminal Objects=Ns5_Section1 Conductor_number=1 Winding=Ns Point_out_of_terminal=true
  Ns_6: Coil Terminal Objects=Ns6_Section1 Conductor_number=1 Winding=Ns Point_out_of_terminal=true
  Ns_7: Coil Terminal Objects=Ns7_Section1 Conductor_number=1 Winding=Ns Point_out_of_terminal=true
  Ns_8: Coil Terminal Objects=Ns8_Section1_Separate1 Conductor_number=1 Winding=Ns Point_out_of_terminal=true
  Np: Winding Group Type=Voltage IsSolid=true Current=16.36A Resistance=0ohm Inductance=0nH Voltage=volt_ac ParallelBranchesNum=1 Phase=0rad
  Ns: Winding Group Type=Current IsSolid=true Current=1000*1.41/volt_ac*1.414 ParallelBranchesNum=1 Phase=0.1522rad
  eddy effects on: Np1..Np8, Ns1..Ns8, Body1_1, Body1_2, Body1_4, Body1_5
  core loss on: Body1, Body1_3
parameters:
  Matrix1: Matrix Np, Ns:
mesh:
  Length1: LengthBased Objects=[Np1..Np8, Ns1..Ns8, plate1, plate2] MaxLength=2mm
  Length2: LengthBased Objects=[Body1, Body1_1..Body1_5] MaxLength=5mm
  initial mesh: GlobalSurfApproximation{CurvedSurfaceApproxChoice=UseSlider SliderMeshSettings=9} GlobalCurvilinear{Apply}
setups:
  Setup1: EddyCurrent MaximumPasses=20 MinimumPasses=2 MinimumConvergedPasses=1 PercentRefinement=30 PercentError=1 NonLinearResidual=0.0001 SmoothBHCurve Frequency=28.5kHz SweepRanges{0.1Hz to 1Hz, log, 10 per decade 1Hz to 1000Hz, log, 10 per decade 1000Hz to 10000Hz, log, 10 per decade 10000Hz to 100000Hz, log, 10 per decade 100000Hz to 1000000Hz, log, 10 per decade 1000000Hz to 10000000Hz, log, 10 per decade} SaveAllFields

design [Thermal]Edgewise_0.5 (Icepak, SteadyState TemperatureAndFlow, model units mm)
options: Default_Fluid_Material=air Default_Solid_Material=Al-Extruded Default_Surface_Material=Steel-oxidised-surface AmbientTemperature=25cel AmbientPressure=0n_per_meter_sq AmbientRadiationTemperature=25cel Gravity_Vector_CS_ID=Global Gravity_Vector_Axis=Z Positive=false SherlockExportDirectory=C:/Users/karlr/Documents/Ansoft/1kW_Final.aedtexport/[Thermal]8turns_3D_CoreLoss_FullInterleaved_Flatwise/ Altitude=0meter
geometry:
  Region [air] = region(percentage_offset=1000 on all sides)
  Np1 [copper] = imported_body(C:\Users\karlr\Documents\edgewise_0.5_sweep.step)
  Np2 [copper] = imported_body(C:\Users\karlr\Documents\edgewise_0.5_sweep.step)
  Np3 [copper] = imported_body(C:\Users\karlr\Documents\edgewise_0.5_sweep.step)
  Np4 [copper] = imported_body(C:\Users\karlr\Documents\edgewise_0.5_sweep.step)
  Np5 [copper] = imported_body(C:\Users\karlr\Documents\edgewise_0.5_sweep.step)
  Np6 [copper] = imported_body(C:\Users\karlr\Documents\edgewise_0.5_sweep.step)
  Np7 [copper] = imported_body(C:\Users\karlr\Documents\edgewise_0.5_sweep.step)
  Np8 [copper] = imported_body(C:\Users\karlr\Documents\edgewise_0.5_sweep.step)
  Ns1 [copper] = imported_body(C:\Users\karlr\Documents\edgewise_0.5_sweep.step)
  Ns2 [copper] = imported_body(C:\Users\karlr\Documents\edgewise_0.5_sweep.step)
  Ns3 [copper] = imported_body(C:\Users\karlr\Documents\edgewise_0.5_sweep.step)
  Ns4 [copper] = imported_body(C:\Users\karlr\Documents\edgewise_0.5_sweep.step)
  Ns5 [copper] = imported_body(C:\Users\karlr\Documents\edgewise_0.5_sweep.step)
  Ns6 [copper] = imported_body(C:\Users\karlr\Documents\edgewise_0.5_sweep.step)
  Ns7 [copper] = imported_body(C:\Users\karlr\Documents\edgewise_0.5_sweep.step)
  Ns8 [copper] = imported_body(C:\Users\karlr\Documents\edgewise_0.5_sweep.step)
  plate1, plate2 [silicon - Copy] = imported_body(C:\Users\karlr\Documents\edgewise_0.5_sweep.step)
  Body1 [ferrite - Copy (2)] = imported_body(C:\Users\karlr\Documents\edgewise_0.5_sweep.step)
  Body1_1, Body1_2 [aluminum] = imported_body(C:\Users\karlr\Documents\edgewise_0.5_sweep.step)
  Body1_3 [ferrite - Copy (2)] = imported_body(C:\Users\karlr\Documents\edgewise_0.5_sweep.step)
  Body1_4, Body1_5 [aluminum] = imported_body(C:\Users\karlr\Documents\edgewise_0.5_sweep.step)
  group core_assembled_edgewise1 = Np1..Np8, Ns1..Ns8, plate1, plate2
  group core_together_2 = Body1, Body1_1, Body1_2
  group core_together1 = Body1_3, Body1_4, Body1_5
boundaries and excitations:
  Opening1: Opening Faces=Region.face(-y) Temperature=AmbientTemp External_Rad._Temperature=AmbientRadTemp Inlet_Type=Pressure Total_Pressure=AmbientPressure
  Opening2: Opening Faces=Region.face(+y) Temperature=AmbientTemp External_Rad._Temperature=AmbientRadTemp Inlet_Type=Velocity Static_Pressure=AmbientPressure X_Velocity=0m_per_sec Y_Velocity=0m_per_sec Z_Velocity=0m_per_sec
  EMLoss1: EM Loss Objects=[Np1..Np8, Ns1..Ns8, Body1, Body1_1..Body1_5] LinkID=359 Project="This Project*" Product=ElectronicsDesktop Design=Edgewise_0.5_interleaved_full Params{freq_hz=28500Hz} ForceSourceToSolve PreservePartnerSoln PathRelativeTo=TargetProject Intrinsics(28.5kHz) LossMultiplier=1
mesh:
  MeshRegions:  Global{MeshMethod=MesherHD ComputeGap MeshRegionResolution=5 MinGapX=1mm MinGapY=1mm MinGapZ=1mm Objects=Region FacetLevel=5 ProximitySizeFunction CurvatureSizeFunction OptimizePCBMesh}
  MeshOperations:
setups:
  Setup1: IcepakSteadyState Flow_Regime=Laminar Include_Temperature=true Include_Flow=true Include_Gravity Solution_Initialization_-_Z_Velocity=0.000980665m_per_sec Convergence_Criteria_-_Flow=0.001 Convergence_Criteria_-_Energy=1e-07 Convergence_Criteria_-_Discrete_Ordinates=1e-06 Radiation_Model="Discrete Ordinates Model" Flow_Iteration_Per_Radiation_Iteration=10 ThetaDivision=2 PhiDivision=2 ThetaPixels=2 PhiPixels=2 Under-relaxation_-_Pressure=0.7 Under-relaxation_-_Momentum=0.3 Under-relaxation_-_Temperature=1 Discretization_Scheme_-_Pressure=Standard Discretization_Scheme_-_Momentum=First Discretization_Scheme_-_Temperature=First Discretization_Scheme_-_Discrete_Ordinates=First Convergence_Criteria_-_Max_Iterations=10000

design [Thermal]Edgewise_0.4 (Icepak, SteadyState TemperatureAndFlow, model units mm)
options: Default_Fluid_Material=air Default_Solid_Material=Al-Extruded Default_Surface_Material=Steel-oxidised-surface AmbientTemperature=25cel AmbientPressure=0n_per_meter_sq AmbientRadiationTemperature=25cel Gravity_Vector_CS_ID=Global Gravity_Vector_Axis=Z Positive=false SherlockExportDirectory=C:/Users/karlr/Documents/Ansoft/1kW_Final.aedtexport/[Thermal]8turns_3D_CoreLoss_FullInterleaved_Flatwise/ Altitude=0meter
geometry:
  Region [air] = region(percentage_offset=1000 on all sides)
  Np1 [copper] = imported_body(C:\Users\karlr\Documents\edgewise_0.4_sweep.step)
  Np2 [copper] = imported_body(C:\Users\karlr\Documents\edgewise_0.4_sweep.step)
  Np3 [copper] = imported_body(C:\Users\karlr\Documents\edgewise_0.4_sweep.step)
  Np4 [copper] = imported_body(C:\Users\karlr\Documents\edgewise_0.4_sweep.step)
  Np5 [copper] = imported_body(C:\Users\karlr\Documents\edgewise_0.4_sweep.step)
  Np6 [copper] = imported_body(C:\Users\karlr\Documents\edgewise_0.4_sweep.step)
  Np7 [copper] = imported_body(C:\Users\karlr\Documents\edgewise_0.4_sweep.step)
  Np8 [copper] = imported_body(C:\Users\karlr\Documents\edgewise_0.4_sweep.step)
  Ns1 [copper] = imported_body(C:\Users\karlr\Documents\edgewise_0.4_sweep.step)
  Ns2 [copper] = imported_body(C:\Users\karlr\Documents\edgewise_0.4_sweep.step)
  Ns3 [copper] = imported_body(C:\Users\karlr\Documents\edgewise_0.4_sweep.step)
  Ns4 [copper] = imported_body(C:\Users\karlr\Documents\edgewise_0.4_sweep.step)
  Ns5 [copper] = imported_body(C:\Users\karlr\Documents\edgewise_0.4_sweep.step)
  Ns6 [copper] = imported_body(C:\Users\karlr\Documents\edgewise_0.4_sweep.step)
  Ns7 [copper] = imported_body(C:\Users\karlr\Documents\edgewise_0.4_sweep.step)
  Ns8 [copper] = imported_body(C:\Users\karlr\Documents\edgewise_0.4_sweep.step)
  plate1, plate2 [silicon - Copy] = imported_body(C:\Users\karlr\Documents\edgewise_0.4_sweep.step)
  Body1 [ferrite - Copy (2)] = imported_body(C:\Users\karlr\Documents\edgewise_0.4_sweep.step)
  Body1_1, Body1_2 [aluminum] = imported_body(C:\Users\karlr\Documents\edgewise_0.4_sweep.step)
  Body1_3 [ferrite - Copy (2)] = imported_body(C:\Users\karlr\Documents\edgewise_0.4_sweep.step)
  Body1_4, Body1_5 [aluminum] = imported_body(C:\Users\karlr\Documents\edgewise_0.4_sweep.step)
  group core_assembled_edgewise1 = Np1..Np8, Ns1..Ns8, plate1, plate2
  group core_together_2 = Body1, Body1_1, Body1_2
  group core_together1 = Body1_3, Body1_4, Body1_5
boundaries and excitations:
  Opening1: Opening Faces=Region.face(-y) Temperature=AmbientTemp External_Rad._Temperature=AmbientRadTemp Inlet_Type=Pressure Total_Pressure=AmbientPressure
  Opening2: Opening Faces=Region.face(+y) Temperature=AmbientTemp External_Rad._Temperature=AmbientRadTemp Inlet_Type=Velocity Static_Pressure=AmbientPressure X_Velocity=0m_per_sec Y_Velocity=0m_per_sec Z_Velocity=0m_per_sec
  EMLoss1: EM Loss Objects=[Np1..Np8, Ns1..Ns8, Body1, Body1_1..Body1_5] LinkID=373 Project="This Project*" Product=ElectronicsDesktop Design=Edgewise_0.4_interleaved_full Params{freq_hz=28500Hz} ForceSourceToSolve PreservePartnerSoln PathRelativeTo=TargetProject Intrinsics(28.5kHz) LossMultiplier=1
mesh:
  MeshRegions:  Global{MeshMethod=MesherHD ComputeGap MeshRegionResolution=5 MinGapX=1mm MinGapY=1mm MinGapZ=1mm Objects=Region FacetLevel=5 ProximitySizeFunction CurvatureSizeFunction OptimizePCBMesh}
  MeshOperations:
setups:
  Setup1: IcepakSteadyState Flow_Regime=Laminar Include_Temperature=true Include_Flow=true Include_Gravity Solution_Initialization_-_Z_Velocity=0.000980665m_per_sec Convergence_Criteria_-_Flow=0.001 Convergence_Criteria_-_Energy=1e-07 Convergence_Criteria_-_Discrete_Ordinates=1e-06 Radiation_Model="Discrete Ordinates Model" Flow_Iteration_Per_Radiation_Iteration=10 ThetaDivision=2 PhiDivision=2 ThetaPixels=2 PhiPixels=2 Under-relaxation_-_Pressure=0.7 Under-relaxation_-_Momentum=0.3 Under-relaxation_-_Temperature=1 Discretization_Scheme_-_Pressure=Standard Discretization_Scheme_-_Momentum=First Discretization_Scheme_-_Temperature=First Discretization_Scheme_-_Discrete_Ordinates=First Convergence_Criteria_-_Max_Iterations=10000

design [Thermal]Edgewise_0.3 (Icepak, SteadyState TemperatureAndFlow, model units mm)
options: Default_Fluid_Material=air Default_Solid_Material=Al-Extruded Default_Surface_Material=Steel-oxidised-surface AmbientTemperature=25cel AmbientPressure=0n_per_meter_sq AmbientRadiationTemperature=25cel Gravity_Vector_CS_ID=Global Gravity_Vector_Axis=Z Positive=false SherlockExportDirectory=C:/Users/karlr/Documents/Ansoft/1kW_Final.aedtexport/[Thermal]8turns_3D_CoreLoss_FullInterleaved_Flatwise/ Altitude=0meter
geometry:
  Region [air] = region(percentage_offset=1000 on all sides)
  Np1 [copper] = imported_body(C:\Users\karlr\Documents\edgewise_0.3_sweep.step)
  Np2 [copper] = imported_body(C:\Users\karlr\Documents\edgewise_0.3_sweep.step)
  Np3 [copper] = imported_body(C:\Users\karlr\Documents\edgewise_0.3_sweep.step)
  Np4 [copper] = imported_body(C:\Users\karlr\Documents\edgewise_0.3_sweep.step)
  Np5 [copper] = imported_body(C:\Users\karlr\Documents\edgewise_0.3_sweep.step)
  Np6 [copper] = imported_body(C:\Users\karlr\Documents\edgewise_0.3_sweep.step)
  Np7 [copper] = imported_body(C:\Users\karlr\Documents\edgewise_0.3_sweep.step)
  Np8 [copper] = imported_body(C:\Users\karlr\Documents\edgewise_0.3_sweep.step)
  Ns1 [copper] = imported_body(C:\Users\karlr\Documents\edgewise_0.3_sweep.step)
  Ns2 [copper] = imported_body(C:\Users\karlr\Documents\edgewise_0.3_sweep.step)
  Ns3 [copper] = imported_body(C:\Users\karlr\Documents\edgewise_0.3_sweep.step)
  Ns4 [copper] = imported_body(C:\Users\karlr\Documents\edgewise_0.3_sweep.step)
  Ns5 [copper] = imported_body(C:\Users\karlr\Documents\edgewise_0.3_sweep.step)
  Ns6 [copper] = imported_body(C:\Users\karlr\Documents\edgewise_0.3_sweep.step)
  Ns7 [copper] = imported_body(C:\Users\karlr\Documents\edgewise_0.3_sweep.step)
  Ns8 [copper] = imported_body(C:\Users\karlr\Documents\edgewise_0.3_sweep.step)
  plate1, plate2 [silicon - Copy] = imported_body(C:\Users\karlr\Documents\edgewise_0.3_sweep.step)
  Body1 [ferrite - Copy (2)] = imported_body(C:\Users\karlr\Documents\edgewise_0.3_sweep.step)
  Body1_1, Body1_2 [aluminum] = imported_body(C:\Users\karlr\Documents\edgewise_0.3_sweep.step)
  Body1_3 [ferrite - Copy (2)] = imported_body(C:\Users\karlr\Documents\edgewise_0.3_sweep.step)
  Body1_4, Body1_5 [aluminum] = imported_body(C:\Users\karlr\Documents\edgewise_0.3_sweep.step)
  group core_assembled_edgewise1 = Np1..Np8, Ns1..Ns8, plate1, plate2
  group core_together_2 = Body1, Body1_1, Body1_2
  group core_together1 = Body1_3, Body1_4, Body1_5
boundaries and excitations:
  Opening1: Opening Faces=Region.face(-y) Temperature=AmbientTemp External_Rad._Temperature=AmbientRadTemp Inlet_Type=Pressure Total_Pressure=AmbientPressure
  Opening2: Opening Faces=Region.face(+y) Temperature=AmbientTemp External_Rad._Temperature=AmbientRadTemp Inlet_Type=Velocity Static_Pressure=AmbientPressure X_Velocity=0m_per_sec Y_Velocity=0m_per_sec Z_Velocity=0m_per_sec
  EMLoss1: EM Loss Objects=[Np1..Np8, Ns1..Ns8, Body1, Body1_1..Body1_5] LinkID=393 Project="This Project*" Product=ElectronicsDesktop Design=Edgewise_0.3_interleaved_full Params{freq_hz=28500Hz} ForceSourceToSolve PreservePartnerSoln PathRelativeTo=TargetProject Intrinsics(28.5kHz) LossMultiplier=1
mesh:
  MeshRegions:  Global{MeshMethod=MesherHD ComputeGap MeshRegionResolution=5 MinGapX=1mm MinGapY=1mm MinGapZ=1mm Objects=Region FacetLevel=5 ProximitySizeFunction CurvatureSizeFunction OptimizePCBMesh}
  MeshOperations:
setups:
  Setup1: IcepakSteadyState Flow_Regime=Laminar Include_Temperature=true Include_Flow=true Include_Gravity Solution_Initialization_-_Z_Velocity=0.000980665m_per_sec Convergence_Criteria_-_Flow=0.001 Convergence_Criteria_-_Energy=1e-07 Convergence_Criteria_-_Discrete_Ordinates=1e-06 Radiation_Model="Discrete Ordinates Model" Flow_Iteration_Per_Radiation_Iteration=10 ThetaDivision=2 PhiDivision=2 ThetaPixels=2 PhiPixels=2 Under-relaxation_-_Pressure=0.7 Under-relaxation_-_Momentum=0.3 Under-relaxation_-_Temperature=1 Discretization_Scheme_-_Pressure=Standard Discretization_Scheme_-_Momentum=First Discretization_Scheme_-_Temperature=First Discretization_Scheme_-_Discrete_Ordinates=First Convergence_Criteria_-_Max_Iterations=10000

design [Thermal]Edgewise_0.2 (Icepak, SteadyState TemperatureAndFlow, model units mm)
options: Default_Fluid_Material=air Default_Solid_Material=Al-Extruded Default_Surface_Material=Steel-oxidised-surface AmbientTemperature=25cel AmbientPressure=0n_per_meter_sq AmbientRadiationTemperature=25cel Gravity_Vector_CS_ID=Global Gravity_Vector_Axis=Z Positive=false SherlockExportDirectory=C:/Users/karlr/Documents/Ansoft/1kW_Final.aedtexport/[Thermal]8turns_3D_CoreLoss_FullInterleaved_Flatwise/ Altitude=0meter
geometry:
  Region [air] = region(percentage_offset=1000 on all sides)
  Np1 [copper] = imported_body(C:\Users\karlr\Documents\edgewise_0.2_sweep.step)
  Np2 [copper] = imported_body(C:\Users\karlr\Documents\edgewise_0.2_sweep.step)
  Np3 [copper] = imported_body(C:\Users\karlr\Documents\edgewise_0.2_sweep.step)
  Np4 [copper] = imported_body(C:\Users\karlr\Documents\edgewise_0.2_sweep.step)
  Np5 [copper] = imported_body(C:\Users\karlr\Documents\edgewise_0.2_sweep.step)
  Np6 [copper] = imported_body(C:\Users\karlr\Documents\edgewise_0.2_sweep.step)
  Np7 [copper] = imported_body(C:\Users\karlr\Documents\edgewise_0.2_sweep.step)
  Np8 [copper] = imported_body(C:\Users\karlr\Documents\edgewise_0.2_sweep.step)
  Ns1 [copper] = imported_body(C:\Users\karlr\Documents\edgewise_0.2_sweep.step)
  Ns2 [copper] = imported_body(C:\Users\karlr\Documents\edgewise_0.2_sweep.step)
  Ns3 [copper] = imported_body(C:\Users\karlr\Documents\edgewise_0.2_sweep.step)
  Ns4 [copper] = imported_body(C:\Users\karlr\Documents\edgewise_0.2_sweep.step)
  Ns5 [copper] = imported_body(C:\Users\karlr\Documents\edgewise_0.2_sweep.step)
  Ns6 [copper] = imported_body(C:\Users\karlr\Documents\edgewise_0.2_sweep.step)
  Ns7 [copper] = imported_body(C:\Users\karlr\Documents\edgewise_0.2_sweep.step)
  Ns8 [copper] = imported_body(C:\Users\karlr\Documents\edgewise_0.2_sweep.step)
  plate1, plate2 [silicon - Copy] = imported_body(C:\Users\karlr\Documents\edgewise_0.2_sweep.step)
  Body1 [ferrite - Copy (2)] = imported_body(C:\Users\karlr\Documents\edgewise_0.2_sweep.step)
  Body1_1, Body1_2 [aluminum] = imported_body(C:\Users\karlr\Documents\edgewise_0.2_sweep.step)
  Body1_3 [ferrite - Copy (2)] = imported_body(C:\Users\karlr\Documents\edgewise_0.2_sweep.step)
  Body1_4, Body1_5 [aluminum] = imported_body(C:\Users\karlr\Documents\edgewise_0.2_sweep.step)
  group core_together_1 = Body1, Body1_1, Body1_2
  group core_together = Body1_3, Body1_4, Body1_5
  group core_assembled_edgewise = Np1..Np8, Ns1..Ns8, plate1, plate2
boundaries and excitations:
  Opening1: Opening Faces=Region.face(-y) Temperature=AmbientTemp External_Rad._Temperature=AmbientRadTemp Inlet_Type=Pressure Total_Pressure=AmbientPressure
  Opening2: Opening Faces=Region.face(+y) Temperature=AmbientTemp External_Rad._Temperature=AmbientRadTemp Inlet_Type=Velocity Static_Pressure=AmbientPressure X_Velocity=0m_per_sec Y_Velocity=0m_per_sec Z_Velocity=0m_per_sec
  EMLoss1: EM Loss Objects=[Np1..Np8, Ns1..Ns8, Body1, Body1_1..Body1_5] LinkID=409 Project="This Project*" Product=ElectronicsDesktop Design=Edgewise_0.2_interleaved_full Params{freq_hz=28500Hz} ForceSourceToSolve PreservePartnerSoln PathRelativeTo=TargetProject Intrinsics(28.5kHz) LossMultiplier=1
mesh:
  MeshRegions:  Global{MeshMethod=MesherHD ComputeGap MeshRegionResolution=5 MinGapX=1mm MinGapY=1mm MinGapZ=1mm Objects=Region FacetLevel=5 ProximitySizeFunction CurvatureSizeFunction OptimizePCBMesh}
  MeshOperations:
setups:
  Setup1: IcepakSteadyState Flow_Regime=Laminar Include_Temperature=true Include_Flow=true Include_Gravity Solution_Initialization_-_Z_Velocity=0.000980665m_per_sec Convergence_Criteria_-_Flow=0.001 Convergence_Criteria_-_Energy=1e-07 Convergence_Criteria_-_Discrete_Ordinates=1e-06 Radiation_Model="Discrete Ordinates Model" Flow_Iteration_Per_Radiation_Iteration=10 ThetaDivision=2 PhiDivision=2 ThetaPixels=2 PhiPixels=2 Under-relaxation_-_Pressure=0.7 Under-relaxation_-_Momentum=0.3 Under-relaxation_-_Temperature=1 Discretization_Scheme_-_Pressure=Standard Discretization_Scheme_-_Momentum=First Discretization_Scheme_-_Temperature=First Discretization_Scheme_-_Discrete_Ordinates=First Convergence_Criteria_-_Max_Iterations=10000

design [Thermal]Edgewise_0.1 (Icepak, SteadyState TemperatureAndFlow, model units mm)
options: Default_Fluid_Material=air Default_Solid_Material=Al-Extruded Default_Surface_Material=Steel-oxidised-surface AmbientTemperature=25cel AmbientPressure=0n_per_meter_sq AmbientRadiationTemperature=25cel Gravity_Vector_CS_ID=Global Gravity_Vector_Axis=Z Positive=false SherlockExportDirectory=C:/Users/karlr/Documents/Ansoft/1kW_Final.aedtexport/[Thermal]8turns_3D_CoreLoss_FullInterleaved_Flatwise/ Altitude=0meter
geometry:
  Region [air] = region(percentage_offset=1000 on all sides)
  Np1 [copper] = imported_body(C:\Users\karlr\Documents\edgewise_0.1_sweep.step)
  Np2 [copper] = imported_body(C:\Users\karlr\Documents\edgewise_0.1_sweep.step)
  Np3 [copper] = imported_body(C:\Users\karlr\Documents\edgewise_0.1_sweep.step)
  Np4 [copper] = imported_body(C:\Users\karlr\Documents\edgewise_0.1_sweep.step)
  Np5 [copper] = imported_body(C:\Users\karlr\Documents\edgewise_0.1_sweep.step)
  Np6 [copper] = imported_body(C:\Users\karlr\Documents\edgewise_0.1_sweep.step)
  Np7 [copper] = imported_body(C:\Users\karlr\Documents\edgewise_0.1_sweep.step)
  Np8 [copper] = imported_body(C:\Users\karlr\Documents\edgewise_0.1_sweep.step)
  Ns1 [copper] = imported_body(C:\Users\karlr\Documents\edgewise_0.1_sweep.step)
  Ns2 [copper] = imported_body(C:\Users\karlr\Documents\edgewise_0.1_sweep.step)
  Ns3 [copper] = imported_body(C:\Users\karlr\Documents\edgewise_0.1_sweep.step)
  Ns4 [copper] = imported_body(C:\Users\karlr\Documents\edgewise_0.1_sweep.step)
  Ns5 [copper] = imported_body(C:\Users\karlr\Documents\edgewise_0.1_sweep.step)
  Ns6 [copper] = imported_body(C:\Users\karlr\Documents\edgewise_0.1_sweep.step)
  Ns7 [copper] = imported_body(C:\Users\karlr\Documents\edgewise_0.1_sweep.step)
  Ns8 [copper] = imported_body(C:\Users\karlr\Documents\edgewise_0.1_sweep.step)
  plate1, plate2 [silicon - Copy] = imported_body(C:\Users\karlr\Documents\edgewise_0.1_sweep.step)
  Body1 [ferrite - Copy (2)] = imported_body(C:\Users\karlr\Documents\edgewise_0.1_sweep.step)
  Body1_1, Body1_2 [aluminum] = imported_body(C:\Users\karlr\Documents\edgewise_0.1_sweep.step)
  Body1_3 [ferrite - Copy (2)] = imported_body(C:\Users\karlr\Documents\edgewise_0.1_sweep.step)
  Body1_4, Body1_5 [aluminum] = imported_body(C:\Users\karlr\Documents\edgewise_0.1_sweep.step)
  group core_together_1 = Body1, Body1_1, Body1_2
  group core_together = Body1_3, Body1_4, Body1_5
  group core_assembled_edgewise = Np1..Np8, Ns1..Ns8, plate1, plate2
boundaries and excitations:
  Opening1: Opening Faces=Region.face(-y) Temperature=AmbientTemp External_Rad._Temperature=AmbientRadTemp Inlet_Type=Pressure Total_Pressure=AmbientPressure
  Opening2: Opening Faces=Region.face(+y) Temperature=AmbientTemp External_Rad._Temperature=AmbientRadTemp Inlet_Type=Velocity Static_Pressure=AmbientPressure X_Velocity=0m_per_sec Y_Velocity=0m_per_sec Z_Velocity=0m_per_sec
  EMLoss1: EM Loss Objects=[Np1..Np8, Ns1..Ns8, Body1, Body1_1..Body1_5] LinkID=424 Project="This Project*" Product=ElectronicsDesktop Design=Edgewise_0.1_interleaved_full Params{freq_hz=28500Hz} ForceSourceToSolve PreservePartnerSoln PathRelativeTo=TargetProject Intrinsics(28.5kHz) LossMultiplier=1
mesh:
  MeshRegions:  Global{MeshMethod=MesherHD ComputeGap MeshRegionResolution=5 MinGapX=1mm MinGapY=1mm MinGapZ=1mm Objects=Region FacetLevel=5 ProximitySizeFunction CurvatureSizeFunction OptimizePCBMesh}
  MeshOperations:
setups:
  Setup1: IcepakSteadyState Flow_Regime=Laminar Include_Temperature=true Include_Flow=true Include_Gravity Solution_Initialization_-_Z_Velocity=0.000980665m_per_sec Convergence_Criteria_-_Flow=0.001 Convergence_Criteria_-_Energy=1e-07 Convergence_Criteria_-_Discrete_Ordinates=1e-06 Radiation_Model="Discrete Ordinates Model" Flow_Iteration_Per_Radiation_Iteration=10 ThetaDivision=2 PhiDivision=2 ThetaPixels=2 PhiPixels=2 Under-relaxation_-_Pressure=0.7 Under-relaxation_-_Momentum=0.3 Under-relaxation_-_Temperature=1 Discretization_Scheme_-_Pressure=Standard Discretization_Scheme_-_Momentum=First Discretization_Scheme_-_Temperature=First Discretization_Scheme_-_Discrete_Ordinates=First Convergence_Criteria_-_Max_Iterations=10000
