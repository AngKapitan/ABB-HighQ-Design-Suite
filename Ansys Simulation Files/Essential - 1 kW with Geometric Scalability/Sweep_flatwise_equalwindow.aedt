# Ansys Electronics Desktop project, version 2023.1
materials:
  aluminum: permeability=1.000021 conductivity=38000000 thermal_conductivity=237.5 mass_density=2689 specific_heat=951 youngs_modulus=69000000000 poissons_ratio=0.31 thermal_expansion_coefficient=2.33e-05
  copper: permeability=0.999991 conductivity=58000000 thermal_conductivity=400 mass_density=8933 specific_heat=385 youngs_modulus=120000000000 poissons_ratio=0.38 thermal_expansion_coefficient=1.77e-05
  ferrite - Copy (2): core_loss_curve{25kHz (0, 0) (0.050633, 1) (0.0590114, 1.50406) (0.0691674, 2.34392) (0.0792528, 3.65275) (0.088772, 5.02746) (0.0939521, 6.11121) (0.1, 7.16954) (0.109499, 8.56175) (0.121957, 11.5767) (0.138164, 16.5092) (0.153013, 23.1293) (0.173347, 32.9841) (0.195272, 44.5991) (0.21382, 61.3838) (0.235462, 78.6962) (0.259294, 104.536) (0.280722, 138.862) (0.295422, 151.746)} core_loss_curve{100kHz (0, 0) (0.0263744, 1.03613) (0.0293752, 1.42608) (0.0332788, 2.03369) (0.0396755, 3.1693) (0.0449479, 4.44016) (0.0523856, 6.91954) (0.0628101, 11.373) (0.0753091, 20.068) (0.0882699, 32.4039) (0.103461, 49.6099) (0.118547, 74.6161) (0.142138, 118.363) (0.165658, 191.122) (0.184506, 245.025) (0.1975, 325.48) (0.215037, 409.937) (0.242235, 554.291) (0.26827, 762.898) (0.287163, 911.04)} core_loss_curve{200kHz (0, 0) (0.0153013, 1.07357) (0.0196383, 2.03369) (0.0260769, 4.28533) (0.0305648, 7.42858) (0.0396755, 14.0722) (0.0481134, 22.7224) (0.059347, 38.6962) (0.0757374, 74.6161) (0.0994345, 162.909) (0.110748, 216.401) (0.130546, 319.755) (0.147894, 472.47) (0.164721, 605.722) (0.183462, 848.612) (0.194168, 1013.4) (0.210213, 1167.99) (0.235462, 1607.55) (0.252045, 2024.69) (0.274425, 2333.54) (0.290439, 2939.06)} core_loss_curve{500kHz (0, 0) (0.0101716, 5.89811) (0.01199, 8.71505) (0.0149581, 13.5815) (0.0170423, 18.6929) (0.0202031, 30.1834) (0.0235462, 38.6962) (0.0266752, 55.1837) (0.0309135, 72.0142) (0.0356225, 99.1166) (0.0401281, 129.346) (0.0465037, 187.76) (0.0515018, 236.481) (0.0580159, 319.755) (0.067616, 447.974) (0.0761681, 574.318) (0.0892769, 776.557) (0.101141, 1068.81) (0.1199, 1524.21) (0.142138, 2292.49) (0.174333, 3327.81) (0.199753, 5186.04) (0.22248, 6531.74) (0.249202, 8373.92)} permittivity=12 permeability=3400 conductivity=0.25 thermal_conductivity=4 core_loss_type="Power Ferrite" core_loss_cm=0.062032234 core_loss_x=1.7066326 core_loss_y=2.5354555 mass_density=4800 specific_heat=750 youngs_modulus=119000000000 thermal_expansion_coefficient=1e-05 core_loss_equiv_cut_depth=0.001meter
  silicon - Copy: permittivity=9 thermal_conductivity=10 mass_density=3700 specific_heat=712 youngs_modulus=135000000000 poissons_ratio=0.25 thermal_expansion_coefficient=2.54e-06
  vacuum: permittivity=1
  air: permittivity=1.0006 permeability=1.0000004 thermal_conductivity=0.0261 mass_density=1.1614 specific_heat=1005 thermal_expansion_coefficient=0.00333 thermal_material_type=Fluid diffusivity=2.88e-05 molecular_mass=0.028966 viscosity=1.84e-05 material_refractive_index=1.000293
  Al-Extruded: thermal_conductivity=205 mass_density=2800 specific_heat=900 youngs_modulus=69000000000 poissons_ratio=0.33 thermal_expansion_coefficient=2.277e-06 thermal_material_type=Solid
  polyimide: permittivity=3.5 dielectric_loss_tangent=0.008 thermal_conductivity=0.25 mass_density=1400 specific_heat=1150 youngs_modulus=7500000000 poissons_ratio=0.35 thermal_expansion_coefficient=7e-05
surface materials:
  Steel-oxidised-surface: surface_emissivity=0.8

design Flatwise_0.2_interleaved_full (Maxwell 3D, EddyCurrent, model units mm)
variables:
  freq_hz = 28500Hz
  volt_ac = 141/28500*Freq
geometry:
  Region [vacuum] = region(percentage_offset=0 on all sides)
  Np1..Np8, Ns1..Ns8 [copper] = imported_body(C:\Users\karlr\Documents\ICMaSS_sweeping\flatwise_0.1_0.2.step)
  plate_1, plate_2 [silicon - Copy] = imported_body(C:\Users\karlr\Documents\ICMaSS_sweeping\flatwise_0.1_0.2.step)
  Body1 [ferrite - Copy (2)] = imported_body(C:\Users\karlr\Documents\ICMaSS_sweeping\flatwise_0.1_0.2.step)
  Body1_1, Body1_2 [aluminum] = imported_body(C:\Users\karlr\Documents\ICMaSS_sweeping\flatwise_0.1_0.2.step)
  Body1_3 [ferrite - Copy (2)] = imported_body(C:\Users\karlr\Documents\ICMaSS_sweeping\flatwise_0.1_0.2.step)
  Body1_4, Body1_5 [aluminum] = imported_body(C:\Users\karlr\Documents\ICMaSS_sweeping\flatwise_0.1_0.2.step)
  Np1_Section1 = Np1.section(plane=ZX)
  Np2_Section1 = Np2.section(plane=ZX)
  Np3_Section1 [copper] = Np3.section(plane=ZX)
  Np4_Section1 [copper] = Np4.section(plane=ZX)
  Np5_Section1 [copper] = Np5.section(plane=ZX)
  Np6_Section1 [copper] = Np6.section(plane=ZX)
  Np7_Section1 [copper] = Np7.section(plane=ZX)
  Np8_Section1 [copper] = Np8.section(plane=ZX)
  Ns1_Section1 = Ns1.section(plane=ZX)
  Ns2_Section1 = Ns2.section(plane=ZX)
  Ns3_Section1 [copper] = Ns3.section(plane=ZX)
  Ns4_Section1 [copper] = Ns4.section(plane=ZX)
  Ns5_Section1 [copper] = Ns5.section(plane=ZX)
  Ns6_Section1 [copper] = Ns6.section(plane=ZX)
  Ns7_Section1 [copper] = Ns7.section(plane=ZX)
  Ns8_Section1 [copper] = Ns8.section(plane=ZX)
  Np1_Section1_Separate1 [copper] = Np1_Section1.separate_bodies()
  Np1_Section1.delete()
  Np2_Section1_Separate1 [copper] = Np2_Section1.separate_bodies()
  Np2_Section1.delete()
  Np3_Section1.separate_bodies()
  Np4_Section1.separate_bodies()
  Np5_Section1.separate_bodies()
  Np6_Section1.separate_bodies()
  Np7_Section1.separate_bodies()
  Np8_Section1.separate_bodies()
  Ns1_Section1_Separate1 [copper] = Ns1_Section1.separate_bodies()
  Ns1_Section1.delete()
  Ns2_Section1_Separate1 [copper] = Ns2_Section1.separate_bodies()
  Ns2_Section1.delete()
  Ns3_Section1.separate_bodies()
  Ns4_Section1.separate_bodies()
  Ns5_Section1.separate_bodies()
  Ns6_Section1.separate_bodies()
  Ns7_Section1.separate_bodies()
  Ns8_Section1.separate_bodies()
  group core_assembled_flatwise = Np1..Np8, Ns1..Ns8, plate_1, plate_2, Np3_Section1, Np4_Section1, Np5_Section1, Np6_Section1, Np7_Section1, Np8_Section1, Ns3_Section1, Ns4_Section1, Ns5_Section1, Ns6_Section1, Ns7_Section1, Ns8_Section1, Np1_Section1_Separate1, Np2_Section1_Separate1, Ns1_Section1_Separate1, Ns2_Section1_Separate1
  group core_together_2 = Body1, Body1_1, Body1_2
  group core_together1 = Body1_3, Body1_4, Body1_5
boundaries and excitations:
  Np_1: Coil Terminal Objects=Np1_Section1_Separate1 Conductor_number=1 Winding=Np Point_out_of_terminal=false
  Np_2: Coil Terminal Objects=Np2_Section1_Separate1 Conductor_number=1 Winding=Np Point_out_of_terminal=false
  Np_3: Coil Terminal Objects=Np3_Section1 Conductor_number=1 Winding=Np Point_out_of_terminal=false
  Np_4: Coil Terminal Objects=Np4_Section1 Conductor_number=1 Winding=Np Point_out_of_terminal=false
  Np_5: Coil Terminal Objects=Np5_Section1 Conductor_number=1 Winding=Np Point_out_of_terminal=false
  Np_6: Coil Terminal Objects=Np6_Section1 Conductor_number=1 Winding=Np Point_out_of_terminal=false
  Np_7: Coil Terminal Objects=Np7_Section1 Conductor_number=1 Winding=Np Point_out_of_terminal=false
  Np_8: Coil Terminal Objects=Np8_Section1 Conductor_number=1 Winding=Np Point_out_of_terminal=false
  Ns_1: Coil Terminal Objects=Ns1_Section1_Separate1 Conductor_number=1 Winding=Ns Point_out_of_terminal=true
  Ns_2: Coil Terminal Objects=Ns2_Section1_Separate1 Conductor_number=1 Winding=Ns Point_out_of_terminal=true
  Ns_3: Coil Terminal Objects=Ns3_Section1 Conductor_number=1 Winding=Ns Point_out_of_terminal=true
  Ns_4: Coil Terminal Objects=Ns4_Section1 Conductor_number=1 Winding=Ns Point_out_of_terminal=true
  Ns_5: Coil Terminal Objects=Ns5_Section1 Conductor_number=1 Winding=Ns Point_out_of_terminal=true
  Ns_6: Coil Terminal Objects=Ns6_Section1 Conductor_number=1 Winding=Ns Point_out_of_terminal=true
  Ns_7: Coil Terminal Objects=Ns7_Section1 Conductor_number=1 Winding=Ns Point_out_of_terminal=true
  Ns_8: Coil Terminal Objects=Ns8_Section1 Conductor_number=1 Winding=Ns Point_out_of_terminal=true
  Np: Winding Group Type=Voltage IsSolid=true Current=16.36A Resistance=0ohm Inductance=0nH Voltage=volt_ac ParallelBranchesNum=1 Phase=0rad
  Ns: Winding Group Type=Current IsSolid=true Current=1000*1.41/volt_ac*1.414 ParallelBranchesNum=1 Phase=0.1522rad
  core loss on: Body1, Body1_3
parameters:
  Matrix1: Matrix Np, Ns:
mesh:
  Length1: LengthBased Objects=[Body1, Body1_1..Body1_5] MaxLength=5mm
  Length2: LengthBased Objects=[Np1..Np8, Ns1..Ns8, plate_1, plate_2] MaxLength=2mm
  initial mesh: GlobalSurfApproximation{CurvedSurfaceApproxChoice=UseSlider SliderMeshSettings=9} GlobalCurvilinear{Apply}
setups:
  Setup1: EddyCurrent MaximumPasses=20 MinimumPasses=2 MinimumConvergedPasses=1 PercentRefinement=30 PercentError=1 NonLinearResidual=0.0001 SmoothBHCurve Frequency=28.5kHz
reports:
  L Table 1: Matrix1.L(Np,Np), Matrix1.L(Ns,Np), Matrix1.L(Np,Ns), Matrix1.L(Ns,Ns), Matrix1.R(Np,Np), Matrix1.R(Ns,Np), Matrix1.R(Np,Ns), Matrix1.R(Ns,Ns) vs Freq on Setup1 : LastAdaptive

design Flatwise_0.25_interleaved_full (Maxwell 3D, EddyCurrent, model units mm)
variables:
  freq_hz = 28500Hz
  volt_ac = 141/28500*Freq
geometry:
  Region [vacuum] = region(percentage_offset=0 on all sides)
  Np1..Np8, Ns1..Ns8 [copper] = imported_body(C:\Users\karlr\Documents\ICMaSS_sweeping\flatwise_0.1_0.25.step)
  plate_1, plate_2 [silicon - Copy] = imported_body(C:\Users\karlr\Documents\ICMaSS_sweeping\flatwise_0.1_0.25.step)
  Body1 [ferrite - Copy (2)] = imported_body(C:\Users\karlr\Documents\ICMaSS_sweeping\flatwise_0.1_0.25.step)
  Body1_1, Body1_2 [aluminum] = imported_body(C:\Users\karlr\Documents\ICMaSS_sweeping\flatwise_0.1_0.25.step)
  Body1_3 [ferrite - Copy (2)] = imported_body(C:\Users\karlr\Documents\ICMaSS_sweeping\flatwise_0.1_0.25.step)
  Body1_4, Body1_5 [aluminum] = imported_body(C:\Users\karlr\Documents\ICMaSS_sweeping\flatwise_0.1_0.25.step)
  Np1_Section1 = Np1.section(plane=ZX)
  Np2_Section1 = Np2.section(plane=ZX)
  Np3_Section1 [copper] = Np3.section(plane=ZX)
  Np4_Section1 [copper] = Np4.section(plane=ZX)
  Np5_Section1 [copper] = Np5.section(plane=ZX)
  Np6_Section1 [copper] = Np6.section(plane=ZX)
  Np7_Section1 [copper] = Np7.section(plane=ZX)
  Np8_Section1 [copper] = Np8.section(plane=ZX)
  Ns1_Section1 = Ns1.section(plane=ZX)
  Ns2_Section1 = Ns2.section(plane=ZX)
  Ns3_Section1 [copper] = Ns3.section(plane=ZX)
  Ns4_Section1 [copper] = Ns4.section(plane=ZX)
  Ns5_Section1 [copper] = Ns5.section(plane=ZX)
  Ns6_Section1 [copper] = Ns6.section(plane=ZX)
  Ns7_Section1 [copper] = Ns7.section(plane=ZX)
  Ns8_Section1 [copper] = Ns8.section(plane=ZX)
  Np1_Section1_Separate1 [copper] = Np1_Section1.separate_bodies()
  Np1_Section1.delete()
  Np2_Section1_Separate1 [copper] = Np2_Section1.separate_bodies()
  Np2_Section1.delete()
  Np3_Section1.separate_bodies()
  Np4_Section1.separate_bodies()
  Np5_Section1.separate_bodies()
  Np6_Section1.separate_bodies()
  Np7_Section1.separate_bodies()
  Np8_Section1.separate_bodies()
  Ns1_Section1_Separate1 [copper] = Ns1_Section1.separate_bodies()
  Ns1_Section1.delete()
  Ns2_Section1_Separate1 [copper] = Ns2_Section1.separate_bodies()
  Ns2_Section1.delete()
  Ns3_Section1.separate_bodies()
  Ns4_Section1.separate_bodies()
  Ns5_Section1.separate_bodies()
  Ns6_Section1.separate_bodies()
  Ns7_Section1.separate_bodies()
  Ns8_Section1.separate_bodies()
  group core_assembled_flatwise = Np1..Np8, Ns1..Ns8, plate_1, plate_2, Np3_Section1, Np4_Section1, Np5_Section1, Np6_Section1, Np7_Section1, Np8_Section1, Ns3_Section1, Ns4_Section1, Ns5_Section1, Ns6_Section1, Ns7_Section1, Ns8_Section1, Np1_Section1_Separate1, Np2_Section1_Separate1, Ns1_Section1_Separate1, Ns2_Section1_Separate1
  group core_together_1 = Body1, Body1_1, Body1_2
  group core_together = Body1_3, Body1_4, Body1_5
boundaries and excitations:
  Ns_1: Coil Terminal Objects=Ns1_Section1_Separate1 Conductor_number=1 Winding=Ns Point_out_of_terminal=true
  Ns_2: Coil Terminal Objects=Ns2_Section1_Separate1 Conductor_number=1 Winding=Ns Point_out_of_terminal=true
  Ns_3: Coil Terminal Objects=Ns3_Section1 Conductor_number=1 Winding=Ns Point_out_of_terminal=true
  Ns_4: Coil Terminal Objects=Ns4_Section1 Conductor_number=1 Winding=Ns Point_out_of_terminal=true
  Ns_5: Coil Terminal Objects=Ns5_Section1 Conductor_number=1 Winding=Ns Point_out_of_terminal=true
  Ns_6: Coil Terminal Objects=Ns6_Section1 Conductor_number=1 Winding=Ns Point_out_of_terminal=true
  Ns_7: Coil Terminal Objects=Ns7_Section1 Conductor_number=1 Winding=Ns Point_out_of_terminal=true
  Ns_8: Coil Terminal Objects=Ns8_Section1 Conductor_number=1 Winding=Ns Point_out_of_terminal=true
  Np_1: Coil Terminal Objects=Np1_Section1_Separate1 Conductor_number=1 Winding=Np Point_out_of_terminal=false
  Np_2: Coil Terminal Objects=Np2_Section1_Separate1 Conductor_number=1 Winding=Np Point_out_of_terminal=false
  Np_3: Coil Terminal Objects=Np3_Section1 Conductor_number=1 Winding=Np Point_out_of_terminal=false
  Np_4: Coil Terminal Objects=Np4_Section1 Conductor_number=1 Winding=Np Point_out_of_terminal=false
  Np_5: Coil Terminal Objects=Np5_Section1 Conductor_number=1 Winding=Np Point_out_of_terminal=false
  Np_6: Coil Terminal Objects=Np6_Section1 Conductor_number=1 Winding=Np Point_out_of_terminal=false
  Np_7: Coil Terminal Objects=Np7_Section1 Conductor_number=1 Winding=Np Point_out_of_terminal=false
  Np_8: Coil Terminal Objects=Np8_Section1 Conductor_number=1 Winding=Np Point_out_of_terminal=false
  Np: Winding Group Type=Voltage IsSolid=true Current=16.36A Resistance=0ohm Inductance=0nH Voltage=volt_ac ParallelBranchesNum=1 Phase=0rad
  Ns: Winding Group Type=Current IsSolid=true Current=1000*1.41/volt_ac*1.414 ParallelBranchesNum=1 Phase=0.1522rad
parameters:
  Matrix1: Matrix Np, Ns:
mesh:
  Length1: LengthBased Objects=[Body1, Body1_1..Body1_5] MaxLength=5mm
  Length2: LengthBased Objects=[Np1..Np8, Ns1..Ns8, plate_1, plate_2] MaxLength=2mm
  initial mesh: GlobalSurfApproximation{CurvedSurfaceApproxChoice=UseSlider SliderMeshSettings=9} GlobalCurvilinear{Apply}
setups:
  Setup1: EddyCurrent MaximumPasses=20 MinimumPasses=2 MinimumConvergedPasses=1 PercentRefinement=30 PercentError=1 NonLinearResidual=0.0001 SmoothBHCurve Frequency=28.5kHz SweepRanges{0.1Hz to 1Hz, log, 10 per decade 1Hz to 1000Hz, log, 10 per decade 1000Hz to 10000Hz, log, 10 per decade 10000Hz to 100000Hz, log, 10 per decade 100000Hz to 1000000Hz, log, 10 per decade 1000000Hz to 10000000Hz, log, 10 per decade} SaveAllFields
reports:
  L Table 1: Matrix1.L(Np,Np), Matrix1.L(Ns,Np), Matrix1.L(Np,Ns), Matrix1.L(Ns,Ns), Matrix1.R(Np,Np), Matrix1.R(Ns,Np), Matrix1.R(Np,Ns), Matrix1.R(Ns,Ns) vs Freq on Setup1 : LastAdaptive

design Flatwise_0.30_interleaved_full (Maxwell 3D, EddyCurrent, model units mm)
variables:
  freq_hz = 28500Hz
  volt_ac = 141/28500*Freq
geometry:
  Region [vacuum] = region(percentage_offset=0 on all sides)
  Np1..Np8, Ns1..Ns8 [copper] = imported_body(C:\Users\karlr\Documents\ICMaSS_sweeping\flatwise_0.1_0.3.step)
  plate_1, plate_2 [silicon - Copy] = imported_body(C:\Users\karlr\Documents\ICMaSS_sweeping\flatwise_0.1_0.3.step)
  Body1 [ferrite - Copy (2)] = imported_body(C:\Users\karlr\Documents\ICMaSS_sweeping\flatwise_0.1_0.3.step)
  Body1_1, Body1_2 [aluminum] = imported_body(C:\Users\karlr\Documents\ICMaSS_sweeping\flatwise_0.1_0.3.step)
  Body1_3 [ferrite - Copy (2)] = imported_body(C:\Users\karlr\Documents\ICMaSS_sweeping\flatwise_0.1_0.3.step)
  Body1_4, Body1_5 [aluminum] = imported_body(C:\Users\karlr\Documents\ICMaSS_sweeping\flatwise_0.1_0.3.step)
  Np1_Section1 = Np1.section(plane=ZX)
  Np2_Section1 = Np2.section(plane=ZX)
  Np3_Section1 [copper] = Np3.section(plane=ZX)
  Np4_Section1 [copper] = Np4.section(plane=ZX)
  Np5_Section1 [copper] = Np5.section(plane=ZX)
  Np6_Section1 [copper] = Np6.section(plane=ZX)
  Np7_Section1 [copper] = Np7.section(plane=ZX)
  Np8_Section1 [copper] = Np8.section(plane=ZX)
  Ns1_Section1 = Ns1.section(plane=ZX)
  Ns2_Section1 = Ns2.section(plane=ZX)
  Ns3_Section1 [copper] = Ns3.section(plane=ZX)
  Ns4_Section1 [copper] = Ns4.section(plane=ZX)
  Ns5_Section1 [copper] = Ns5.section(plane=ZX)
  Ns6_Section1 [copper] = Ns6.section(plane=ZX)
  Ns7_Section1 [copper] = Ns7.section(plane=ZX)
  Ns8_Section1 [copper] = Ns8.section(plane=ZX)
  Np1_Section1_Separate1 [copper] = Np1_Section1.separate_bodies()
  Np1_Section1.delete()
  Np2_Section1_Separate1 [copper] = Np2_Section1.separate_bodies()
  Np2_Section1.delete()
  Np3_Section1.separate_bodies()
  Np4_Section1.separate_bodies()
  Np5_Section1.separate_bodies()
  Np6_Section1.separate_bodies()
  Np7_Section1.separate_bodies()
  Np8_Section1.separate_bodies()
  Ns1_Section1_Separate1 [copper] = Ns1_Section1.separate_bodies()
  Ns1_Section1.delete()
  Ns2_Section1_Separate1 [copper] = Ns2_Section1.separate_bodies()
  Ns2_Section1.delete()
  Ns3_Section1.separate_bodies()
  Ns4_Section1.separate_bodies()
  Ns5_Section1.separate_bodies()
  Ns6_Section1.separate_bodies()
  Ns7_Section1.separate_bodies()
  Ns8_Section1.separate_bodies()
  Rectangle1 [non-model] = rectangle(corner=(36.6mm, 25.43mm, 1.6666608e-08mm), z_size=18.666667mm, x_size=-36.6mm)
  group core_assembled_flatwise = Np1..Np8, Ns1..Ns8, plate_1, plate_2, Np3_Section1, Np4_Section1, Np5_Section1, Np6_Section1, Np7_Section1, Np8_Section1, Ns3_Section1, Ns4_Section1, Ns5_Section1, Ns6_Section1, Ns7_Section1, Ns8_Section1, Np1_Section1_Separate1, Np2_Section1_Separate1, Ns1_Section1_Separate1, Ns2_Section1_Separate1
  group core_together_1 = Body1, Body1_1, Body1_2
  group core_together = Body1_3, Body1_4, Body1_5
boundaries and excitations:
  Ns_1: Coil Terminal Objects=Ns1_Section1_Separate1 Conductor_number=1 Winding=Ns Point_out_of_terminal=true
  Ns_2: Coil Terminal Objects=Ns2_Section1_Separate1 Conductor_number=1 Winding=Ns Point_out_of_terminal=true
  Ns_3: Coil Terminal Objects=Ns3_Section1 Conductor_number=1 Winding=Ns Point_out_of_terminal=true
  Ns_4: Coil Terminal Objects=Ns4_Section1 Conductor_number=1 Winding=Ns Point_out_of_terminal=true
  Ns_5: Coil Terminal Objects=Ns5_Section1 Conductor_number=1 Winding=Ns Point_out_of_terminal=true
  Ns_6: Coil Terminal Objects=Ns6_Section1 Conductor_number=1 Winding=Ns Point_out_of_terminal=true
  Ns_7: Coil Terminal Objects=Ns7_Section1 Conductor_number=1 Winding=Ns Point_out_of_terminal=true
  Ns_8: Coil Terminal Objects=Ns8_Section1 Conductor_number=1 Winding=Ns Point_out_of_terminal=true
  Np_1: Coil Terminal Objects=Np1_Section1_Separate1 Conductor_number=1 Winding=Np Point_out_of_terminal=false
  Np_2: Coil Terminal Objects=Np2_Section1_Separate1 Conductor_number=1 Winding=Np Point_out_of_terminal=false
  Np_3: Coil Terminal Objects=Np3_Section1 Conductor_number=1 Winding=Np Point_out_of_terminal=false
  Np_4: Coil Terminal Objects=Np4_Section1 Conductor_number=1 Winding=Np Point_out_of_terminal=false
  Np_5: Coil Terminal Objects=Np5_Section1 Conductor_number=1 Winding=Np Point_out_of_terminal=false
  Np_6: Coil Terminal Objects=Np6_Section1 Conductor_number=1 Winding=Np Point_out_of_terminal=false
  Np_7: Coil Terminal Objects=Np7_Section1 Conductor_number=1 Winding=Np Point_out_of_terminal=false
  Np_8: Coil Terminal Objects=Np8_Section1 Conductor_number=1 Winding=Np Point_out_of_terminal=false
  Np: Winding Group Type=Voltage IsSolid=true Current=16.36A Resistance=0ohm Inductance=0nH Voltage=volt_ac ParallelBranchesNum=1 Phase=0rad
  Ns: Winding Group Type=Current IsSolid=true Current=1000*1.41/volt_ac*1.414 ParallelBranchesNum=1 Phase=0.1522rad
  core loss on: Body1, Body1_3
parameters:
  Matrix1: Matrix Np, Ns:
mesh:
  Length1: LengthBased Objects=[Body1, Body1_1..Body1_5] MaxLength=5mm
  Length2: LengthBased Objects=[Np1..Np8, Ns1..Ns8, plate_1, plate_2] MaxLength=2mm
  initial mesh: GlobalSurfApproximation{CurvedSurfaceApproxChoice=UseSlider SliderMeshSettings=9} GlobalCurvilinear{Apply}
setups:
  Setup1: EddyCurrent MaximumPasses=20 MinimumPasses=2 MinimumConvergedPasses=1 PercentRefinement=30 PercentError=1 NonLinearResidual=0.0001 SmoothBHCurve Frequency=28.5kHz
field plots:
  Mag_B1: B over a plane on Setup1 : LastAdaptive at Freq=28.5kHz Phase=45deg
  Mesh1: MeshPlots in Np1..Np8, Ns1..Ns8 on Setup1 : LastAdaptive at Freq=28.5kHz Phase=0deg
  Mesh2: MeshPlots over a plane on Setup1 : LastAdaptive at Freq=28.5kHz Phase=0deg
  Mag_J1, Mag_J2: J over Np1_Section1_Separate1.face Np2_Section1_Separate1.face Np3_Section1.face Np4_Section1.face Np5_Section1.face Np6_Section1.face Np7_Section1.face Np8_Section1.face Ns1_Section1_Separate1.face Ns2_Section1_Separate1.face Ns3_Section1.face Ns4_Section1.face Ns5_Section1.face Ns6_Section1.face Ns7_Section1.face Ns8_Section1.face on Setup1 : LastAdaptive at Freq=28.5kHz Phase=45deg
  Mag_B2: B over Body1_3, Body1 on Setup1 : LastAdaptive at Freq=28.5kHz Phase=45deg
  Mag_J3: J over Np1..Np8, Ns1..Ns8 on Setup1 : LastAdaptive at Freq=28.5kHz Phase=45deg
reports:
  L Table 1: Matrix1.L(Np,Np), Matrix1.L(Ns,Np), Matrix1.L(Np,Ns), Matrix1.L(Ns,Ns), Matrix1.R(Np,Np), Matrix1.R(Ns,Np), Matrix1.R(Np,Ns), Matrix1.R(Ns,Ns) vs Freq on Setup1 : LastAdaptive

design Flatwise_0.40_interleaved_full (Maxwell 3D, EddyCurrent, model units mm)
variables:
  freq_hz = 28500Hz
  volt_ac = 141/28500*Freq
geometry:
  Region [vacuum] = region(percentage_offset=0 on all sides)
  Np1..Np8, Ns1..Ns8 [copper] = imported_body(C:\Users\karlr\Documents\ICMaSS_sweeping\flatwise_0.1_0.4.step)
  plate_1, plate_2 [silicon - Copy] = imported_body(C:\Users\karlr\Documents\ICMaSS_sweeping\flatwise_0.1_0.4.step)
  Body1 [ferrite - Copy (2)] = imported_body(C:\Users\karlr\Documents\ICMaSS_sweeping\flatwise_0.1_0.4.step)
  Body1_1, Body1_2 [aluminum] = imported_body(C:\Users\karlr\Documents\ICMaSS_sweeping\flatwise_0.1_0.4.step)
  Body1_3 [ferrite - Copy (2)] = imported_body(C:\Users\karlr\Documents\ICMaSS_sweeping\flatwise_0.1_0.4.step)
  Body1_4, Body1_5 [aluminum] = imported_body(C:\Users\karlr\Documents\ICMaSS_sweeping\flatwise_0.1_0.4.step)
  Ns8_Section1 [copper] = Ns8.section(plane=ZX)
  Np1_Section1 = Np1.section(plane=ZX)
  Np2_Section1 = Np2.section(plane=ZX)
  Np3_Section1 [copper] = Np3.section(plane=ZX)
  Np4_Section1 [copper] = Np4.section(plane=ZX)
  Np5_Section1 [copper] = Np5.section(plane=ZX)
  Np6_Section1 [copper] = Np6.section(plane=ZX)
  Np7_Section1 [copper] = Np7.section(plane=ZX)
  Np8_Section1 [copper] = Np8.section(plane=ZX)
  Ns1_Section1 = Ns1.section(plane=ZX)
  Ns2_Section1 = Ns2.section(plane=ZX)
  Ns3_Section1 [copper] = Ns3.section(plane=ZX)
  Ns4_Section1 [copper] = Ns4.section(plane=ZX)
  Ns5_Section1 [copper] = Ns5.section(plane=ZX)
  Ns6_Section1 [copper] = Ns6.section(plane=ZX)
  Ns7_Section1 [copper] = Ns7.section(plane=ZX)
  Ns8_Section1.separate_bodies()
  Np1_Section1_Separate1 [copper] = Np1_Section1.separate_bodies()
  Np1_Section1.delete()
  Np2_Section1_Separate1 [copper] = Np2_Section1.separate_bodies()
  Np2_Section1.delete()
  Np3_Section1.separate_bodies()
  Np4_Section1.separate_bodies()
  Np5_Section1.separate_bodies()
  Np6_Section1.separate_bodies()
  Np7_Section1.separate_bodies()
  Np8_Section1.separate_bodies()
  Ns1_Section1_Separate1 [copper] = Ns1_Section1.separate_bodies()
  Ns1_Section1.delete()
  Ns2_Section1_Separate1 [copper] = Ns2_Section1.separate_bodies()
  Ns2_Section1.delete()
  Ns3_Section1.separate_bodies()
  Ns4_Section1.separate_bodies()
  Ns5_Section1.separate_bodies()
  Ns6_Section1.separate_bodies()
  Ns7_Section1.separate_bodies()
  group core_assembled_flatwise = Np1..Np8, Ns1..Ns8, plate_1, plate_2, Ns8_Section1, Np3_Section1, Np4_Section1, Np5_Section1, Np6_Section1, Np7_Section1, Np8_Section1, Ns3_Section1, Ns4_Section1, Ns5_Section1, Ns6_Section1, Ns7_Section1, Np1_Section1_Separate1, Np2_Section1_Separate1, Ns1_Section1_Separate1, Ns2_Section1_Separate1
  group core_together_1 = Body1, Body1_1, Body1_2
  group core_together = Body1_3, Body1_4, Body1_5
boundaries and excitations:
  Np_1: Coil Terminal Objects=Np8_Section1 Conductor_number=1 Winding=Np Point_out_of_terminal=false
  Np_2: Coil Terminal Objects=Np1_Section1_Separate1 Conductor_number=1 Winding=Np Point_out_of_terminal=false
  Np_3: Coil Terminal Objects=Np2_Section1_Separate1 Conductor_number=1 Winding=Np Point_out_of_terminal=false
  Np_4: Coil Terminal Objects=Np3_Section1 Conductor_number=1 Winding=Np Point_out_of_terminal=false
  Np_5: Coil Terminal Objects=Np4_Section1 Conductor_number=1 Winding=Np Point_out_of_terminal=false
  Np_6: Coil Terminal Objects=Np5_Section1 Conductor_number=1 Winding=Np Point_out_of_terminal=false
  Np_7: Coil Terminal Objects=Np6_Section1 Conductor_number=1 Winding=Np Point_out_of_terminal=false
  Np_8: Coil Terminal Objects=Np7_Section1 Conductor_number=1 Winding=Np Point_out_of_terminal=false
  Ns_1: Coil Terminal Objects=Ns1_Section1_Separate1 Conductor_number=1 Winding=Ns Point_out_of_terminal=true
  Ns_2: Coil Terminal Objects=Ns2_Section1_Separate1 Conductor_number=1 Winding=Ns Point_out_of_terminal=true
  Ns_3: Coil Terminal Objects=Ns3_Section1 Conductor_number=1 Winding=Ns Point_out_of_terminal=true
  Ns_4: Coil Terminal Objects=Ns4_Section1 Conductor_number=1 Winding=Ns Point_out_of_terminal=true
  Ns_5: Coil Terminal Objects=Ns5_Section1 Conductor_number=1 Winding=Ns Point_out_of_terminal=true
  Ns_6: Coil Terminal Objects=Ns6_Section1 Conductor_number=1 Winding=Ns Point_out_of_terminal=true
  Ns_7: Coil Terminal Objects=Ns7_Section1 Conductor_number=1 Winding=Ns Point_out_of_terminal=true
  Ns_8: Coil Terminal Objects=Ns8_Section1 Conductor_number=1 Winding=Ns Point_out_of_terminal=true
  Np: Winding Group Type=Voltage IsSolid=true Current=16.36A Resistance=0ohm Inductance=0nH Voltage=volt_ac ParallelBranchesNum=1 Phase=0rad
  Ns: Winding Group Type=Current IsSolid=true Current=1000*1.41/volt_ac*1.414 ParallelBranchesNum=1 Phase=0.1522rad
  core loss on: Body1, Body1_3
parameters:
  Matrix1: Matrix Np, Ns:
mesh:
  Length1: LengthBased Objects=[Np1..Np8, Ns1..Ns8, plate_1, plate_2] MaxLength=2mm
  Length2: LengthBased Objects=[Body1, Body1_1..Body1_5] MaxLength=5mm
  initial mesh: GlobalSurfApproximation{CurvedSurfaceApproxChoice=UseSlider SliderMeshSettings=9} GlobalCurvilinear{Apply}
setups:
  Setup1: EddyCurrent MaximumPasses=20 MinimumPasses=2 MinimumConvergedPasses=1 PercentRefinement=30 PercentError=1 NonLinearResidual=0.0001 SmoothBHCurve Frequency=28.5kHz SweepRanges{0.1Hz to 1Hz, log, 10 per decade 1Hz to 1000Hz, log, 10 per decade 1000Hz to 10000Hz, log, 10 per decade 10000Hz to 100000Hz, log, 10 per decade 100000Hz to 1000000Hz, log, 10 per decade 1000000Hz to 10000000Hz, log, 10 per decade} SaveAllFields
reports:
  L Table 1: Matrix1.L(Np,Np), Matrix1.L(Ns,Np), Matrix1.L(Np,Ns), Matrix1.L(Ns,Ns), Matrix1.R(Np,Np), Matrix1.R(Ns,Np), Matrix1.R(Np,Ns), Matrix1.R(Ns,Ns) vs Freq on Setup1 : LastAdaptive

design Flatwise_0.50_interleaved_full (Maxwell 3D, EddyCurrent, model units mm)
variables:
  freq_hz = 28500Hz
  volt_ac = 141/28500*Freq
geometry:
  Region [vacuum] = region(percentage_offset=0 on all sides)
  Np1..Np8, Ns1..Ns8 [copper] = imported_body(C:\Users\karlr\Documents\ICMaSS_sweeping\flatwise_0.1_0.5.step)
  plate_1, plate_2 [silicon - Copy] = imported_body(C:\Users\karlr\Documents\ICMaSS_sweeping\flatwise_0.1_0.5.step)
  Body1 [ferrite - Copy (2)] = imported_body(C:\Users\karlr\Documents\ICMaSS_sweeping\flatwise_0.1_0.5.step)
  Body1_1, Body1_2 [aluminum] = imported_body(C:\Users\karlr\Documents\ICMaSS_sweeping\flatwise_0.1_0.5.step)
  Body1_3 [ferrite - Copy (2)] = imported_body(C:\Users\karlr\Documents\ICMaSS_sweeping\flatwise_0.1_0.5.step)
  Body1_4, Body1_5 [aluminum] = imported_body(C:\Users\karlr\Documents\ICMaSS_sweeping\flatwise_0.1_0.5.step)
  Np1_Section1 = Np1.section(plane=ZX)
  Np2_Section1 = Np2.section(plane=ZX)
  Np3_Section1 [copper] = Np3.section(plane=ZX)
  Np4_Section1 [copper] = Np4.section(plane=ZX)
  Np5_Section1 [copper] = Np5.section(plane=ZX)
  Np6_Section1 [copper] = Np6.section(plane=ZX)
  Np7_Section1 [copper] = Np7.section(plane=ZX)
  Np8_Section1 [copper] = Np8.section(plane=ZX)
  Ns1_Section1 = Ns1.section(plane=ZX)
  Ns2_Section1 = Ns2.section(plane=ZX)
  Ns3_Section1 [copper] = Ns3.section(plane=ZX)
  Ns4_Section1 [copper] = Ns4.section(plane=ZX)
  Ns5_Section1 [copper] = Ns5.section(plane=ZX)
  Ns6_Section1 [copper] = Ns6.section(plane=ZX)
  Ns7_Section1 [copper] = Ns7.section(plane=ZX)
  Ns8_Section1 [copper] = Ns8.section(plane=ZX)
  Np1_Section1_Separate1 [copper] = Np1_Section1.separate_bodies()
  Np1_Section1.delete()
  Np2_Section1_Separate1 [copper] = Np2_Section1.separate_bodies()
  Np2_Section1.delete()
  Np3_Section1.separate_bodies()
  Np4_Section1.separate_bodies()
  Np5_Section1.separate_bodies()
  Np6_Section1.separate_bodies()
  Np7_Section1.separate_bodies()
  Np8_Section1.separate_bodies()
  Ns1_Section1_Separate1 [copper] = Ns1_Section1.separate_bodies()
  Ns1_Section1.delete()
  Ns2_Section1_Separate1 [copper] = Ns2_Section1.separate_bodies()
  Ns2_Section1.delete()
  Ns3_Section1.separate_bodies()
  Ns4_Section1.separate_bodies()
  Ns5_Section1.separate_bodies()
  Ns6_Section1.separate_bodies()
  Ns7_Section1.separate_bodies()
  Ns8_Section1.separate_bodies()
  Rectangle1 [non-model] = rectangle(corner=(6mm, -10.5mm, 8mm), x_size=31mm, y_size=72.12mm)
  group core_assembled_flatwise = Np1..Np8, Ns1..Ns8, plate_1, plate_2, Np3_Section1, Np4_Section1, Np5_Section1, Np6_Section1, Np7_Section1, Np8_Section1, Ns3_Section1, Ns4_Section1, Ns5_Section1, Ns6_Section1, Ns7_Section1, Ns8_Section1, Np1_Section1_Separate1, Np2_Section1_Separate1, Ns1_Section1_Separate1, Ns2_Section1_Separate1
  group core_together_1 = Body1, Body1_1, Body1_2
  group core_together = Body1_3, Body1_4, Body1_5
boundaries and excitations:
  Ns_1: Coil Terminal Objects=Ns8_Section1 Conductor_number=1 Winding=Ns Point_out_of_terminal=true
  Ns_2: Coil Terminal Objects=Ns1_Section1_Separate1 Conductor_number=1 Winding=Ns Point_out_of_terminal=true
  Ns_3: Coil Terminal Objects=Ns2_Section1_Separate1 Conductor_number=1 Winding=Ns Point_out_of_terminal=true
  Ns_4: Coil Terminal Objects=Ns3_Section1 Conductor_number=1 Winding=Ns Point_out_of_terminal=true
  Ns_5: Coil Terminal Objects=Ns4_Section1 Conductor_number=1 Winding=Ns Point_out_of_terminal=true
  Ns_6: Coil Terminal Objects=Ns5_Section1 Conductor_number=1 Winding=Ns Point_out_of_terminal=true
  Ns_7: Coil Terminal Objects=Ns6_Section1 Conductor_number=1 Winding=Ns Point_out_of_terminal=true
  Ns_8: Coil Terminal Objects=Ns7_Section1 Conductor_number=1 Winding=Ns Point_out_of_terminal=true
  Np_1: Coil Terminal Objects=Np1_Section1_Separate1 Conductor_number=1 Winding=Np Point_out_of_terminal=false
  Np_2: Coil Terminal Objects=Np2_Section1_Separate1 Conductor_number=1 Winding=Np Point_out_of_terminal=false
  Np_3: Coil Terminal Objects=Np3_Section1 Conductor_number=1 Winding=Np Point_out_of_terminal=false
  Np_4: Coil Terminal Objects=Np4_Section1 Conductor_number=1 Winding=Np Point_out_of_terminal=false
  Np_5: Coil Terminal Objects=Np5_Section1 Conductor_number=1 Winding=Np Point_out_of_terminal=false
  Np_6: Coil Terminal Objects=Np6_Section1 Conductor_number=1 Winding=Np Point_out_of_terminal=false
  Np_7: Coil Terminal Objects=Np7_Section1 Conductor_number=1 Winding=Np Point_out_of_terminal=false
  Np_8: Coil Terminal Objects=Np8_Section1 Conductor_number=1 Winding=Np Point_out_of_terminal=false
  Np: Winding Group Type=Current IsSolid=true Current=1000*1.41/volt_ac*1.414 ParallelBranchesNum=1 Phase=0rad
  Ns: Winding Group Type=Current IsSolid=true Current=1000*1.41/volt_ac*1.414 ParallelBranchesNum=1 Phase=0.1522rad
  core loss on: Body1, Body1_3
parameters:
  Matrix1: Matrix Np, Ns:
mesh:
  Length1: LengthBased Objects=[Np1..Np8, Ns1..Ns8, plate_1, plate_2] MaxLength=2mm
  Length2: LengthBased Objects=[Body1, Body1_1..Body1_5] MaxLength=5mm
  initial mesh: GlobalSurfApproximation{CurvedSurfaceApproxChoice=UseSlider SliderMeshSettings=9} GlobalCurvilinear{Apply}
setups:
  Setup1: EddyCurrent MaximumPasses=20 MinimumPasses=2 MinimumConvergedPasses=1 PercentRefinement=30 PercentError=1 NonLinearResidual=0.0001 SmoothBHCurve Frequency=28.5kHz
  Setup2: EddyCurrent MaximumPasses=10 MinimumPasses=2 MinimumConvergedPasses=1 PercentRefinement=30 PercentError=1 NonLinearResidual=0.0001 Frequency=1Hz
field plots:
  Mag_J1: J over a plane on Setup1 : LastAdaptive at Freq=28.5kHz Phase=45deg
reports:
  L Table 1: Matrix1.L(Np,Np), Matrix1.L(Ns,Np), Matrix1.L(Np,Ns), Matrix1.L(Ns,Ns), Matrix1.R(Np,Np), Matrix1.R(Ns,Np), Matrix1.R(Np,Ns), Matrix1.R(Ns,Ns) vs Freq on Setup1 : LastAdaptive

design Flatwise_0.30_interleaved_full1 (Maxwell 3D, EddyCurrent, model units mm)
variables:
  freq_hz = 28500Hz
  volt_ac = 141/28500*Freq
geometry:
  Region [vacuum] = region(percentage_offset=0 on all sides)
  Np1..Np8, Ns1..Ns8 [copper] = imported_body(C:\Users\karlr\Documents\ICMaSS_sweeping\flatwise_0.1_0.3.step)
  plate_1, plate_2 [silicon - Copy] = imported_body(C:\Users\karlr\Documents\ICMaSS_sweeping\flatwise_0.1_0.3.step)
  Body1 [ferrite - Copy (2)] = imported_body(C:\Users\karlr\Documents\ICMaSS_sweeping\flatwise_0.1_0.3.step)
  Body1_1, Body1_2 [aluminum] = imported_body(C:\Users\karlr\Documents\ICMaSS_sweeping\flatwise_0.1_0.3.step)
  Body1_3 [ferrite - Copy (2)] = imported_body(C:\Users\karlr\Documents\ICMaSS_sweeping\flatwise_0.1_0.3.step)
  Body1_4, Body1_5 [aluminum] = imported_body(C:\Users\karlr\Documents\ICMaSS_sweeping\flatwise_0.1_0.3.step)
  Np1_Section1 = Np1.section(plane=ZX)
  Np2_Section1 = Np2.section(plane=ZX)
  Np3_Section1 [copper] = Np3.section(plane=ZX)
  Np4_Section1 [copper] = Np4.section(plane=ZX)
  Np5_Section1 [copper] = Np5.section(plane=ZX)
  Np6_Section1 [copper] = Np6.section(plane=ZX)
  Np7_Section1 [copper] = Np7.section(plane=ZX)
  Np8_Section1 [copper] = Np8.section(plane=ZX)
  Ns1_Section1 = Ns1.section(plane=ZX)
  Ns2_Section1 = Ns2.section(plane=ZX)
  Ns3_Section1 [copper] = Ns3.section(plane=ZX)
  Ns4_Section1 [copper] = Ns4.section(plane=ZX)
  Ns5_Section1 [copper] = Ns5.section(plane=ZX)
  Ns6_Section1 [copper] = Ns6.section(plane=ZX)
  Ns7_Section1 [copper] = Ns7.section(plane=ZX)
  Ns8_Section1 [copper] = Ns8.section(plane=ZX)
  Np1_Section1_Separate1 [copper] = Np1_Section1.separate_bodies()
  Np1_Section1.delete()
  Np2_Section1_Separate1 [copper] = Np2_Section1.separate_bodies()
  Np2_Section1.delete()
  Np3_Section1.separate_bodies()
  Np4_Section1.separate_bodies()
  Np5_Section1.separate_bodies()
  Np6_Section1.separate_bodies()
  Np7_Section1.separate_bodies()
  Np8_Section1.separate_bodies()
  Ns1_Section1_Separate1 [copper] = Ns1_Section1.separate_bodies()
  Ns1_Section1.delete()
  Ns2_Section1_Separate1 [copper] = Ns2_Section1.separate_bodies()
  Ns2_Section1.delete()
  Ns3_Section1.separate_bodies()
  Ns4_Section1.separate_bodies()
  Ns5_Section1.separate_bodies()
  Ns6_Section1.separate_bodies()
  Ns7_Section1.separate_bodies()
  Ns8_Section1.separate_bodies()
  [Np1..Np8, Ns1..Ns8, plate_1, plate_2, Body1, Body1_1..Body1_5, Np3_Section1, Np4_Section1, Np5_Section1, Np6_Section1, Np7_Section1, Np8_Section1, Ns3_Section1, Ns4_Section1, Ns5_Section1, Ns6_Section1, Ns7_Section1, Ns8_Section1, Np1_Section1_Separate1, Np2_Section1_Separate1, Ns1_Section1_Separate1, Ns2_Section1_Separate1].move(-18.3mm, -25.43mm, -9.2833333mm)
  group core_assembled_flatwise = Np1..Np8, Ns1..Ns8, plate_1, plate_2, Np3_Section1, Np4_Section1, Np5_Section1, Np6_Section1, Np7_Section1, Np8_Section1, Ns3_Section1, Ns4_Section1, Ns5_Section1, Ns6_Section1, Ns7_Section1, Ns8_Section1, Np1_Section1_Separate1, Np2_Section1_Separate1, Ns1_Section1_Separate1, Ns2_Section1_Separate1
  group core_together_1 = Body1, Body1_1, Body1_2
  group core_together = Body1_3, Body1_4, Body1_5
boundaries and excitations:
  Ns_1: Coil Terminal Objects=Ns1_Section1_Separate1 Conductor_number=1 Winding=Ns Point_out_of_terminal=true
  Ns_2: Coil Terminal Objects=Ns2_Section1_Separate1 Conductor_number=1 Winding=Ns Point_out_of_terminal=true
  Ns_3: Coil Terminal Objects=Ns3_Section1 Conductor_number=1 Winding=Ns Point_out_of_terminal=true
  Ns_4: Coil Terminal Objects=Ns4_Section1 Conductor_number=1 Winding=Ns Point_out_of_terminal=true
  Ns_5: Coil Terminal Objects=Ns5_Section1 Conductor_number=1 Winding=Ns Point_out_of_terminal=true
  Ns_6: Coil Terminal Objects=Ns6_Section1 Conductor_number=1 Winding=Ns Point_out_of_terminal=true
  Ns_7: Coil Terminal Objects=Ns7_Section1 Conductor_number=1 Winding=Ns Point_out_of_terminal=true
  Ns_8: Coil Terminal Objects=Ns8_Section1 Conductor_number=1 Winding=Ns Point_out_of_terminal=true
  Np_1: Coil Terminal Objects=Np1_Section1_Separate1 Conductor_number=1 Winding=Np Point_out_of_terminal=false
  Np_2: Coil Terminal Objects=Np2_Section1_Separate1 Conductor_number=1 Winding=Np Point_out_of_terminal=false
  Np_3: Coil Terminal Objects=Np3_Section1 Conductor_number=1 Winding=Np Point_out_of_terminal=false
  Np_4: Coil Terminal Objects=Np4_Section1 Conductor_number=1 Winding=Np Point_out_of_terminal=false
  Np_5: Coil Terminal Objects=Np5_Section1 Conductor_number=1 Winding=Np Point_out_of_terminal=false
  Np_6: Coil Terminal Objects=Np6_Section1 Conductor_number=1 Winding=Np Point_out_of_terminal=false
  Np_7: Coil Terminal Objects=Np7_Section1 Conductor_number=1 Winding=Np Point_out_of_terminal=false
  Np_8: Coil Terminal Objects=Np8_Section1 Conductor_number=1 Winding=Np Point_out_of_terminal=false
  Np: Winding Group Type=Voltage IsSolid=true Current=16.36A Resistance=0ohm Inductance=0nH Voltage=volt_ac ParallelBranchesNum=1 Phase=0rad
  Ns: Winding Group Type=Current IsSolid=true Current=1000*1.41/volt_ac*1.414 ParallelBranchesNum=1 Phase=0.1522rad
  core loss on: Body1, Body1_3
parameters:
  Matrix1: Matrix Np, Ns:
mesh:
  Length1: LengthBased Objects=[Body1, Body1_1..Body1_5] MaxLength=5mm
  Length2: LengthBased Objects=[Np1..Np8, Ns1..Ns8, plate_1, plate_2] MaxLength=2mm
  initial mesh: GlobalSurfApproximation{CurvedSurfaceApproxChoice=UseSlider SliderMeshSettings=9} GlobalCurvilinear{Apply}
setups:
  Setup1: EddyCurrent MaximumPasses=20 MinimumPasses=2 MinimumConvergedPasses=1 PercentRefinement=30 PercentError=1 NonLinearResidual=0.0001 SmoothBHCurve Frequency=28.5kHz
field plots:
  Mesh1: MeshPlots in Np1..Np8, Ns1..Ns8 on Setup1 : LastAdaptive at Freq=28.5kHz Phase=0deg
reports:
  L Table 1: Matrix1.L(Np,Np), Matrix1.L(Ns,Np), Matrix1.L(Np,Ns), Matrix1.L(Ns,Ns), Matrix1.R(Np,Np), Matrix1.R(Ns,Np), Matrix1.R(Np,Ns), Matrix1.R(Ns,Ns) vs Freq on Setup1 : LastAdaptive

design Flatwise_0.30_interleaved_full2 (Maxwell 3D, EddyCurrent, model units mm)
variables:
  freq_hz = 28500Hz
  volt_ac = 141/28500*Freq
geometry:
  Region [vacuum] = region(percentage_offset=0 on all sides)
  Np1..Np8, Ns1..Ns8 [copper] = imported_body(C:\Users\karlr\Documents\ICMaSS_sweeping\flatwise_0.1_0.3.step)
  plate_1, plate_2 [silicon - Copy] = imported_body(C:\Users\karlr\Documents\ICMaSS_sweeping\flatwise_0.1_0.3.step)
  Body1 [ferrite - Copy (2)] = imported_body(C:\Users\karlr\Documents\ICMaSS_sweeping\flatwise_0.1_0.3.step)
  Body1_1, Body1_2 [aluminum] = imported_body(C:\Users\karlr\Documents\ICMaSS_sweeping\flatwise_0.1_0.3.step)
  Body1_3 [ferrite - Copy (2)] = imported_body(C:\Users\karlr\Documents\ICMaSS_sweeping\flatwise_0.1_0.3.step)
  Body1_4, Body1_5 [aluminum] = imported_body(C:\Users\karlr\Documents\ICMaSS_sweeping\flatwise_0.1_0.3.step)
  Np1_Section1 = Np1.section(plane=ZX)
  Np2_Section1 = Np2.section(plane=ZX)
  Np3_Section1 [copper] = Np3.section(plane=ZX)
  Np4_Section1 [copper] = Np4.section(plane=ZX)
  Np5_Section1 [copper] = Np5.section(plane=ZX)
  Np6_Section1 [copper] = Np6.section(plane=ZX)
  Np7_Section1 [copper] = Np7.section(plane=ZX)
  Np8_Section1 [copper] = Np8.section(plane=ZX)
  Ns1_Section1 = Ns1.section(plane=ZX)
  Ns2_Section1 = Ns2.section(plane=ZX)
  Ns3_Section1 [copper] = Ns3.section(plane=ZX)
  Ns4_Section1 [copper] = Ns4.section(plane=ZX)
  Ns5_Section1 [copper] = Ns5.section(plane=ZX)
  Ns6_Section1 [copper] = Ns6.section(plane=ZX)
  Ns7_Section1 [copper] = Ns7.section(plane=ZX)
  Ns8_Section1 [copper] = Ns8.section(plane=ZX)
  Np1_Section1_Separate1 [copper] = Np1_Section1.separate_bodies()
  Np1_Section1.delete()
  Np2_Section1_Separate1 [copper] = Np2_Section1.separate_bodies()
  Np2_Section1.delete()
  Np3_Section1.separate_bodies()
  Np4_Section1.separate_bodies()
  Np5_Section1.separate_bodies()
  Np6_Section1.separate_bodies()
  Np7_Section1.separate_bodies()
  Np8_Section1.separate_bodies()
  Ns1_Section1_Separate1 [copper] = Ns1_Section1.separate_bodies()
  Ns1_Section1.delete()
  Ns2_Section1_Separate1 [copper] = Ns2_Section1.separate_bodies()
  Ns2_Section1.delete()
  Ns3_Section1.separate_bodies()
  Ns4_Section1.separate_bodies()
  Ns5_Section1.separate_bodies()
  Ns6_Section1.separate_bodies()
  Ns7_Section1.separate_bodies()
  Ns8_Section1.separate_bodies()
  [Np1..Np8, Ns1..Ns8, plate_1, plate_2, Body1, Body1_1..Body1_5, Np3_Section1, Np4_Section1, Np5_Section1, Np6_Section1, Np7_Section1, Np8_Section1, Ns3_Section1, Ns4_Section1, Ns5_Section1, Ns6_Section1, Ns7_Section1, Ns8_Section1, Np1_Section1_Separate1, Np2_Section1_Separate1, Ns1_Section1_Separate1, Ns2_Section1_Separate1].move(-18.3mm, -25.43mm, -9.2833333mm)
  group core_assembled_flatwise = Np1..Np8, Ns1..Ns8, plate_1, plate_2, Np3_Section1, Np4_Section1, Np5_Section1, Np6_Section1, Np7_Section1, Np8_Section1, Ns3_Section1, Ns4_Section1, Ns5_Section1, Ns6_Section1, Ns7_Section1, Ns8_Section1, Np1_Section1_Separate1, Np2_Section1_Separate1, Ns1_Section1_Separate1, Ns2_Section1_Separate1
  group core_together_1 = Body1, Body1_1, Body1_2
  group core_together = Body1_3, Body1_4, Body1_5
boundaries and excitations:
  Ns_1: Coil Terminal Objects=Ns1_Section1_Separate1 Conductor_number=1 Winding=Ns Point_out_of_terminal=true
  Ns_2: Coil Terminal Objects=Ns2_Section1_Separate1 Conductor_number=1 Winding=Ns Point_out_of_terminal=true
  Ns_3: Coil Terminal Objects=Ns3_Section1 Conductor_number=1 Winding=Ns Point_out_of_terminal=true
  Ns_4: Coil Terminal Objects=Ns4_Section1 Conductor_number=1 Winding=Ns Point_out_of_terminal=true
  Ns_5: Coil Terminal Objects=Ns5_Section1 Conductor_number=1 Winding=Ns Point_out_of_terminal=true
  Ns_6: Coil Terminal Objects=Ns6_Section1 Conductor_number=1 Winding=Ns Point_out_of_terminal=true
  Ns_7: Coil Terminal Objects=Ns7_Section1 Conductor_number=1 Winding=Ns Point_out_of_terminal=true
  Ns_8: Coil Terminal Objects=Ns8_Section1 Conductor_number=1 Winding=Ns Point_out_of_terminal=true
  Np_1: Coil Terminal Objects=Np1_Section1_Separate1 Conductor_number=1 Winding=Np Point_out_of_terminal=false
  Np_2: Coil Terminal Objects=Np2_Section1_Separate1 Conductor_number=1 Winding=Np Point_out_of_terminal=false
  Np_3: Coil Terminal Objects=Np3_Section1 Conductor_number=1 Winding=Np Point_out_of_terminal=false
  Np_4: Coil Terminal Objects=Np4_Section1 Conductor_number=1 Winding=Np Point_out_of_terminal=false
  Np_5: Coil Terminal Objects=Np5_Section1 Conductor_number=1 Winding=Np Point_out_of_terminal=false
  Np_6: Coil Terminal Objects=Np6_Section1 Conductor_number=1 Winding=Np Point_out_of_terminal=false
  Np_7: Coil Terminal Objects=Np7_Section1 Conductor_number=1 Winding=Np Point_out_of_terminal=false
  Np_8: Coil Terminal Objects=Np8_Section1 Conductor_number=1 Winding=Np Point_out_of_terminal=false
  Np: Winding Group Type=Voltage IsSolid=true Current=16.36A Resistance=0ohm Inductance=0nH Voltage=volt_ac ParallelBranchesNum=1 Phase=0rad
  Ns: Winding Group Type=Current IsSolid=true Current=1000*1.41/volt_ac*1.414 ParallelBranchesNum=1 Phase=180deg
  core loss on: Body1, Body1_3
parameters:
  Matrix1: Matrix Np, Ns:
mesh:
  Length1: LengthBased Objects=[Body1, Body1_1..Body1_5] MaxLength=5mm
  Length2: LengthBased Objects=[Np1..Np8, Ns1..Ns8, plate_1, plate_2] MaxLength=2mm
  initial mesh: GlobalSurfApproximation{CurvedSurfaceApproxChoice=UseSlider SliderMeshSettings=9} GlobalCurvilinear{Apply}
setups:
  Setup1: EddyCurrent MaximumPasses=20 MinimumPasses=2 MinimumConvergedPasses=1 PercentRefinement=30 PercentError=1 NonLinearResidual=0.0001 SmoothBHCurve Frequency=28.5kHz
  Setup2: EddyCurrent MaximumPasses=20 MinimumPasses=2 MinimumConvergedPasses=1 PercentRefinement=30 PercentError=1 NonLinearResidual=0.0001 SmoothBHCurve Frequency=0.1Hz
field plots:
  Mesh1: MeshPlots in Np1..Np8, Ns1..Ns8 on Setup1 : LastAdaptive at Freq=28.5kHz Phase=0deg
  Mag_J1: J over Np1_Section1_Separate1.face Np2_Section1_Separate1.face Np3_Section1.face(at (-7.75, -25.43, 0.05)) Np4_Section1.face(at (-8.55, -25.43, 0.05)) Np5_Section1.face(at (-9.35, -25.43, 0.05)) Np6_Section1.face(at (-10.15, -25.43, 0.05)) Np7_Section1.face(at (-10.95, -25.43, 0.05)) Np8_Section1.face(at (-11.75, -25.43, 0.05)) Ns1_Section1_Separate1.face Ns2_Section1_Separate1.face Ns3_Section1.face(at (-8.15, -25.43, 0.05)) Ns4_Section1.face(at (-8.95, -25.43, 0.05)) Ns5_Section1.face(at (-9.75, -25.43, 0.05)) Ns6_Section1.face(at (-10.55, -25.43, 0.05)) Ns7_Section1.face(at (-11.35, -25.43, 0.05)) Ns8_Section1.face(at (-12.15, -25.43, 0.05)) on Setup1 : LastAdaptive at Freq=28.5kHz Phase=0deg
reports:
  L Table 1: Matrix1.L(Np,Np), Matrix1.L(Ns,Np), Matrix1.L(Np,Ns), Matrix1.L(Ns,Ns), Matrix1.R(Np,Np), Matrix1.R(Ns,Np), Matrix1.R(Np,Ns), Matrix1.R(Ns,Ns) vs Freq on Setup1 : LastAdaptive

design Flatwise_0.30_interleaved_INTERWINDING CAPACITANCE (Maxwell 3D, Electrostatic, model units mm)
variables:
  freq_hz = 28500Hz
  volt_ac = 141/28500*Freq
geometry:
  Region [vacuum] = region(percentage_offset=0 on all sides)
  Np1..Np8, Ns1..Ns8 [copper] = imported_body(C:\Users\karlr\Documents\ICMaSS_sweeping\flatwise_0.1_0.3.step)
  plate_1, plate_2 [silicon - Copy] = imported_body(C:\Users\karlr\Documents\ICMaSS_sweeping\flatwise_0.1_0.3.step)
  Body1 [ferrite - Copy (2)] = imported_body(C:\Users\karlr\Documents\ICMaSS_sweeping\flatwise_0.1_0.3.step)
  Body1_1, Body1_2 [aluminum] = imported_body(C:\Users\karlr\Documents\ICMaSS_sweeping\flatwise_0.1_0.3.step)
  Body1_3 [ferrite - Copy (2)] = imported_body(C:\Users\karlr\Documents\ICMaSS_sweeping\flatwise_0.1_0.3.step)
  Body1_4, Body1_5 [aluminum] = imported_body(C:\Users\karlr\Documents\ICMaSS_sweeping\flatwise_0.1_0.3.step)
  Np1_Section1 = Np1.section(plane=ZX)
  Np2_Section1 = Np2.section(plane=ZX)
  Np3_Section1 [copper] = Np3.section(plane=ZX)
  Np4_Section1 [copper] = Np4.section(plane=ZX)
  Np5_Section1 [copper] = Np5.section(plane=ZX)
  Np6_Section1 [copper] = Np6.section(plane=ZX)
  Np7_Section1 [copper] = Np7.section(plane=ZX)
  Np8_Section1 [copper] = Np8.section(plane=ZX)
  Ns1_Section1 = Ns1.section(plane=ZX)
  Ns2_Section1 = Ns2.section(plane=ZX)
  Ns3_Section1 [copper] = Ns3.section(plane=ZX)
  Ns4_Section1 [copper] = Ns4.section(plane=ZX)
  Ns5_Section1 [copper] = Ns5.section(plane=ZX)
  Ns6_Section1 [copper] = Ns6.section(plane=ZX)
  Ns7_Section1 [copper] = Ns7.section(plane=ZX)
  Ns8_Section1 [copper] = Ns8.section(plane=ZX)
  Np1_Section1_Separate1 [copper] = Np1_Section1.separate_bodies()
  Np1_Section1.delete()
  Np2_Section1_Separate1 [copper] = Np2_Section1.separate_bodies()
  Np2_Section1.delete()
  Np3_Section1.separate_bodies()
  Np4_Section1.separate_bodies()
  Np5_Section1.separate_bodies()
  Np6_Section1.separate_bodies()
  Np7_Section1.separate_bodies()
  Np8_Section1.separate_bodies()
  Ns1_Section1_Separate1 [copper] = Ns1_Section1.separate_bodies()
  Ns1_Section1.delete()
  Ns2_Section1_Separate1 [copper] = Ns2_Section1.separate_bodies()
  Ns2_Section1.delete()
  Ns3_Section1.separate_bodies()
  Ns4_Section1.separate_bodies()
  Ns5_Section1.separate_bodies()
  Ns6_Section1.separate_bodies()
  Ns7_Section1.separate_bodies()
  Ns8_Section1.separate_bodies()
  Rectangle1 [non-model] = rectangle(corner=(30.6mm, 25.43mm, 6mm), z_size=6.6666667mm, x_size=-24.6mm)
  Rectangle2 [non-model] = rectangle(corner=(18.3mm, 59.16mm, 1.6666608e-08mm), y_size=-67.46mm, z_size=18.666667mm)
  Rectangle2.move(12.3mm, 0mm, -8.3333003e-09mm)
  Rectangle2.move(-6.6mm, -0.43mm, -0.14166667mm)
  Rectangle2.move(2.1316282e-13mm, 0.135mm, 0.14166666mm)
  Rectangle2.move(0.2mm, 0mm, 0mm)
  Rectangle2.move(1mm, -3mm, 0mm)
  Rectangle2.move(-0.6mm, 0mm, 0mm)
  Rectangle2.move(-0.1mm, 0mm, 0mm)
  Rectangle2.move(2.4mm, -1.7763568e-14mm, -2.4868996e-14mm)
  group core_assembled_flatwise = Np1..Np8, Ns1..Ns8, plate_1, plate_2, Np3_Section1, Np4_Section1, Np5_Section1, Np6_Section1, Np7_Section1, Np8_Section1, Ns3_Section1, Ns4_Section1, Ns5_Section1, Ns6_Section1, Ns7_Section1, Ns8_Section1, Np1_Section1_Separate1, Np2_Section1_Separate1, Ns1_Section1_Separate1, Ns2_Section1_Separate1
  group core_together_1 = Body1, Body1_1, Body1_2
  group core_together = Body1_3, Body1_4, Body1_5
boundaries and excitations:
  Voltage1: Voltage Objects=[Np1..Np8] Voltage=1V
  Voltage2: Voltage Objects=[Ns1..Ns8] Voltage=0mV
parameters:
  Matrix1: Matrix Voltage1, Voltage2: NumberOfTurns=1
mesh:
  Length1: LengthBased Objects=[Body1, Body1_1..Body1_5] MaxLength=5mm
  Length2: LengthBased Objects=[Np1..Np8, Ns1..Ns8, plate_1, plate_2] MaxLength=2mm
  initial mesh: GlobalSurfApproximation{CurvedSurfaceApproxChoice=UseSlider SliderMeshSettings=9} GlobalCurvilinear{Apply}
setups:
  Setup1: Electrostatic MaximumPasses=20 MinimumPasses=2 MinimumConvergedPasses=1 PercentRefinement=30 PercentError=1 NonLinearResidual=0.001

design Flatwise_0.30_PSSPinterleaved_full (Maxwell 3D, EddyCurrent, model units mm)
variables:
  freq_hz = 28500Hz
  volt_ac = 141/28500*Freq
geometry:
  Region [vacuum] = region(percentage_offset=0 on all sides)
  Np1..Np8, Ns1..Ns8 [copper] = imported_body(C:\Users\karlr\Documents\ICMaSS_sweeping\flatwise_0.1_0.3.step)
  plate_1, plate_2 [silicon - Copy] = imported_body(C:\Users\karlr\Documents\ICMaSS_sweeping\flatwise_0.1_0.3.step)
  Body1 [ferrite - Copy (2)] = imported_body(C:\Users\karlr\Documents\ICMaSS_sweeping\flatwise_0.1_0.3.step)
  Body1_1, Body1_2 [aluminum] = imported_body(C:\Users\karlr\Documents\ICMaSS_sweeping\flatwise_0.1_0.3.step)
  Body1_3 [ferrite - Copy (2)] = imported_body(C:\Users\karlr\Documents\ICMaSS_sweeping\flatwise_0.1_0.3.step)
  Body1_4, Body1_5 [aluminum] = imported_body(C:\Users\karlr\Documents\ICMaSS_sweeping\flatwise_0.1_0.3.step)
  Np1_Section1 = Np1.section(plane=ZX)
  Np2_Section1 = Np2.section(plane=ZX)
  Np3_Section1 [copper] = Np3.section(plane=ZX)
  Np4_Section1 [copper] = Np4.section(plane=ZX)
  Np5_Section1 [copper] = Np5.section(plane=ZX)
  Np6_Section1 [copper] = Np6.section(plane=ZX)
  Np7_Section1 [copper] = Np7.section(plane=ZX)
  Np8_Section1 [copper] = Np8.section(plane=ZX)
  Ns1_Section1 = Ns1.section(plane=ZX)
  Ns2_Section1 = Ns2.section(plane=ZX)
  Ns3_Section1 [copper] = Ns3.section(plane=ZX)
  Ns4_Section1 [copper] = Ns4.section(plane=ZX)
  Ns5_Section1 [copper] = Ns5.section(plane=ZX)
  Ns6_Section1 [copper] = Ns6.section(plane=ZX)
  Ns7_Section1 [copper] = Ns7.section(plane=ZX)
  Ns8_Section1 [copper] = Ns8.section(plane=ZX)
  Np1_Section1_Separate1 [copper] = Np1_Section1.separate_bodies()
  Np1_Section1.delete()
  Np2_Section1_Separate1 [copper] = Np2_Section1.separate_bodies()
  Np2_Section1.delete()
  Np3_Section1.separate_bodies()
  Np4_Section1.separate_bodies()
  Np5_Section1.separate_bodies()
  Np6_Section1.separate_bodies()
  Np7_Section1.separate_bodies()
  Np8_Section1.separate_bodies()
  Ns1_Section1_Separate1 [copper] = Ns1_Section1.separate_bodies()
  Ns1_Section1.delete()
  Ns2_Section1_Separate1 [copper] = Ns2_Section1.separate_bodies()
  Ns2_Section1.delete()
  Ns3_Section1.separate_bodies()
  Ns4_Section1.separate_bodies()
  Ns5_Section1.separate_bodies()
  Ns6_Section1.separate_bodies()
  Ns7_Section1.separate_bodies()
  Ns8_Section1.separate_bodies()
  Rectangle1 [non-model] = rectangle(corner=(30.6mm, 25.43mm, 6mm), z_size=6.6666667mm, x_size=-24.6mm)
  Rectangle2 [non-model] = rectangle(corner=(18.3mm, 59.16mm, 1.6666608e-08mm), y_size=-67.46mm, z_size=18.666667mm)
  Rectangle2.move(12.3mm, 0mm, -8.3333003e-09mm)
  Rectangle2.move(-6.6mm, -0.43mm, -0.14166667mm)
  Rectangle2.move(2.1316282e-13mm, 0.135mm, 0.14166666mm)
  Rectangle2.move(0.2mm, 0mm, 0mm)
  Rectangle2.move(1mm, -3mm, 0mm)
  Rectangle2.move(-0.6mm, 0mm, 0mm)
  Rectangle2.move(-0.1mm, 0mm, 0mm)
  Rectangle2.move(2.4mm, -1.7763568e-14mm, -2.4868996e-14mm)
  group core_assembled_flatwise = Np1..Np8, Ns1..Ns8, plate_1, plate_2, Np3_Section1, Np4_Section1, Np5_Section1, Np6_Section1, Np7_Section1, Np8_Section1, Ns3_Section1, Ns4_Section1, Ns5_Section1, Ns6_Section1, Ns7_Section1, Ns8_Section1, Np1_Section1_Separate1, Np2_Section1_Separate1, Ns1_Section1_Separate1, Ns2_Section1_Separate1
  group core_together_1 = Body1, Body1_1, Body1_2
  group core_together = Body1_3, Body1_4, Body1_5
boundaries and excitations:
  Np_1: Coil Terminal Objects=Np1_Section1_Separate1 Conductor_number=1 Winding=Np Point_out_of_terminal=false
  Np_2: Coil Terminal Objects=Np3_Section1 Conductor_number=1 Winding=Np Point_out_of_terminal=false
  Np_3: Coil Terminal Objects=Ns2_Section1_Separate1 Conductor_number=1 Winding=Np Point_out_of_terminal=false
  Np_4: Coil Terminal Objects=Np5_Section1 Conductor_number=1 Winding=Np Point_out_of_terminal=false
  Np_5: Coil Terminal Objects=Ns4_Section1 Conductor_number=1 Winding=Np Point_out_of_terminal=false
  Np_6: Coil Terminal Objects=Np7_Section1 Conductor_number=1 Winding=Np Point_out_of_terminal=false
  Np_7: Coil Terminal Objects=Ns6_Section1 Conductor_number=1 Winding=Np Point_out_of_terminal=false
  Np_8: Coil Terminal Objects=Ns8_Section1 Conductor_number=1 Winding=Np Point_out_of_terminal=false
  Ns_1: Coil Terminal Objects=Np2_Section1_Separate1 Conductor_number=1 Winding=Ns Point_out_of_terminal=true
  Ns_2: Coil Terminal Objects=Np4_Section1 Conductor_number=1 Winding=Ns Point_out_of_terminal=true
  Ns_3: Coil Terminal Objects=Np6_Section1 Conductor_number=1 Winding=Ns Point_out_of_terminal=true
  Ns_4: Coil Terminal Objects=Np8_Section1 Conductor_number=1 Winding=Ns Point_out_of_terminal=true
  Ns_5: Coil Terminal Objects=Ns1_Section1_Separate1 Conductor_number=1 Winding=Ns Point_out_of_terminal=true
  Ns_6: Coil Terminal Objects=Ns3_Section1 Conductor_number=1 Winding=Ns Point_out_of_terminal=true
  Ns_7: Coil Terminal Objects=Ns5_Section1 Conductor_number=1 Winding=Ns Point_out_of_terminal=true
  Ns_8: Coil Terminal Objects=Ns7_Section1 Conductor_number=1 Winding=Ns Point_out_of_terminal=true
  Np: Winding Group Type=Voltage IsSolid=true Current=16.36A Resistance=0ohm Inductance=0nH Voltage=volt_ac ParallelBranchesNum=1 Phase=0rad
  Ns: Winding Group Type=Current IsSolid=true Current=1000*1.41/volt_ac*1.414 ParallelBranchesNum=1 Phase=0.1522rad
  core loss on: Body1, Body1_3
parameters:
  Matrix1: Matrix Np, Ns:
mesh:
  Length1: LengthBased Objects=[Body1, Body1_1..Body1_5] MaxLength=5mm
  Length2: LengthBased Objects=[Np1..Np8, Ns1..Ns8, plate_1, plate_2] MaxLength=2mm
  initial mesh: GlobalSurfApproximation{CurvedSurfaceApproxChoice=UseSlider SliderMeshSettings=9} GlobalCurvilinear{Apply}
setups:
  Setup1: EddyCurrent MaximumPasses=20 MinimumPasses=2 MinimumConvergedPasses=1 PercentRefinement=30 PercentError=1 NonLinearResidual=0.0001 SmoothBHCurve Frequency=28.5kHz
field plots:
  Mesh1: MeshPlots in Np1..Np8, Ns1..Ns8 on Setup1 : LastAdaptive at Freq=28.5kHz Phase=0deg
  Mag_J1: J over a plane on Setup1 : LastAdaptive at Freq=28.5kHz Phase=45deg
  Mag_J2: J over a plane on Setup1 : LastAdaptive at Freq=28.5kHz Phase=0deg
reports:
  L Table 1: Matrix1.L(Np,Np), Matrix1.L(Ns,Np), Matrix1.L(Np,Ns), Matrix1.L(Ns,Ns), Matrix1.R(Np,Np), Matrix1.R(Ns,Np), Matrix1.R(Np,Ns), Matrix1.R(Ns,Ns) vs Freq on Setup1 : LastAdaptive

design Flatwise_0.30_Nointerleaved_full (Maxwell 3D, EddyCurrent, model units mm)
variables:
  freq_hz = 28500Hz
  volt_ac = 141/28500*Freq
geometry:
  Region [vacuum] = region(percentage_offset=0 on all sides)
  Np1..Np8, Ns1..Ns8 [copper] = imported_body(C:\Users\karlr\Documents\ICMaSS_sweeping\flatwise_0.1_0.3.step)
  plate_1, plate_2 [silicon - Copy] = imported_body(C:\Users\karlr\Documents\ICMaSS_sweeping\flatwise_0.1_0.3.step)
  Body1 [ferrite - Copy (2)] = imported_body(C:\Users\karlr\Documents\ICMaSS_sweeping\flatwise_0.1_0.3.step)
  Body1_1, Body1_2 [aluminum] = imported_body(C:\Users\karlr\Documents\ICMaSS_sweeping\flatwise_0.1_0.3.step)
  Body1_3 [ferrite - Copy (2)] = imported_body(C:\Users\karlr\Documents\ICMaSS_sweeping\flatwise_0.1_0.3.step)
  Body1_4, Body1_5 [aluminum] = imported_body(C:\Users\karlr\Documents\ICMaSS_sweeping\flatwise_0.1_0.3.step)
  Np1_Section1 = Np1.section(plane=ZX)
  Np2_Section1 = Np2.section(plane=ZX)
  Np3_Section1 [copper] = Np3.section(plane=ZX)
  Np4_Section1 [copper] = Np4.section(plane=ZX)
  Np5_Section1 [copper] = Np5.section(plane=ZX)
  Np6_Section1 [copper] = Np6.section(plane=ZX)
  Np7_Section1 [copper] = Np7.section(plane=ZX)
  Np8_Section1 [copper] = Np8.section(plane=ZX)
  Ns1_Section1 = Ns1.section(plane=ZX)
  Ns2_Section1 = Ns2.section(plane=ZX)
  Ns3_Section1 [copper] = Ns3.section(plane=ZX)
  Ns4_Section1 [copper] = Ns4.section(plane=ZX)
  Ns5_Section1 [copper] = Ns5.section(plane=ZX)
  Ns6_Section1 [copper] = Ns6.section(plane=ZX)
  Ns7_Section1 [copper] = Ns7.section(plane=ZX)
  Ns8_Section1 [copper] = Ns8.section(plane=ZX)
  Np1_Section1_Separate1 [copper] = Np1_Section1.separate_bodies()
  Np1_Section1.delete()
  Np2_Section1_Separate1 [copper] = Np2_Section1.separate_bodies()
  Np2_Section1.delete()
  Np3_Section1.separate_bodies()
  Np4_Section1.separate_bodies()
  Np5_Section1.separate_bodies()
  Np6_Section1.separate_bodies()
  Np7_Section1.separate_bodies()
  Np8_Section1.separate_bodies()
  Ns1_Section1_Separate1 [copper] = Ns1_Section1.separate_bodies()
  Ns1_Section1.delete()
  Ns2_Section1_Separate1 [copper] = Ns2_Section1.separate_bodies()
  Ns2_Section1.delete()
  Ns3_Section1.separate_bodies()
  Ns4_Section1.separate_bodies()
  Ns5_Section1.separate_bodies()
  Ns6_Section1.separate_bodies()
  Ns7_Section1.separate_bodies()
  Ns8_Section1.separate_bodies()
  Rectangle1 [non-model] = rectangle(corner=(30.6mm, 25.43mm, 6mm), z_size=6.6666667mm, x_size=-24.6mm)
  Rectangle2 [non-model] = rectangle(corner=(18.3mm, 59.16mm, 1.6666608e-08mm), y_size=-67.46mm, z_size=18.666667mm)
  Rectangle2.move(12.3mm, 0mm, -8.3333003e-09mm)
  Rectangle2.move(-6.6mm, -0.43mm, -0.14166667mm)
  Rectangle2.move(2.1316282e-13mm, 0.135mm, 0.14166666mm)
  Rectangle2.move(0.2mm, 0mm, 0mm)
  Rectangle2.move(1mm, -3mm, 0mm)
  Rectangle2.move(-0.6mm, 0mm, 0mm)
  Rectangle2.move(-0.1mm, 0mm, 0mm)
  Rectangle2.move(2.4mm, -1.7763568e-14mm, -2.4868996e-14mm)
  group core_assembled_flatwise = Np1..Np8, Ns1..Ns8, plate_1, plate_2, Np3_Section1, Np4_Section1, Np5_Section1, Np6_Section1, Np7_Section1, Np8_Section1, Ns3_Section1, Ns4_Section1, Ns5_Section1, Ns6_Section1, Ns7_Section1, Ns8_Section1, Np1_Section1_Separate1, Np2_Section1_Separate1, Ns1_Section1_Separate1, Ns2_Section1_Separate1
  group core_together_1 = Body1, Body1_1, Body1_2
  group core_together = Body1_3, Body1_4, Body1_5
boundaries and excitations:
  Np_1: Coil Terminal Objects=Np1_Section1_Separate1 Conductor_number=1 Winding=Np Point_out_of_terminal=false
  Np_2: Coil Terminal Objects=Np2_Section1_Separate1 Conductor_number=1 Winding=Np Point_out_of_terminal=false
  Np_3: Coil Terminal Objects=Np3_Section1 Conductor_number=1 Winding=Np Point_out_of_terminal=false
  Np_4: Coil Terminal Objects=Np4_Section1 Conductor_number=1 Winding=Np Point_out_of_terminal=false
  Np_5: Coil Terminal Objects=Ns1_Section1_Separate1 Conductor_number=1 Winding=Np Point_out_of_terminal=false
  Np_6: Coil Terminal Objects=Ns2_Section1_Separate1 Conductor_number=1 Winding=Np Point_out_of_terminal=false
  Np_7: Coil Terminal Objects=Ns3_Section1 Conductor_number=1 Winding=Np Point_out_of_terminal=false
  Np_8: Coil Terminal Objects=Ns4_Section1 Conductor_number=1 Winding=Np Point_out_of_terminal=false
  Ns_1: Coil Terminal Objects=Np5_Section1 Conductor_number=1 Winding=Ns Point_out_of_terminal=true
  Ns_2: Coil Terminal Objects=Np6_Section1 Conductor_number=1 Winding=Ns Point_out_of_terminal=true
  Ns_3: Coil Terminal Objects=Np7_Section1 Conductor_number=1 Winding=Ns Point_out_of_terminal=true
  Ns_4: Coil Terminal Objects=Np8_Section1 Conductor_number=1 Winding=Ns Point_out_of_terminal=true
  Ns_5: Coil Terminal Objects=Ns5_Section1 Conductor_number=1 Winding=Ns Point_out_of_terminal=true
  Ns_6: Coil Terminal Objects=Ns6_Section1 Conductor_number=1 Winding=Ns Point_out_of_terminal=true
  Ns_7: Coil Terminal Objects=Ns7_Section1 Conductor_number=1 Winding=Ns Point_out_of_terminal=true
  Ns_8: Coil Terminal Objects=Ns8_Section1 Conductor_number=1 Winding=Ns Point_out_of_terminal=true
  Np: Winding Group Type=Voltage IsSolid=true Current=16.36A Resistance=0ohm Inductance=0nH Voltage=volt_ac ParallelBranchesNum=1 Phase=0rad
  Ns: Winding Group Type=Current IsSolid=true Current=1000*1.41/volt_ac*1.414 ParallelBranchesNum=1 Phase=0.1522rad
  core loss on: Body1, Body1_3
parameters:
  Matrix1: Matrix Np, Ns:
mesh:
  Length1: LengthBased Objects=[Body1, Body1_1..Body1_5] MaxLength=5mm
  Length2: LengthBased Objects=[Np1..Np8, Ns1..Ns8, plate_1, plate_2] MaxLength=2mm
  initial mesh: GlobalSurfApproximation{CurvedSurfaceApproxChoice=UseSlider SliderMeshSettings=9} GlobalCurvilinear{Apply}
setups:
  Setup1: EddyCurrent MaximumPasses=20 MinimumPasses=2 MinimumConvergedPasses=1 PercentRefinement=30 PercentError=1 NonLinearResidual=0.0001 SmoothBHCurve Frequency=28.5kHz
field plots:
  Mesh1: MeshPlots in Np1..Np8, Ns1..Ns8 on Setup1 : LastAdaptive at Freq=28.5kHz Phase=0deg
  Mag_J1: J over a plane on Setup1 : LastAdaptive at Freq=28.5kHz Phase=45deg
  Mag_J2: J over a plane on Setup1 : LastAdaptive at Freq=28.5kHz Phase=0deg
reports:
  L Table 1: Matrix1.L(Np,Np), Matrix1.L(Ns,Np), Matrix1.L(Np,Ns), Matrix1.L(Ns,Ns), Matrix1.R(Np,Np), Matrix1.R(Ns,Np), Matrix1.R(Np,Ns), Matrix1.R(Ns,Ns) vs Freq on Setup1 : LastAdaptive

design Flatwise_0.30_PSSPinterleaved_INTERWINDING CAPACITANCE (Maxwell 3D, Electrostatic, model units mm)
variables:
  freq_hz = 28500Hz
  volt_ac = 141/28500*Freq
geometry:
  Region [vacuum] = region(percentage_offset=0 on all sides)
  Np1..Np8, Ns1..Ns8 [copper] = imported_body(C:\Users\karlr\Documents\ICMaSS_sweeping\flatwise_0.1_0.3.step)
  plate_1, plate_2 [silicon - Copy] = imported_body(C:\Users\karlr\Documents\ICMaSS_sweeping\flatwise_0.1_0.3.step)
  Body1 [ferrite - Copy (2)] = imported_body(C:\Users\karlr\Documents\ICMaSS_sweeping\flatwise_0.1_0.3.step)
  Body1_1, Body1_2 [aluminum] = imported_body(C:\Users\karlr\Documents\ICMaSS_sweeping\flatwise_0.1_0.3.step)
  Body1_3 [ferrite - Copy (2)] = imported_body(C:\Users\karlr\Documents\ICMaSS_sweeping\flatwise_0.1_0.3.step)
  Body1_4, Body1_5 [aluminum] = imported_body(C:\Users\karlr\Documents\ICMaSS_sweeping\flatwise_0.1_0.3.step)
  Np1_Section1 = Np1.section(plane=ZX)
  Np2_Section1 = Np2.section(plane=ZX)
  Np3_Section1 [copper] = Np3.section(plane=ZX)
  Np4_Section1 [copper] = Np4.section(plane=ZX)
  Np5_Section1 [copper] = Np5.section(plane=ZX)
  Np6_Section1 [copper] = Np6.section(plane=ZX)
  Np7_Section1 [copper] = Np7.section(plane=ZX)
  Np8_Section1 [copper] = Np8.section(plane=ZX)
  Ns1_Section1 = Ns1.section(plane=ZX)
  Ns2_Section1 = Ns2.section(plane=ZX)
  Ns3_Section1 [copper] = Ns3.section(plane=ZX)
  Ns4_Section1 [copper] = Ns4.section(plane=ZX)
  Ns5_Section1 [copper] = Ns5.section(plane=ZX)
  Ns6_Section1 [copper] = Ns6.section(plane=ZX)
  Ns7_Section1 [copper] = Ns7.section(plane=ZX)
  Ns8_Section1 [copper] = Ns8.section(plane=ZX)
  Np1_Section1_Separate1 [copper] = Np1_Section1.separate_bodies()
  Np1_Section1.delete()
  Np2_Section1_Separate1 [copper] = Np2_Section1.separate_bodies()
  Np2_Section1.delete()
  Np3_Section1.separate_bodies()
  Np4_Section1.separate_bodies()
  Np5_Section1.separate_bodies()
  Np6_Section1.separate_bodies()
  Np7_Section1.separate_bodies()
  Np8_Section1.separate_bodies()
  Ns1_Section1_Separate1 [copper] = Ns1_Section1.separate_bodies()
  Ns1_Section1.delete()
  Ns2_Section1_Separate1 [copper] = Ns2_Section1.separate_bodies()
  Ns2_Section1.delete()
  Ns3_Section1.separate_bodies()
  Ns4_Section1.separate_bodies()
  Ns5_Section1.separate_bodies()
  Ns6_Section1.separate_bodies()
  Ns7_Section1.separate_bodies()
  Ns8_Section1.separate_bodies()
  Rectangle1 [non-model] = rectangle(corner=(30.6mm, 25.43mm, 6mm), z_size=6.6666667mm, x_size=-24.6mm)
  Rectangle2 [non-model] = rectangle(corner=(18.3mm, 59.16mm, 1.6666608e-08mm), y_size=-67.46mm, z_size=18.666667mm)
  Rectangle2.move(12.3mm, 0mm, -8.3333003e-09mm)
  Rectangle2.move(-6.6mm, -0.43mm, -0.14166667mm)
  Rectangle2.move(2.1316282e-13mm, 0.135mm, 0.14166666mm)
  Rectangle2.move(0.2mm, 0mm, 0mm)
  Rectangle2.move(1mm, -3mm, 0mm)
  Rectangle2.move(-0.6mm, 0mm, 0mm)
  Rectangle2.move(-0.1mm, 0mm, 0mm)
  Rectangle2.move(2.4mm, -1.7763568e-14mm, -2.4868996e-14mm)
  group core_assembled_flatwise = Np1..Np8, Ns1..Ns8, plate_1, plate_2, Np3_Section1, Np4_Section1, Np5_Section1, Np6_Section1, Np7_Section1, Np8_Section1, Ns3_Section1, Ns4_Section1, Ns5_Section1, Ns6_Section1, Ns7_Section1, Ns8_Section1, Np1_Section1_Separate1, Np2_Section1_Separate1, Ns1_Section1_Separate1, Ns2_Section1_Separate1
  group core_together_1 = Body1, Body1_1, Body1_2
  group core_together = Body1_3, Body1_4, Body1_5
boundaries and excitations:
  Voltage1: Voltage Objects=[Np1, Np3, Np5, Np7, Ns2, Ns4, Ns6, Ns8] Voltage=1V
  Voltage2: Voltage Objects=[Np2, Np4, Np6, Np8, Ns1, Ns3, Ns5, Ns7] Voltage=0mV
parameters:
  Matrix1: Matrix Voltage1, Voltage2: NumberOfTurns=1
mesh:
  Length1: LengthBased Objects=[Body1, Body1_1..Body1_5] MaxLength=5mm
  Length2: LengthBased Objects=[Np1..Np8, Ns1..Ns8, plate_1, plate_2] MaxLength=2mm
  initial mesh: GlobalSurfApproximation{CurvedSurfaceApproxChoice=UseSlider SliderMeshSettings=9} GlobalCurvilinear{Apply}
setups:
  Setup1: Electrostatic MaximumPasses=20 MinimumPasses=2 MinimumConvergedPasses=1 PercentRefinement=30 PercentError=1 NonLinearResidual=0.001

design Flatwise_0.30_Nointerleaved_INTERWINDING CAPACITANCE (Maxwell 3D, Electrostatic, model units mm)
variables:
  freq_hz = 28500Hz
  volt_ac = 141/28500*Freq
geometry:
  Region [vacuum] = region(percentage_offset=0 on all sides)
  Np1..Np8, Ns1..Ns8 [copper] = imported_body(C:\Users\karlr\Documents\ICMaSS_sweeping\flatwise_0.1_0.3.step)
  plate_1, plate_2 [silicon - Copy] = imported_body(C:\Users\karlr\Documents\ICMaSS_sweeping\flatwise_0.1_0.3.step)
  Body1 [ferrite - Copy (2)] = imported_body(C:\Users\karlr\Documents\ICMaSS_sweeping\flatwise_0.1_0.3.step)
  Body1_1, Body1_2 [aluminum] = imported_body(C:\Users\karlr\Documents\ICMaSS_sweeping\flatwise_0.1_0.3.step)
  Body1_3 [ferrite - Copy (2)] = imported_body(C:\Users\karlr\Documents\ICMaSS_sweeping\flatwise_0.1_0.3.step)
  Body1_4, Body1_5 [aluminum] = imported_body(C:\Users\karlr\Documents\ICMaSS_sweeping\flatwise_0.1_0.3.step)
  Np1_Section1 = Np1.section(plane=ZX)
  Np2_Section1 = Np2.section(plane=ZX)
  Np3_Section1 [copper] = Np3.section(plane=ZX)
  Np4_Section1 [copper] = Np4.section(plane=ZX)
  Np5_Section1 [copper] = Np5.section(plane=ZX)
  Np6_Section1 [copper] = Np6.section(plane=ZX)
  Np7_Section1 [copper] = Np7.section(plane=ZX)
  Np8_Section1 [copper] = Np8.section(plane=ZX)
  Ns1_Section1 = Ns1.section(plane=ZX)
  Ns2_Section1 = Ns2.section(plane=ZX)
  Ns3_Section1 [copper] = Ns3.section(plane=ZX)
  Ns4_Section1 [copper] = Ns4.section(plane=ZX)
  Ns5_Section1 [copper] = Ns5.section(plane=ZX)
  Ns6_Section1 [copper] = Ns6.section(plane=ZX)
  Ns7_Section1 [copper] = Ns7.section(plane=ZX)
  Ns8_Section1 [copper] = Ns8.section(plane=ZX)
  Np1_Section1_Separate1 [copper] = Np1_Section1.separate_bodies()
  Np1_Section1.delete()
  Np2_Section1_Separate1 [copper] = Np2_Section1.separate_bodies()
  Np2_Section1.delete()
  Np3_Section1.separate_bodies()
  Np4_Section1.separate_bodies()
  Np5_Section1.separate_bodies()
  Np6_Section1.separate_bodies()
  Np7_Section1.separate_bodies()
  Np8_Section1.separate_bodies()
  Ns1_Section1_Separate1 [copper] = Ns1_Section1.separate_bodies()
  Ns1_Section1.delete()
  Ns2_Section1_Separate1 [copper] = Ns2_Section1.separate_bodies()
  Ns2_Section1.delete()
  Ns3_Section1.separate_bodies()
  Ns4_Section1.separate_bodies()
  Ns5_Section1.separate_bodies()
  Ns6_Section1.separate_bodies()
  Ns7_Section1.separate_bodies()
  Ns8_Section1.separate_bodies()
  Rectangle1 [non-model] = rectangle(corner=(30.6mm, 25.43mm, 6mm), z_size=6.6666667mm, x_size=-24.6mm)
  Rectangle2 [non-model] = rectangle(corner=(18.3mm, 59.16mm, 1.6666608e-08mm), y_size=-67.46mm, z_size=18.666667mm)
  Rectangle2.move(12.3mm, 0mm, -8.3333003e-09mm)
  Rectangle2.move(-6.6mm, -0.43mm, -0.14166667mm)
  Rectangle2.move(2.1316282e-13mm, 0.135mm, 0.14166666mm)
  Rectangle2.move(0.2mm, 0mm, 0mm)
  Rectangle2.move(1mm, -3mm, 0mm)
  Rectangle2.move(-0.6mm, 0mm, 0mm)
  Rectangle2.move(-0.1mm, 0mm, 0mm)
  Rectangle2.move(2.4mm, -1.7763568e-14mm, -2.4868996e-14mm)
  group core_assembled_flatwise = Np1..Np8, Ns1..Ns8, plate_1, plate_2, Np3_Section1, Np4_Section1, Np5_Section1, Np6_Section1, Np7_Section1, Np8_Section1, Ns3_Section1, Ns4_Section1, Ns5_Section1, Ns6_Section1, Ns7_Section1, Ns8_Section1, Np1_Section1_Separate1, Np2_Section1_Separate1, Ns1_Section1_Separate1, Ns2_Section1_Separate1
  group core_together_1 = Body1, Body1_1, Body1_2
  group core_together = Body1_3, Body1_4, Body1_5
boundaries and excitations:
  Voltage1: Voltage Objects=[Np1, Ns1, Np2, Np3, Np4, Ns2, Ns3, Ns4] Voltage=1V
  Voltage2: Voltage Objects=[Np5..Np8, Ns5..Ns8] Voltage=0mV
parameters:
  Matrix1: Matrix Voltage1, Voltage2: NumberOfTurns=1
mesh:
  Length1: LengthBased Objects=[Body1, Body1_1..Body1_5] MaxLength=5mm
  Length2: LengthBased Objects=[Np1..Np8, Ns1..Ns8, plate_1, plate_2] MaxLength=2mm
  initial mesh: GlobalSurfApproximation{CurvedSurfaceApproxChoice=UseSlider SliderMeshSettings=9} GlobalCurvilinear{Apply}
setups:
  Setup1: Electrostatic MaximumPasses=20 MinimumPasses=2 MinimumConvergedPasses=1 PercentRefinement=30 PercentError=1 NonLinearResidual=0.001

design Flatwise_0.30_interleaved_INTTRAPRI (Maxwell 3D, Electrostatic, model units mm)
variables:
  freq_hz = 28500Hz
  volt_ac = 141/28500*Freq
geometry:
  Region [vacuum] = region(percentage_offset=0 on all sides)
  Np1..Np8, Ns1..Ns8 [copper] = imported_body(C:\Users\karlr\Documents\ICMaSS_sweeping\flatwise_0.1_0.3.step)
  plate_1, plate_2 [silicon - Copy] = imported_body(C:\Users\karlr\Documents\ICMaSS_sweeping\flatwise_0.1_0.3.step)
  Body1 [ferrite - Copy (2)] = imported_body(C:\Users\karlr\Documents\ICMaSS_sweeping\flatwise_0.1_0.3.step)
  Body1_1, Body1_2 [aluminum] = imported_body(C:\Users\karlr\Documents\ICMaSS_sweeping\flatwise_0.1_0.3.step)
  Body1_3 [ferrite - Copy (2)] = imported_body(C:\Users\karlr\Documents\ICMaSS_sweeping\flatwise_0.1_0.3.step)
  Body1_4, Body1_5 [aluminum] = imported_body(C:\Users\karlr\Documents\ICMaSS_sweeping\flatwise_0.1_0.3.step)
  Np1_Section1 = Np1.section(plane=ZX)
  Np2_Section1 = Np2.section(plane=ZX)
  Np3_Section1 [copper] = Np3.section(plane=ZX)
  Np4_Section1 [copper] = Np4.section(plane=ZX)
  Np5_Section1 [copper] = Np5.section(plane=ZX)
  Np6_Section1 [copper] = Np6.section(plane=ZX)
  Np7_Section1 [copper] = Np7.section(plane=ZX)
  Np8_Section1 [copper] = Np8.section(plane=ZX)
  Ns1_Section1 = Ns1.section(plane=ZX)
  Ns2_Section1 = Ns2.section(plane=ZX)
  Ns3_Section1 [copper] = Ns3.section(plane=ZX)
  Ns4_Section1 [copper] = Ns4.section(plane=ZX)
  Ns5_Section1 [copper] = Ns5.section(plane=ZX)
  Ns6_Section1 [copper] = Ns6.section(plane=ZX)
  Ns7_Section1 [copper] = Ns7.section(plane=ZX)
  Ns8_Section1 [copper] = Ns8.section(plane=ZX)
  Np1_Section1_Separate1 [copper] = Np1_Section1.separate_bodies()
  Np1_Section1.delete()
  Np2_Section1_Separate1 [copper] = Np2_Section1.separate_bodies()
  Np2_Section1.delete()
  Np3_Section1.separate_bodies()
  Np4_Section1.separate_bodies()
  Np5_Section1.separate_bodies()
  Np6_Section1.separate_bodies()
  Np7_Section1.separate_bodies()
  Np8_Section1.separate_bodies()
  Ns1_Section1_Separate1 [copper] = Ns1_Section1.separate_bodies()
  Ns1_Section1.delete()
  Ns2_Section1_Separate1 [copper] = Ns2_Section1.separate_bodies()
  Ns2_Section1.delete()
  Ns3_Section1.separate_bodies()
  Ns4_Section1.separate_bodies()
  Ns5_Section1.separate_bodies()
  Ns6_Section1.separate_bodies()
  Ns7_Section1.separate_bodies()
  Ns8_Section1.separate_bodies()
  Rectangle1 [non-model] = rectangle(corner=(30.6mm, 25.43mm, 6mm), z_size=6.6666667mm, x_size=-24.6mm)
  Rectangle2 [non-model] = rectangle(corner=(18.3mm, 59.16mm, 1.6666608e-08mm), y_size=-67.46mm, z_size=18.666667mm)
  Rectangle2.move(12.3mm, 0mm, -8.3333003e-09mm)
  Rectangle2.move(-6.6mm, -0.43mm, -0.14166667mm)
  Rectangle2.move(2.1316282e-13mm, 0.135mm, 0.14166666mm)
  Rectangle2.move(0.2mm, 0mm, 0mm)
  Rectangle2.move(1mm, -3mm, 0mm)
  Rectangle2.move(-0.6mm, 0mm, 0mm)
  Rectangle2.move(-0.1mm, 0mm, 0mm)
  Rectangle2.move(2.4mm, -1.7763568e-14mm, -2.4868996e-14mm)
  group core_assembled_flatwise = Np1..Np8, Ns1..Ns8, plate_1, plate_2, Np3_Section1, Np4_Section1, Np5_Section1, Np6_Section1, Np7_Section1, Np8_Section1, Ns3_Section1, Ns4_Section1, Ns5_Section1, Ns6_Section1, Ns7_Section1, Ns8_Section1, Np1_Section1_Separate1, Np2_Section1_Separate1, Ns1_Section1_Separate1, Ns2_Section1_Separate1
  group core_together_1 = Body1, Body1_1, Body1_2
  group core_together = Body1_3, Body1_4, Body1_5
boundaries and excitations:
  Voltage1: Voltage Objects=Np1 Voltage="(1/7*7) V"
  Voltage2: Voltage Objects=Np2 Voltage="(1/7*6) V"
  Voltage3: Voltage Objects=Np3 Voltage="(1/7*5) V"
  Voltage4: Voltage Objects=Np4 Voltage="(1/7*4) V"
  Voltage5: Voltage Objects=Np5 Voltage="(1/7*3) V"
  Voltage6: Voltage Objects=Np6 Voltage="(1/7*2) V"
  Voltage7: Voltage Objects=Np7 Voltage="(1/7*1) V"
  Voltage8: Voltage Objects=Np8 Voltage=0mV
parameters:
  Matrix1: Matrix Voltage1..Voltage8: NumberOfTurns=1
mesh:
  Length1: LengthBased Objects=[Body1, Body1_1..Body1_5] MaxLength=5mm
  Length2: LengthBased Objects=[Np1..Np8, Ns1..Ns8, plate_1, plate_2] MaxLength=2mm
  initial mesh: GlobalSurfApproximation{CurvedSurfaceApproxChoice=UseSlider SliderMeshSettings=9} GlobalCurvilinear{Apply}
setups:
  Setup1: Electrostatic MaximumPasses=20 MinimumPasses=2 MinimumConvergedPasses=1 PercentRefinement=30 PercentError=1 NonLinearResidual=0.001

design Flatwise_0.30_interleaved_INTTRASEC (Maxwell 3D, Electrostatic, model units mm)
variables:
  freq_hz = 28500Hz
  volt_ac = 141/28500*Freq
geometry:
  Region [vacuum] = region(percentage_offset=0 on all sides)
  Np1..Np8, Ns1..Ns8 [copper] = imported_body(C:\Users\karlr\Documents\ICMaSS_sweeping\flatwise_0.1_0.3.step)
  plate_1, plate_2 [silicon - Copy] = imported_body(C:\Users\karlr\Documents\ICMaSS_sweeping\flatwise_0.1_0.3.step)
  Body1 [ferrite - Copy (2)] = imported_body(C:\Users\karlr\Documents\ICMaSS_sweeping\flatwise_0.1_0.3.step)
  Body1_1, Body1_2 [aluminum] = imported_body(C:\Users\karlr\Documents\ICMaSS_sweeping\flatwise_0.1_0.3.step)
  Body1_3 [ferrite - Copy (2)] = imported_body(C:\Users\karlr\Documents\ICMaSS_sweeping\flatwise_0.1_0.3.step)
  Body1_4, Body1_5 [aluminum] = imported_body(C:\Users\karlr\Documents\ICMaSS_sweeping\flatwise_0.1_0.3.step)
  Np1_Section1 = Np1.section(plane=ZX)
  Np2_Section1 = Np2.section(plane=ZX)
  Np3_Section1 [copper] = Np3.section(plane=ZX)
  Np4_Section1 [copper] = Np4.section(plane=ZX)
  Np5_Section1 [copper] = Np5.section(plane=ZX)
  Np6_Section1 [copper] = Np6.section(plane=ZX)
  Np7_Section1 [copper] = Np7.section(plane=ZX)
  Np8_Section1 [copper] = Np8.section(plane=ZX)
  Ns1_Section1 = Ns1.section(plane=ZX)
  Ns2_Section1 = Ns2.section(plane=ZX)
  Ns3_Section1 [copper] = Ns3.section(plane=ZX)
  Ns4_Section1 [copper] = Ns4.section(plane=ZX)
  Ns5_Section1 [copper] = Ns5.section(plane=ZX)
  Ns6_Section1 [copper] = Ns6.section(plane=ZX)
  Ns7_Section1 [copper] = Ns7.section(plane=ZX)
  Ns8_Section1 [copper] = Ns8.section(plane=ZX)
  Np1_Section1_Separate1 [copper] = Np1_Section1.separate_bodies()
  Np1_Section1.delete()
  Np2_Section1_Separate1 [copper] = Np2_Section1.separate_bodies()
  Np2_Section1.delete()
  Np3_Section1.separate_bodies()
  Np4_Section1.separate_bodies()
  Np5_Section1.separate_bodies()
  Np6_Section1.separate_bodies()
  Np7_Section1.separate_bodies()
  Np8_Section1.separate_bodies()
  Ns1_Section1_Separate1 [copper] = Ns1_Section1.separate_bodies()
  Ns1_Section1.delete()
  Ns2_Section1_Separate1 [copper] = Ns2_Section1.separate_bodies()
  Ns2_Section1.delete()
  Ns3_Section1.separate_bodies()
  Ns4_Section1.separate_bodies()
  Ns5_Section1.separate_bodies()
  Ns6_Section1.separate_bodies()
  Ns7_Section1.separate_bodies()
  Ns8_Section1.separate_bodies()
  Rectangle1 [non-model] = rectangle(corner=(30.6mm, 25.43mm, 6mm), z_size=6.6666667mm, x_size=-24.6mm)
  Rectangle2 [non-model] = rectangle(corner=(18.3mm, 59.16mm, 1.6666608e-08mm), y_size=-67.46mm, z_size=18.666667mm)
  Rectangle2.move(12.3mm, 0mm, -8.3333003e-09mm)
  Rectangle2.move(-6.6mm, -0.43mm, -0.14166667mm)
  Rectangle2.move(2.1316282e-13mm, 0.135mm, 0.14166666mm)
  Rectangle2.move(0.2mm, 0mm, 0mm)
  Rectangle2.move(1mm, -3mm, 0mm)
  Rectangle2.move(-0.6mm, 0mm, 0mm)
  Rectangle2.move(-0.1mm, 0mm, 0mm)
  Rectangle2.move(2.4mm, -1.7763568e-14mm, -2.4868996e-14mm)
  group core_assembled_flatwise = Np1..Np8, Ns1..Ns8, plate_1, plate_2, Np3_Section1, Np4_Section1, Np5_Section1, Np6_Section1, Np7_Section1, Np8_Section1, Ns3_Section1, Ns4_Section1, Ns5_Section1, Ns6_Section1, Ns7_Section1, Ns8_Section1, Np1_Section1_Separate1, Np2_Section1_Separate1, Ns1_Section1_Separate1, Ns2_Section1_Separate1
  group core_together_1 = Body1, Body1_1, Body1_2
  group core_together = Body1_3, Body1_4, Body1_5
boundaries and excitations:
  Voltage1: Voltage Objects=Ns1 Voltage="(1/7*7) V"
  Voltage2: Voltage Objects=Ns2 Voltage="(1/7*6) V"
  Voltage3: Voltage Objects=Ns3 Voltage="(1/7*5) V"
  Voltage4: Voltage Objects=Ns4 Voltage="(1/7*4) V"
  Voltage5: Voltage Objects=Ns5 Voltage="(1/7*3) V"
  Voltage6: Voltage Objects=Ns6 Voltage="(1/7*2) V"
  Voltage7: Voltage Objects=Ns7 Voltage="(1/7*1) V"
  Voltage8: Voltage Objects=Ns8 Voltage=0mV
parameters:
  Matrix1: Matrix Voltage1..Voltage8: NumberOfTurns=1
mesh:
  Length1: LengthBased Objects=[Body1, Body1_1..Body1_5] MaxLength=5mm
  Length2: LengthBased Objects=[Np1..Np8, Ns1..Ns8, plate_1, plate_2] MaxLength=2mm
  initial mesh: GlobalSurfApproximation{CurvedSurfaceApproxChoice=UseSlider SliderMeshSettings=9} GlobalCurvilinear{Apply}
setups:
  Setup1: Electrostatic MaximumPasses=20 MinimumPasses=2 MinimumConvergedPasses=1 PercentRefinement=30 PercentError=1 NonLinearResidual=0.001

design Flatwise_0.30_Nointerleaved_INTTRAPRI (Maxwell 3D, Electrostatic, model units mm)
variables:
  freq_hz = 28500Hz
  volt_ac = 141/28500*Freq
geometry:
  Region [vacuum] = region(percentage_offset=0 on all sides)
  Np1..Np8, Ns1..Ns8 [copper] = imported_body(C:\Users\karlr\Documents\ICMaSS_sweeping\flatwise_0.1_0.3.step)
  plate_1, plate_2 [silicon - Copy] = imported_body(C:\Users\karlr\Documents\ICMaSS_sweeping\flatwise_0.1_0.3.step)
  Body1 [ferrite - Copy (2)] = imported_body(C:\Users\karlr\Documents\ICMaSS_sweeping\flatwise_0.1_0.3.step)
  Body1_1, Body1_2 [aluminum] = imported_body(C:\Users\karlr\Documents\ICMaSS_sweeping\flatwise_0.1_0.3.step)
  Body1_3 [ferrite - Copy (2)] = imported_body(C:\Users\karlr\Documents\ICMaSS_sweeping\flatwise_0.1_0.3.step)
  Body1_4, Body1_5 [aluminum] = imported_body(C:\Users\karlr\Documents\ICMaSS_sweeping\flatwise_0.1_0.3.step)
  Np1_Section1 = Np1.section(plane=ZX)
  Np2_Section1 = Np2.section(plane=ZX)
  Np3_Section1 [copper] = Np3.section(plane=ZX)
  Np4_Section1 [copper] = Np4.section(plane=ZX)
  Np5_Section1 [copper] = Np5.section(plane=ZX)
  Np6_Section1 [copper] = Np6.section(plane=ZX)
  Np7_Section1 [copper] = Np7.section(plane=ZX)
  Np8_Section1 [copper] = Np8.section(plane=ZX)
  Ns1_Section1 = Ns1.section(plane=ZX)
  Ns2_Section1 = Ns2.section(plane=ZX)
  Ns3_Section1 [copper] = Ns3.section(plane=ZX)
  Ns4_Section1 [copper] = Ns4.section(plane=ZX)
  Ns5_Section1 [copper] = Ns5.section(plane=ZX)
  Ns6_Section1 [copper] = Ns6.section(plane=ZX)
  Ns7_Section1 [copper] = Ns7.section(plane=ZX)
  Ns8_Section1 [copper] = Ns8.section(plane=ZX)
  Np1_Section1_Separate1 [copper] = Np1_Section1.separate_bodies()
  Np1_Section1.delete()
  Np2_Section1_Separate1 [copper] = Np2_Section1.separate_bodies()
  Np2_Section1.delete()
  Np3_Section1.separate_bodies()
  Np4_Section1.separate_bodies()
  Np5_Section1.separate_bodies()
  Np6_Section1.separate_bodies()
  Np7_Section1.separate_bodies()
  Np8_Section1.separate_bodies()
  Ns1_Section1_Separate1 [copper] = Ns1_Section1.separate_bodies()
  Ns1_Section1.delete()
  Ns2_Section1_Separate1 [copper] = Ns2_Section1.separate_bodies()
  Ns2_Section1.delete()
  Ns3_Section1.separate_bodies()
  Ns4_Section1.separate_bodies()
  Ns5_Section1.separate_bodies()
  Ns6_Section1.separate_bodies()
  Ns7_Section1.separate_bodies()
  Ns8_Section1.separate_bodies()
  Rectangle1 [non-model] = rectangle(corner=(30.6mm, 25.43mm, 6mm), z_size=6.6666667mm, x_size=-24.6mm)
  Rectangle2 [non-model] = rectangle(corner=(18.3mm, 59.16mm, 1.6666608e-08mm), y_size=-67.46mm, z_size=18.666667mm)
  Rectangle2.move(12.3mm, 0mm, -8.3333003e-09mm)
  Rectangle2.move(-6.6mm, -0.43mm, -0.14166667mm)
  Rectangle2.move(2.1316282e-13mm, 0.135mm, 0.14166666mm)
  Rectangle2.move(0.2mm, 0mm, 0mm)
  Rectangle2.move(1mm, -3mm, 0mm)
  Rectangle2.move(-0.6mm, 0mm, 0mm)
  Rectangle2.move(-0.1mm, 0mm, 0mm)
  Rectangle2.move(2.4mm, -1.7763568e-14mm, -2.4868996e-14mm)
  group core_assembled_flatwise = Np1..Np8, Ns1..Ns8, plate_1, plate_2, Np3_Section1, Np4_Section1, Np5_Section1, Np6_Section1, Np7_Section1, Np8_Section1, Ns3_Section1, Ns4_Section1, Ns5_Section1, Ns6_Section1, Ns7_Section1, Ns8_Section1, Np1_Section1_Separate1, Np2_Section1_Separate1, Ns1_Section1_Separate1, Ns2_Section1_Separate1
  group core_together_1 = Body1, Body1_1, Body1_2
  group core_together = Body1_3, Body1_4, Body1_5
boundaries and excitations:
  Voltage1: Voltage Objects=Np1 Voltage="(1/7*7) V"
  Voltage2: Voltage Objects=Ns1 Voltage="(1/7*6) V"
  Voltage3: Voltage Objects=Np2 Voltage="(1/7*5) V"
  Voltage4: Voltage Objects=Ns2 Voltage="(1/7*4) V"
  Voltage5: Voltage Objects=Np3 Voltage="(1/7*3) V"
  Voltage6: Voltage Objects=Ns3 Voltage="(1/7*2) V"
  Voltage7: Voltage Objects=Np4 Voltage="(1/7*1) V"
  Voltage8: Voltage Objects=Ns4 Voltage=0mV
parameters:
  Matrix1: Matrix Voltage1..Voltage8: NumberOfTurns=1
mesh:
  Length1: LengthBased Objects=[Body1, Body1_1..Body1_5] MaxLength=5mm
  Length2: LengthBased Objects=[Np1..Np8, Ns1..Ns8, plate_1, plate_2] MaxLength=2mm
  initial mesh: GlobalSurfApproximation{CurvedSurfaceApproxChoice=UseSlider SliderMeshSettings=9} GlobalCurvilinear{Apply}
setups:
  Setup1: Electrostatic MaximumPasses=20 MinimumPasses=2 MinimumConvergedPasses=1 PercentRefinement=30 PercentError=1 NonLinearResidual=0.001

design Flatwise_0.30_Nointerleaved_INTTRASEC (Maxwell 3D, Electrostatic, model units mm)
variables:
  freq_hz = 28500Hz
  volt_ac = 141/28500*Freq
geometry:
  Region [vacuum] = region(percentage_offset=0 on all sides)
  Np1..Np8, Ns1..Ns8 [copper] = imported_body(C:\Users\karlr\Documents\ICMaSS_sweeping\flatwise_0.1_0.3.step)
  plate_1, plate_2 [silicon - Copy] = imported_body(C:\Users\karlr\Documents\ICMaSS_sweeping\flatwise_0.1_0.3.step)
  Body1 [ferrite - Copy (2)] = imported_body(C:\Users\karlr\Documents\ICMaSS_sweeping\flatwise_0.1_0.3.step)
  Body1_1, Body1_2 [aluminum] = imported_body(C:\Users\karlr\Documents\ICMaSS_sweeping\flatwise_0.1_0.3.step)
  Body1_3 [ferrite - Copy (2)] = imported_body(C:\Users\karlr\Documents\ICMaSS_sweeping\flatwise_0.1_0.3.step)
  Body1_4, Body1_5 [aluminum] = imported_body(C:\Users\karlr\Documents\ICMaSS_sweeping\flatwise_0.1_0.3.step)
  Np1_Section1 = Np1.section(plane=ZX)
  Np2_Section1 = Np2.section(plane=ZX)
  Np3_Section1 [copper] = Np3.section(plane=ZX)
  Np4_Section1 [copper] = Np4.section(plane=ZX)
  Np5_Section1 [copper] = Np5.section(plane=ZX)
  Np6_Section1 [copper] = Np6.section(plane=ZX)
  Np7_Section1 [copper] = Np7.section(plane=ZX)
  Np8_Section1 [copper] = Np8.section(plane=ZX)
  Ns1_Section1 = Ns1.section(plane=ZX)
  Ns2_Section1 = Ns2.section(plane=ZX)
  Ns3_Section1 [copper] = Ns3.section(plane=ZX)
  Ns4_Section1 [copper] = Ns4.section(plane=ZX)
  Ns5_Section1 [copper] = Ns5.section(plane=ZX)
  Ns6_Section1 [copper] = Ns6.section(plane=ZX)
  Ns7_Section1 [copper] = Ns7.section(plane=ZX)
  Ns8_Section1 [copper] = Ns8.section(plane=ZX)
  Np1_Section1_Separate1 [copper] = Np1_Section1.separate_bodies()
  Np1_Section1.delete()
  Np2_Section1_Separate1 [copper] = Np2_Section1.separate_bodies()
  Np2_Section1.delete()
  Np3_Section1.separate_bodies()
  Np4_Section1.separate_bodies()
  Np5_Section1.separate_bodies()
  Np6_Section1.separate_bodies()
  Np7_Section1.separate_bodies()
  Np8_Section1.separate_bodies()
  Ns1_Section1_Separate1 [copper] = Ns1_Section1.separate_bodies()
  Ns1_Section1.delete()
  Ns2_Section1_Separate1 [copper] = Ns2_Section1.separate_bodies()
  Ns2_Section1.delete()
  Ns3_Section1.separate_bodies()
  Ns4_Section1.separate_bodies()
  Ns5_Section1.separate_bodies()
  Ns6_Section1.separate_bodies()
  Ns7_Section1.separate_bodies()
  Ns8_Section1.separate_bodies()
  Rectangle1 [non-model] = rectangle(corner=(30.6mm, 25.43mm, 6mm), z_size=6.6666667mm, x_size=-24.6mm)
  Rectangle2 [non-model] = rectangle(corner=(18.3mm, 59.16mm, 1.6666608e-08mm), y_size=-67.46mm, z_size=18.666667mm)
  Rectangle2.move(12.3mm, 0mm, -8.3333003e-09mm)
  Rectangle2.move(-6.6mm, -0.43mm, -0.14166667mm)
  Rectangle2.move(2.1316282e-13mm, 0.135mm, 0.14166666mm)
  Rectangle2.move(0.2mm, 0mm, 0mm)
  Rectangle2.move(1mm, -3mm, 0mm)
  Rectangle2.move(-0.6mm, 0mm, 0mm)
  Rectangle2.move(-0.1mm, 0mm, 0mm)
  Rectangle2.move(2.4mm, -1.7763568e-14mm, -2.4868996e-14mm)
  group core_assembled_flatwise = Np1..Np8, Ns1..Ns8, plate_1, plate_2, Np3_Section1, Np4_Section1, Np5_Section1, Np6_Section1, Np7_Section1, Np8_Section1, Ns3_Section1, Ns4_Section1, Ns5_Section1, Ns6_Section1, Ns7_Section1, Ns8_Section1, Np1_Section1_Separate1, Np2_Section1_Separate1, Ns1_Section1_Separate1, Ns2_Section1_Separate1
  group core_together_1 = Body1, Body1_1, Body1_2
  group core_together = Body1_3, Body1_4, Body1_5
boundaries and excitations:
  Voltage1: Voltage Objects=Np5 Voltage="(1/7*7) V"
  Voltage2: Voltage Objects=Ns5 Voltage="(1/7*6) V"
  Voltage3: Voltage Objects=Np6 Voltage="(1/7*5) V"
  Voltage4: Voltage Objects=Ns6 Voltage="(1/7*4) V"
  Voltage5: Voltage Objects=Np7 Voltage="(1/7*3) V"
  Voltage6: Voltage Objects=Ns7 Voltage="(1/7*2) V"
  Voltage7: Voltage Objects=Np8 Voltage="(1/7*1) V"
  Voltage8: Voltage Objects=Ns8 Voltage=0mV
parameters:
  Matrix1: Matrix Voltage1..Voltage8: NumberOfTurns=1
mesh:
  Length1: LengthBased Objects=[Body1, Body1_1..Body1_5] MaxLength=5mm
  Length2: LengthBased Objects=[Np1..Np8, Ns1..Ns8, plate_1, plate_2] MaxLength=2mm
  initial mesh: GlobalSurfApproximation{CurvedSurfaceApproxChoice=UseSlider SliderMeshSettings=9} GlobalCurvilinear{Apply}
setups:
  Setup1: Electrostatic MaximumPasses=20 MinimumPasses=2 MinimumConvergedPasses=1 PercentRefinement=30 PercentError=1 NonLinearResidual=0.001

design Flatwise_0.30_PSSPinterleaved_INTTRAPRI (Maxwell 3D, Electrostatic, model units mm)
variables:
  freq_hz = 28500Hz
  volt_ac = 141/28500*Freq
geometry:
  Region [vacuum] = region(percentage_offset=0 on all sides)
  Np1..Np8, Ns1..Ns8 [copper] = imported_body(C:\Users\karlr\Documents\ICMaSS_sweeping\flatwise_0.1_0.3.step)
  plate_1, plate_2 [silicon - Copy] = imported_body(C:\Users\karlr\Documents\ICMaSS_sweeping\flatwise_0.1_0.3.step)
  Body1 [ferrite - Copy (2)] = imported_body(C:\Users\karlr\Documents\ICMaSS_sweeping\flatwise_0.1_0.3.step)
  Body1_1, Body1_2 [aluminum] = imported_body(C:\Users\karlr\Documents\ICMaSS_sweeping\flatwise_0.1_0.3.step)
  Body1_3 [ferrite - Copy (2)] = imported_body(C:\Users\karlr\Documents\ICMaSS_sweeping\flatwise_0.1_0.3.step)
  Body1_4, Body1_5 [aluminum] = imported_body(C:\Users\karlr\Documents\ICMaSS_sweeping\flatwise_0.1_0.3.step)
  Np1_Section1 = Np1.section(plane=ZX)
  Np2_Section1 = Np2.section(plane=ZX)
  Np3_Section1 [copper] = Np3.section(plane=ZX)
  Np4_Section1 [copper] = Np4.section(plane=ZX)
  Np5_Section1 [copper] = Np5.section(plane=ZX)
  Np6_Section1 [copper] = Np6.section(plane=ZX)
  Np7_Section1 [copper] = Np7.section(plane=ZX)
  Np8_Section1 [copper] = Np8.section(plane=ZX)
  Ns1_Section1 = Ns1.section(plane=ZX)
  Ns2_Section1 = Ns2.section(plane=ZX)
  Ns3_Section1 [copper] = Ns3.section(plane=ZX)
  Ns4_Section1 [copper] = Ns4.section(plane=ZX)
  Ns5_Section1 [copper] = Ns5.section(plane=ZX)
  Ns6_Section1 [copper] = Ns6.section(plane=ZX)
  Ns7_Section1 [copper] = Ns7.section(plane=ZX)
  Ns8_Section1 [copper] = Ns8.section(plane=ZX)
  Np1_Section1_Separate1 [copper] = Np1_Section1.separate_bodies()
  Np1_Section1.delete()
  Np2_Section1_Separate1 [copper] = Np2_Section1.separate_bodies()
  Np2_Section1.delete()
  Np3_Section1.separate_bodies()
  Np4_Section1.separate_bodies()
  Np5_Section1.separate_bodies()
  Np6_Section1.separate_bodies()
  Np7_Section1.separate_bodies()
  Np8_Section1.separate_bodies()
  Ns1_Section1_Separate1 [copper] = Ns1_Section1.separate_bodies()
  Ns1_Section1.delete()
  Ns2_Section1_Separate1 [copper] = Ns2_Section1.separate_bodies()
  Ns2_Section1.delete()
  Ns3_Section1.separate_bodies()
  Ns4_Section1.separate_bodies()
  Ns5_Section1.separate_bodies()
  Ns6_Section1.separate_bodies()
  Ns7_Section1.separate_bodies()
  Ns8_Section1.separate_bodies()
  Rectangle1 [non-model] = rectangle(corner=(30.6mm, 25.43mm, 6mm), z_size=6.6666667mm, x_size=-24.6mm)
  Rectangle2 [non-model] = rectangle(corner=(18.3mm, 59.16mm, 1.6666608e-08mm), y_size=-67.46mm, z_size=18.666667mm)
  Rectangle2.move(12.3mm, 0mm, -8.3333003e-09mm)
  Rectangle2.move(-6.6mm, -0.43mm, -0.14166667mm)
  Rectangle2.move(2.1316282e-13mm, 0.135mm, 0.14166666mm)
  Rectangle2.move(0.2mm, 0mm, 0mm)
  Rectangle2.move(1mm, -3mm, 0mm)
  Rectangle2.move(-0.6mm, 0mm, 0mm)
  Rectangle2.move(-0.1mm, 0mm, 0mm)
  Rectangle2.move(2.4mm, -1.7763568e-14mm, -2.4868996e-14mm)
  group core_assembled_flatwise = Np1..Np8, Ns1..Ns8, plate_1, plate_2, Np3_Section1, Np4_Section1, Np5_Section1, Np6_Section1, Np7_Section1, Np8_Section1, Ns3_Section1, Ns4_Section1, Ns5_Section1, Ns6_Section1, Ns7_Section1, Ns8_Section1, Np1_Section1_Separate1, Np2_Section1_Separate1, Ns1_Section1_Separate1, Ns2_Section1_Separate1
  group core_together_1 = Body1, Body1_1, Body1_2
  group core_together = Body1_3, Body1_4, Body1_5
boundaries and excitations:
  Voltage1: Voltage Objects=Np1 Voltage="(1/7*7) V"
  Voltage2: Voltage Objects=Ns2 Voltage="(1/7*6) V"
  Voltage3: Voltage Objects=Np3 Voltage="(1/7*5) V"
  Voltage4: Voltage Objects=Ns4 Voltage="(1/7*4) V"
  Voltage5: Voltage Objects=Np5 Voltage="(1/7*3) V"
  Voltage6: Voltage Objects=Ns6 Voltage="(1/7*2) V"
  Voltage7: Voltage Objects=Np7 Voltage="(1/7*1) V"
  Voltage8: Voltage Objects=Ns8 Voltage=0mV
parameters:
  Matrix1: Matrix Voltage1..Voltage8: NumberOfTurns=1
mesh:
  Length1: LengthBased Objects=[Body1, Body1_1..Body1_5] MaxLength=5mm
  Length2: LengthBased Objects=[Np1..Np8, Ns1..Ns8, plate_1, plate_2] MaxLength=2mm
  initial mesh: GlobalSurfApproximation{CurvedSurfaceApproxChoice=UseSlider SliderMeshSettings=9} GlobalCurvilinear{Apply}
setups:
  Setup1: Electrostatic MaximumPasses=20 MinimumPasses=2 MinimumConvergedPasses=1 PercentRefinement=30 PercentError=1 NonLinearResidual=0.001

design Flatwise_0.30_PSSPinterleaved_INTTRASEC (Maxwell 3D, Electrostatic, model units mm)
variables:
  freq_hz = 28500Hz
  volt_ac = 141/28500*Freq
geometry:
  Region [vacuum] = region(percentage_offset=0 on all sides)
  Np1..Np8, Ns1..Ns8 [copper] = imported_body(C:\Users\karlr\Documents\ICMaSS_sweeping\flatwise_0.1_0.3.step)
  plate_1, plate_2 [silicon - Copy] = imported_body(C:\Users\karlr\Documents\ICMaSS_sweeping\flatwise_0.1_0.3.step)
  Body1 [ferrite - Copy (2)] = imported_body(C:\Users\karlr\Documents\ICMaSS_sweeping\flatwise_0.1_0.3.step)
  Body1_1, Body1_2 [aluminum] = imported_body(C:\Users\karlr\Documents\ICMaSS_sweeping\flatwise_0.1_0.3.step)
  Body1_3 [ferrite - Copy (2)] = imported_body(C:\Users\karlr\Documents\ICMaSS_sweeping\flatwise_0.1_0.3.step)
  Body1_4, Body1_5 [aluminum] = imported_body(C:\Users\karlr\Documents\ICMaSS_sweeping\flatwise_0.1_0.3.step)
  Np1_Section1 = Np1.section(plane=ZX)
  Np2_Section1 = Np2.section(plane=ZX)
  Np3_Section1 [copper] = Np3.section(plane=ZX)
  Np4_Section1 [copper] = Np4.section(plane=ZX)
  Np5_Section1 [copper] = Np5.section(plane=ZX)
  Np6_Section1 [copper] = Np6.section(plane=ZX)
  Np7_Section1 [copper] = Np7.section(plane=ZX)
  Np8_Section1 [copper] = Np8.section(plane=ZX)
  Ns1_Section1 = Ns1.section(plane=ZX)
  Ns2_Section1 = Ns2.section(plane=ZX)
  Ns3_Section1 [copper] = Ns3.section(plane=ZX)
  Ns4_Section1 [copper] = Ns4.section(plane=ZX)
  Ns5_Section1 [copper] = Ns5.section(plane=ZX)
  Ns6_Section1 [copper] = Ns6.section(plane=ZX)
  Ns7_Section1 [copper] = Ns7.section(plane=ZX)
  Ns8_Section1 [copper] = Ns8.section(plane=ZX)
  Np1_Section1_Separate1 [copper] = Np1_Section1.separate_bodies()
  Np1_Section1.delete()
  Np2_Section1_Separate1 [copper] = Np2_Section1.separate_bodies()
  Np2_Section1.delete()
  Np3_Section1.separate_bodies()
  Np4_Section1.separate_bodies()
  Np5_Section1.separate_bodies()
  Np6_Section1.separate_bodies()
  Np7_Section1.separate_bodies()
  Np8_Section1.separate_bodies()
  Ns1_Section1_Separate1 [copper] = Ns1_Section1.separate_bodies()
  Ns1_Section1.delete()
  Ns2_Section1_Separate1 [copper] = Ns2_Section1.separate_bodies()
  Ns2_Section1.delete()
  Ns3_Section1.separate_bodies()
  Ns4_Section1.separate_bodies()
  Ns5_Section1.separate_bodies()
  Ns6_Section1.separate_bodies()
  Ns7_Section1.separate_bodies()
  Ns8_Section1.separate_bodies()
  Rectangle1 [non-model] = rectangle(corner=(30.6mm, 25.43mm, 6mm), z_size=6.6666667mm, x_size=-24.6mm)
  Rectangle2 [non-model] = rectangle(corner=(18.3mm, 59.16mm, 1.6666608e-08mm), y_size=-67.46mm, z_size=18.666667mm)
  Rectangle2.move(12.3mm, 0mm, -8.3333003e-09mm)
  Rectangle2.move(-6.6mm, -0.43mm, -0.14166667mm)
  Rectangle2.move(2.1316282e-13mm, 0.135mm, 0.14166666mm)
  Rectangle2.move(0.2mm, 0mm, 0mm)
  Rectangle2.move(1mm, -3mm, 0mm)
  Rectangle2.move(-0.6mm, 0mm, 0mm)
  Rectangle2.move(-0.1mm, 0mm, 0mm)
  Rectangle2.move(2.4mm, -1.7763568e-14mm, -2.4868996e-14mm)
  group core_assembled_flatwise = Np1..Np8, Ns1..Ns8, plate_1, plate_2, Np3_Section1, Np4_Section1, Np5_Section1, Np6_Section1, Np7_Section1, Np8_Section1, Ns3_Section1, Ns4_Section1, Ns5_Section1, Ns6_Section1, Ns7_Section1, Ns8_Section1, Np1_Section1_Separate1, Np2_Section1_Separate1, Ns1_Section1_Separate1, Ns2_Section1_Separate1
  group core_together_1 = Body1, Body1_1, Body1_2
  group core_together = Body1_3, Body1_4, Body1_5
boundaries and excitations:
  Voltage1: Voltage Objects=Ns1 Voltage="(1/7*7) V"
  Voltage2: Voltage Objects=Np2 Voltage="(1/7*6) V"
  Voltage3: Voltage Objects=Ns3 Voltage="(1/7*5) V"
  Voltage4: Voltage Objects=Np4 Voltage="(1/7*4) V"
  Voltage5: Voltage Objects=Ns5 Voltage="(1/7*3) V"
  Voltage6: Voltage Objects=Np6 Voltage="(1/7*2) V"
  Voltage7: Voltage Objects=Ns7 Voltage="(1/7*1) V"
  Voltage8: Voltage Objects=Np8 Voltage=0mV
parameters:
  Matrix1: Matrix Voltage1..Voltage8: NumberOfTurns=1
mesh:
  Length1: LengthBased Objects=[Body1, Body1_1..Body1_5] MaxLength=5mm
  Length2: LengthBased Objects=[Np1..Np8, Ns1..Ns8, plate_1, plate_2] MaxLength=2mm
  initial mesh: GlobalSurfApproximation{CurvedSurfaceApproxChoice=UseSlider SliderMeshSettings=9} GlobalCurvilinear{Apply}
setups:
  Setup1: Electrostatic MaximumPasses=20 MinimumPasses=2 MinimumConvergedPasses=1 PercentRefinement=30 PercentError=1 NonLinearResidual=0.001

design Flatwise_0.30_interleaved_EFIELD (Maxwell 3D, Electrostatic, model units mm)
variables:
  freq_hz = 28500Hz
  volt_ac = 141/28500*Freq
geometry:
  Region [vacuum] = region(percentage_offset=0 on all sides)
  Np1..Np8, Ns1..Ns8 [copper] = imported_body(C:\Users\karlr\Documents\ICMaSS_sweeping\flatwise_0.1_0.3.step)
  plate_1, plate_2 [silicon - Copy] = imported_body(C:\Users\karlr\Documents\ICMaSS_sweeping\flatwise_0.1_0.3.step)
  Body1 [ferrite - Copy (2)] = imported_body(C:\Users\karlr\Documents\ICMaSS_sweeping\flatwise_0.1_0.3.step)
  Body1_1, Body1_2 [aluminum] = imported_body(C:\Users\karlr\Documents\ICMaSS_sweeping\flatwise_0.1_0.3.step)
  Body1_3 [ferrite - Copy (2)] = imported_body(C:\Users\karlr\Documents\ICMaSS_sweeping\flatwise_0.1_0.3.step)
  Body1_4, Body1_5 [aluminum] = imported_body(C:\Users\karlr\Documents\ICMaSS_sweeping\flatwise_0.1_0.3.step)
  Np1_Section1 = Np1.section(plane=ZX)
  Np2_Section1 = Np2.section(plane=ZX)
  Np3_Section1 [copper] = Np3.section(plane=ZX)
  Np4_Section1 [copper] = Np4.section(plane=ZX)
  Np5_Section1 [copper] = Np5.section(plane=ZX)
  Np6_Section1 [copper] = Np6.section(plane=ZX)
  Np7_Section1 [copper] = Np7.section(plane=ZX)
  Np8_Section1 [copper] = Np8.section(plane=ZX)
  Ns1_Section1 = Ns1.section(plane=ZX)
  Ns2_Section1 = Ns2.section(plane=ZX)
  Ns3_Section1 [copper] = Ns3.section(plane=ZX)
  Ns4_Section1 [copper] = Ns4.section(plane=ZX)
  Ns5_Section1 [copper] = Ns5.section(plane=ZX)
  Ns6_Section1 [copper] = Ns6.section(plane=ZX)
  Ns7_Section1 [copper] = Ns7.section(plane=ZX)
  Ns8_Section1 [copper] = Ns8.section(plane=ZX)
  Np1_Section1_Separate1 [copper] = Np1_Section1.separate_bodies()
  Np1_Section1.delete()
  Np2_Section1_Separate1 [copper] = Np2_Section1.separate_bodies()
  Np2_Section1.delete()
  Np3_Section1.separate_bodies()
  Np4_Section1.separate_bodies()
  Np5_Section1.separate_bodies()
  Np6_Section1.separate_bodies()
  Np7_Section1.separate_bodies()
  Np8_Section1.separate_bodies()
  Ns1_Section1_Separate1 [copper] = Ns1_Section1.separate_bodies()
  Ns1_Section1.delete()
  Ns2_Section1_Separate1 [copper] = Ns2_Section1.separate_bodies()
  Ns2_Section1.delete()
  Ns3_Section1.separate_bodies()
  Ns4_Section1.separate_bodies()
  Ns5_Section1.separate_bodies()
  Ns6_Section1.separate_bodies()
  Ns7_Section1.separate_bodies()
  Ns8_Section1.separate_bodies()
  Rectangle2 = rectangle(corner=(36.6mm, 25.43mm, 1.666661e-08mm), z_size=18.666667mm, x_size=-36.6mm)
  group core_assembled_flatwise = Np1..Np8, Ns1..Ns8, plate_1, plate_2, Np3_Section1, Np4_Section1, Np5_Section1, Np6_Section1, Np7_Section1, Np8_Section1, Ns3_Section1, Ns4_Section1, Ns5_Section1, Ns6_Section1, Ns7_Section1, Ns8_Section1, Np1_Section1_Separate1, Np2_Section1_Separate1, Ns1_Section1_Separate1, Ns2_Section1_Separate1
  group core_together_1 = Body1, Body1_1, Body1_2
  group core_together = Body1_3, Body1_4, Body1_5
boundaries and excitations:
  Voltage1: Voltage Objects=[Np1..Np8] Voltage=100V
  Voltage2: Voltage Objects=[Ns1..Ns8] Voltage=0mV
parameters:
  Matrix1: Matrix Voltage1, Voltage2: NumberOfTurns=1
mesh:
  Length1: LengthBased Objects=[Body1, Body1_1..Body1_5] MaxLength=5mm
  Length2: LengthBased Objects=[Np1..Np8, Ns1..Ns8, plate_1, plate_2] MaxLength=2mm
  initial mesh: GlobalSurfApproximation{CurvedSurfaceApproxChoice=UseSlider SliderMeshSettings=9} GlobalCurvilinear{Apply}
setups:
  Setup1: Electrostatic MaximumPasses=20 MinimumPasses=2 MinimumConvergedPasses=1 PercentRefinement=30 PercentError=1 NonLinearResidual=0.001
field plots:
  Mag_E1: E over Rectangle2.face on Setup1 : LastAdaptive

design Flatwise_0.30_interleaved_full3 (Maxwell 3D, EddyCurrent, model units mm)
variables:
  freq_hz = 28500Hz
  volt_ac = 141/28500*Freq
geometry:
  Region [vacuum] = region(percentage_offset=0 on all sides)
  Np1..Np8, Ns1..Ns8 [copper] = imported_body(C:\Users\karlr\Documents\ICMaSS_sweeping\flatwise_0.1_0.3.step)
  plate_1, plate_2 [silicon - Copy] = imported_body(C:\Users\karlr\Documents\ICMaSS_sweeping\flatwise_0.1_0.3.step)
  Body1 [ferrite - Copy (2)] = imported_body(C:\Users\karlr\Documents\ICMaSS_sweeping\flatwise_0.1_0.3.step)
  Body1_1, Body1_2 [aluminum] = imported_body(C:\Users\karlr\Documents\ICMaSS_sweeping\flatwise_0.1_0.3.step)
  Body1_3 [ferrite - Copy (2)] = imported_body(C:\Users\karlr\Documents\ICMaSS_sweeping\flatwise_0.1_0.3.step)
  Body1_4, Body1_5 [aluminum] = imported_body(C:\Users\karlr\Documents\ICMaSS_sweeping\flatwise_0.1_0.3.step)
  Np1_Section1 = Np1.section(plane=ZX)
  Np2_Section1 = Np2.section(plane=ZX)
  Np3_Section1 [copper] = Np3.section(plane=ZX)
  Np4_Section1 [copper] = Np4.section(plane=ZX)
  Np5_Section1 [copper] = Np5.section(plane=ZX)
  Np6_Section1 [copper] = Np6.section(plane=ZX)
  Np7_Section1 [copper] = Np7.section(plane=ZX)
  Np8_Section1 [copper] = Np8.section(plane=ZX)
  Ns1_Section1 = Ns1.section(plane=ZX)
  Ns2_Section1 = Ns2.section(plane=ZX)
  Ns3_Section1 [copper] = Ns3.section(plane=ZX)
  Ns4_Section1 [copper] = Ns4.section(plane=ZX)
  Ns5_Section1 [copper] = Ns5.section(plane=ZX)
  Ns6_Section1 [copper] = Ns6.section(plane=ZX)
  Ns7_Section1 [copper] = Ns7.section(plane=ZX)
  Ns8_Section1 [copper] = Ns8.section(plane=ZX)
  Np1_Section1_Separate1 [copper] = Np1_Section1.separate_bodies()
  Np1_Section1.delete()
  Np2_Section1_Separate1 [copper] = Np2_Section1.separate_bodies()
  Np2_Section1.delete()
  Np3_Section1.separate_bodies()
  Np4_Section1.separate_bodies()
  Np5_Section1.separate_bodies()
  Np6_Section1.separate_bodies()
  Np7_Section1.separate_bodies()
  Np8_Section1.separate_bodies()
  Ns1_Section1_Separate1 [copper] = Ns1_Section1.separate_bodies()
  Ns1_Section1.delete()
  Ns2_Section1_Separate1 [copper] = Ns2_Section1.separate_bodies()
  Ns2_Section1.delete()
  Ns3_Section1.separate_bodies()
  Ns4_Section1.separate_bodies()
  Ns5_Section1.separate_bodies()
  Ns6_Section1.separate_bodies()
  Ns7_Section1.separate_bodies()
  Ns8_Section1.separate_bodies()
  Rectangle1 [non-model] = rectangle(corner=(36.6mm, 25.43mm, 1.6666608e-08mm), z_size=18.666667mm, x_size=-36.6mm)
  group core_assembled_flatwise = Np1..Np8, Ns1..Ns8, plate_1, plate_2, Np3_Section1, Np4_Section1, Np5_Section1, Np6_Section1, Np7_Section1, Np8_Section1, Ns3_Section1, Ns4_Section1, Ns5_Section1, Ns6_Section1, Ns7_Section1, Ns8_Section1, Np1_Section1_Separate1, Np2_Section1_Separate1, Ns1_Section1_Separate1, Ns2_Section1_Separate1
  group core_together_1 = Body1, Body1_1, Body1_2
  group core_together = Body1_3, Body1_4, Body1_5
boundaries and excitations:
  Ns_1: Coil Terminal Objects=Ns1_Section1_Separate1 Conductor_number=1 Winding=Ns Point_out_of_terminal=true
  Ns_2: Coil Terminal Objects=Ns2_Section1_Separate1 Conductor_number=1 Winding=Ns Point_out_of_terminal=true
  Ns_3: Coil Terminal Objects=Ns3_Section1 Conductor_number=1 Winding=Ns Point_out_of_terminal=true
  Ns_4: Coil Terminal Objects=Ns4_Section1 Conductor_number=1 Winding=Ns Point_out_of_terminal=true
  Ns_5: Coil Terminal Objects=Ns5_Section1 Conductor_number=1 Winding=Ns Point_out_of_terminal=true
  Ns_6: Coil Terminal Objects=Ns6_Section1 Conductor_number=1 Winding=Ns Point_out_of_terminal=true
  Ns_7: Coil Terminal Objects=Ns7_Section1 Conductor_number=1 Winding=Ns Point_out_of_terminal=true
  Ns_8: Coil Terminal Objects=Ns8_Section1 Conductor_number=1 Winding=Ns Point_out_of_terminal=true
  Np_1: Coil Terminal Objects=Np1_Section1_Separate1 Conductor_number=1 Winding=Np Point_out_of_terminal=false
  Np_2: Coil Terminal Objects=Np2_Section1_Separate1 Conductor_number=1 Winding=Np Point_out_of_terminal=false
  Np_3: Coil Terminal Objects=Np3_Section1 Conductor_number=1 Winding=Np Point_out_of_terminal=false
  Np_4: Coil Terminal Objects=Np4_Section1 Conductor_number=1 Winding=Np Point_out_of_terminal=false
  Np_5: Coil Terminal Objects=Np5_Section1 Conductor_number=1 Winding=Np Point_out_of_terminal=false
  Np_6: Coil Terminal Objects=Np6_Section1 Conductor_number=1 Winding=Np Point_out_of_terminal=false
  Np_7: Coil Terminal Objects=Np7_Section1 Conductor_number=1 Winding=Np Point_out_of_terminal=false
  Np_8: Coil Terminal Objects=Np8_Section1 Conductor_number=1 Winding=Np Point_out_of_terminal=false
  Np: Winding Group Type=Voltage IsSolid=true Current=16.36A Resistance=0ohm Inductance=0nH Voltage=volt_ac ParallelBranchesNum=1 Phase=0rad
  Ns: Winding Group Type=Current IsSolid=true Current=1000*1.41/volt_ac*1.414 ParallelBranchesNum=1 Phase=0.1522rad
  core loss on: Body1, Body1_3
parameters:
  Matrix1: Matrix Np, Ns:
mesh:
  Length1: LengthBased Objects=[Body1, Body1_1..Body1_5] MaxLength=1mm
  SkinDepth1: SkinDepthBased Objects=[Np1..Np8, Ns1..Ns8] SkinDepth=0.39145843mm SurfTriMaxLength=1mm NumLayers=2
  initial mesh: GlobalSurfApproximation{CurvedSurfaceApproxChoice=UseSlider SliderMeshSettings=9} GlobalCurvilinear{Apply}
setups:
  Setup1: EddyCurrent MaximumPasses=20 MinimumPasses=2 MinimumConvergedPasses=1 PercentRefinement=30 PercentError=1 NonLinearResidual=0.0001 SmoothBHCurve Frequency=28.5kHz
field plots:
  Mag_B1: B over a plane on Setup1 : LastAdaptive at Freq=28.5kHz Phase=45deg
reports:
  L Table 1: Matrix1.L(Np,Np), Matrix1.L(Ns,Np), Matrix1.L(Np,Ns), Matrix1.L(Ns,Ns), Matrix1.R(Np,Np), Matrix1.R(Ns,Np), Matrix1.R(Np,Ns), Matrix1.R(Ns,Ns) vs Freq on Setup1 : LastAdaptive

design Flatwise_0.30_interleaved_full4 (Maxwell 3D, EddyCurrent, model units mm)
variables:
  freq_hz = 28500Hz
  volt_ac = 141/28500*Freq
geometry:
  Region [vacuum] = region(percentage_offset=0 on all sides)
  Np1..Np8, Ns1..Ns8 [copper] = imported_body(C:\Users\karlr\Documents\ICMaSS_sweeping\flatwise_0.1_0.3.step)
  plate_1, plate_2 [silicon - Copy] = imported_body(C:\Users\karlr\Documents\ICMaSS_sweeping\flatwise_0.1_0.3.step)
  Body1 [ferrite - Copy (2)] = imported_body(C:\Users\karlr\Documents\ICMaSS_sweeping\flatwise_0.1_0.3.step)
  Body1_1, Body1_2 [aluminum] = imported_body(C:\Users\karlr\Documents\ICMaSS_sweeping\flatwise_0.1_0.3.step)
  Body1_3 [ferrite - Copy (2)] = imported_body(C:\Users\karlr\Documents\ICMaSS_sweeping\flatwise_0.1_0.3.step)
  Body1_4, Body1_5 [aluminum] = imported_body(C:\Users\karlr\Documents\ICMaSS_sweeping\flatwise_0.1_0.3.step)
  Np1_Section1 = Np1.section(plane=ZX)
  Np2_Section1 = Np2.section(plane=ZX)
  Np3_Section1 [copper] = Np3.section(plane=ZX)
  Np4_Section1 [copper] = Np4.section(plane=ZX)
  Np5_Section1 [copper] = Np5.section(plane=ZX)
  Np6_Section1 [copper] = Np6.section(plane=ZX)
  Np7_Section1 [copper] = Np7.section(plane=ZX)
  Np8_Section1 [copper] = Np8.section(plane=ZX)
  Ns1_Section1 = Ns1.section(plane=ZX)
  Ns2_Section1 = Ns2.section(plane=ZX)
  Ns3_Section1 [copper] = Ns3.section(plane=ZX)
  Ns4_Section1 [copper] = Ns4.section(plane=ZX)
  Ns5_Section1 [copper] = Ns5.section(plane=ZX)
  Ns6_Section1 [copper] = Ns6.section(plane=ZX)
  Ns7_Section1 [copper] = Ns7.section(plane=ZX)
  Ns8_Section1 [copper] = Ns8.section(plane=ZX)
  Np1_Section1_Separate1 [copper] = Np1_Section1.separate_bodies()
  Np1_Section1.delete()
  Np2_Section1_Separate1 [copper] = Np2_Section1.separate_bodies()
  Np2_Section1.delete()
  Np3_Section1.separate_bodies()
  Np4_Section1.separate_bodies()
  Np5_Section1.separate_bodies()
  Np6_Section1.separate_bodies()
  Np7_Section1.separate_bodies()
  Np8_Section1.separate_bodies()
  Ns1_Section1_Separate1 [copper] = Ns1_Section1.separate_bodies()
  Ns1_Section1.delete()
  Ns2_Section1_Separate1 [copper] = Ns2_Section1.separate_bodies()
  Ns2_Section1.delete()
  Ns3_Section1.separate_bodies()
  Ns4_Section1.separate_bodies()
  Ns5_Section1.separate_bodies()
  Ns6_Section1.separate_bodies()
  Ns7_Section1.separate_bodies()
  Ns8_Section1.separate_bodies()
  Rectangle1 [non-model] = rectangle(corner=(36.6mm, 25.43mm, 1.6666608e-08mm), z_size=18.666667mm, x_size=-36.6mm)
  Rectangle2 [non-model] = rectangle(corner=(6mm, 58.16mm, 9.3333333mm), x_size=24.6mm, y_size=-65.46mm)
  group core_assembled_flatwise = Np1..Np8, Ns1..Ns8, plate_1, plate_2, Np3_Section1, Np4_Section1, Np5_Section1, Np6_Section1, Np7_Section1, Np8_Section1, Ns3_Section1, Ns4_Section1, Ns5_Section1, Ns6_Section1, Ns7_Section1, Ns8_Section1, Np1_Section1_Separate1, Np2_Section1_Separate1, Ns1_Section1_Separate1, Ns2_Section1_Separate1
  group core_together_1 = Body1, Body1_1, Body1_2
  group core_together = Body1_3, Body1_4, Body1_5
boundaries and excitations:
  Ns_1: Coil Terminal Objects=Ns1_Section1_Separate1 Conductor_number=1 Winding=Ns Point_out_of_terminal=true
  Ns_2: Coil Terminal Objects=Ns2_Section1_Separate1 Conductor_number=1 Winding=Ns Point_out_of_terminal=true
  Ns_3: Coil Terminal Objects=Ns3_Section1 Conductor_number=1 Winding=Ns Point_out_of_terminal=true
  Ns_4: Coil Terminal Objects=Ns4_Section1 Conductor_number=1 Winding=Ns Point_out_of_terminal=true
  Ns_5: Coil Terminal Objects=Ns5_Section1 Conductor_number=1 Winding=Ns Point_out_of_terminal=true
  Ns_6: Coil Terminal Objects=Ns6_Section1 Conductor_number=1 Winding=Ns Point_out_of_terminal=true
  Ns_7: Coil Terminal Objects=Ns7_Section1 Conductor_number=1 Winding=Ns Point_out_of_terminal=true
  Ns_8: Coil Terminal Objects=Ns8_Section1 Conductor_number=1 Winding=Ns Point_out_of_terminal=true
  Np_1: Coil Terminal Objects=Np1_Section1_Separate1 Conductor_number=1 Winding=Np Point_out_of_terminal=false
  Np_2: Coil Terminal Objects=Np2_Section1_Separate1 Conductor_number=1 Winding=Np Point_out_of_terminal=false
  Np_3: Coil Terminal Objects=Np3_Section1 Conductor_number=1 Winding=Np Point_out_of_terminal=false
  Np_4: Coil Terminal Objects=Np4_Section1 Conductor_number=1 Winding=Np Point_out_of_terminal=false
  Np_5: Coil Terminal Objects=Np5_Section1 Conductor_number=1 Winding=Np Point_out_of_terminal=false
  Np_6: Coil Terminal Objects=Np6_Section1 Conductor_number=1 Winding=Np Point_out_of_terminal=false
  Np_7: Coil Terminal Objects=Np7_Section1 Conductor_number=1 Winding=Np Point_out_of_terminal=false
  Np_8: Coil Terminal Objects=Np8_Section1 Conductor_number=1 Winding=Np Point_out_of_terminal=false
  Np: Winding Group Type=Current IsSolid=true Current=1000*1.41/volt_ac*1.414 ParallelBranchesNum=1 Phase=0rad
  Ns: Winding Group Type=Current IsSolid=true Current=1000*1.41/volt_ac*1.414 ParallelBranchesNum=1 Phase=0.1522rad
  core loss on: Body1, Body1_3
parameters:
  Matrix1: Matrix Np, Ns:
mesh:
  Length1: LengthBased Objects=[Body1, Body1_1..Body1_5] MaxLength=1mm
  SkinDepth1: SkinDepthBased Objects=[Np1..Np8, Ns1..Ns8] SkinDepth=0.39145843mm SurfTriMaxLength=1mm NumLayers=2
  initial mesh: GlobalSurfApproximation{CurvedSurfaceApproxChoice=UseSlider SliderMeshSettings=9} GlobalCurvilinear{Apply}
setups:
  Setup1: EddyCurrent MaximumPasses=20 MinimumPasses=2 MinimumConvergedPasses=1 PercentRefinement=30 PercentError=1 NonLinearResidual=0.0001 SmoothBHCurve Frequency=28.5kHz
field plots:
  Mag_J1: J over a plane on Setup1 : LastAdaptive at Freq=28.5kHz Phase=45deg
reports:
  L Table 1: Matrix1.L(Np,Np), Matrix1.L(Ns,Np), Matrix1.L(Np,Ns), Matrix1.L(Ns,Ns), Matrix1.R(Np,Np), Matrix1.R(Ns,Np), Matrix1.R(Np,Ns), Matrix1.R(Ns,Ns) vs Freq on Setup1 : LastAdaptive

design Flatwise_0.30_interleaved_full5 (Maxwell 3D, EddyCurrent, model units mm)
variables:
  freq_hz = 28500Hz
  volt_ac = 141/28500*Freq
geometry:
  Region [vacuum] = region(percentage_offset=0 on all sides)
  Np1..Np8, Ns1..Ns8 [copper] = imported_body(C:\Users\karlr\Documents\ICMaSS_sweeping\flatwise_0.1_0.3.step)
  plate_1, plate_2 [silicon - Copy] = imported_body(C:\Users\karlr\Documents\ICMaSS_sweeping\flatwise_0.1_0.3.step)
  Body1 [ferrite - Copy (2)] = imported_body(C:\Users\karlr\Documents\ICMaSS_sweeping\flatwise_0.1_0.3.step)
  Body1_1, Body1_2 [aluminum] = imported_body(C:\Users\karlr\Documents\ICMaSS_sweeping\flatwise_0.1_0.3.step)
  Body1_3 [ferrite - Copy (2)] = imported_body(C:\Users\karlr\Documents\ICMaSS_sweeping\flatwise_0.1_0.3.step)
  Body1_4, Body1_5 [aluminum] = imported_body(C:\Users\karlr\Documents\ICMaSS_sweeping\flatwise_0.1_0.3.step)
  Np1_Section1 = Np1.section(plane=ZX)
  Np2_Section1 = Np2.section(plane=ZX)
  Np3_Section1 [copper] = Np3.section(plane=ZX)
  Np4_Section1 [copper] = Np4.section(plane=ZX)
  Np5_Section1 [copper] = Np5.section(plane=ZX)
  Np6_Section1 [copper] = Np6.section(plane=ZX)
  Np7_Section1 [copper] = Np7.section(plane=ZX)
  Np8_Section1 [copper] = Np8.section(plane=ZX)
  Ns1_Section1 = Ns1.section(plane=ZX)
  Ns2_Section1 = Ns2.section(plane=ZX)
  Ns3_Section1 [copper] = Ns3.section(plane=ZX)
  Ns4_Section1 [copper] = Ns4.section(plane=ZX)
  Ns5_Section1 [copper] = Ns5.section(plane=ZX)
  Ns6_Section1 [copper] = Ns6.section(plane=ZX)
  Ns7_Section1 [copper] = Ns7.section(plane=ZX)
  Ns8_Section1 [copper] = Ns8.section(plane=ZX)
  Np1_Section1_Separate1 [copper] = Np1_Section1.separate_bodies()
  Np1_Section1.delete()
  Np2_Section1_Separate1 [copper] = Np2_Section1.separate_bodies()
  Np2_Section1.delete()
  Np3_Section1.separate_bodies()
  Np4_Section1.separate_bodies()
  Np5_Section1.separate_bodies()
  Np6_Section1.separate_bodies()
  Np7_Section1.separate_bodies()
  Np8_Section1.separate_bodies()
  Ns1_Section1_Separate1 [copper] = Ns1_Section1.separate_bodies()
  Ns1_Section1.delete()
  Ns2_Section1_Separate1 [copper] = Ns2_Section1.separate_bodies()
  Ns2_Section1.delete()
  Ns3_Section1.separate_bodies()
  Ns4_Section1.separate_bodies()
  Ns5_Section1.separate_bodies()
  Ns6_Section1.separate_bodies()
  Ns7_Section1.separate_bodies()
  Ns8_Section1.separate_bodies()
  Rectangle1 [non-model] = rectangle(corner=(36.6mm, 25.43mm, 1.6666608e-08mm), z_size=18.666667mm, x_size=-36.6mm)
  group core_assembled_flatwise = Np1..Np8, Ns1..Ns8, plate_1, plate_2, Np3_Section1, Np4_Section1, Np5_Section1, Np6_Section1, Np7_Section1, Np8_Section1, Ns3_Section1, Ns4_Section1, Ns5_Section1, Ns6_Section1, Ns7_Section1, Ns8_Section1, Np1_Section1_Separate1, Np2_Section1_Separate1, Ns1_Section1_Separate1, Ns2_Section1_Separate1
  group core_together_1 = Body1, Body1_1, Body1_2
  group core_together = Body1_3, Body1_4, Body1_5
boundaries and excitations:
  Ns_1: Coil Terminal Objects=Ns1_Section1_Separate1 Conductor_number=1 Winding=Ns Point_out_of_terminal=true
  Ns_2: Coil Terminal Objects=Ns2_Section1_Separate1 Conductor_number=1 Winding=Ns Point_out_of_terminal=true
  Ns_3: Coil Terminal Objects=Ns3_Section1 Conductor_number=1 Winding=Ns Point_out_of_terminal=true
  Ns_4: Coil Terminal Objects=Ns4_Section1 Conductor_number=1 Winding=Ns Point_out_of_terminal=true
  Ns_5: Coil Terminal Objects=Ns5_Section1 Conductor_number=1 Winding=Ns Point_out_of_terminal=true
  Ns_6: Coil Terminal Objects=Ns6_Section1 Conductor_number=1 Winding=Ns Point_out_of_terminal=true
  Ns_7: Coil Terminal Objects=Ns7_Section1 Conductor_number=1 Winding=Ns Point_out_of_terminal=true
  Ns_8: Coil Terminal Objects=Ns8_Section1 Conductor_number=1 Winding=Ns Point_out_of_terminal=true
  Np_1: Coil Terminal Objects=Np1_Section1_Separate1 Conductor_number=1 Winding=Np Point_out_of_terminal=false
  Np_2: Coil Terminal Objects=Np2_Section1_Separate1 Conductor_number=1 Winding=Np Point_out_of_terminal=false
  Np_3: Coil Terminal Objects=Np3_Section1 Conductor_number=1 Winding=Np Point_out_of_terminal=false
  Np_4: Coil Terminal Objects=Np4_Section1 Conductor_number=1 Winding=Np Point_out_of_terminal=false
  Np_5: Coil Terminal Objects=Np5_Section1 Conductor_number=1 Winding=Np Point_out_of_terminal=false
  Np_6: Coil Terminal Objects=Np6_Section1 Conductor_number=1 Winding=Np Point_out_of_terminal=false
  Np_7: Coil Terminal Objects=Np7_Section1 Conductor_number=1 Winding=Np Point_out_of_terminal=false
  Np_8: Coil Terminal Objects=Np8_Section1 Conductor_number=1 Winding=Np Point_out_of_terminal=false
  Np: Winding Group Type=Voltage IsSolid=true Current=16.36A Resistance=0ohm Inductance=0nH Voltage=volt_ac ParallelBranchesNum=1 Phase=0rad
  Ns: Winding Group Type=Current IsSolid=true Current=1000*1.41/volt_ac*1.414 ParallelBranchesNum=1 Phase=0.1522rad
  core loss on: Body1, Body1_3
parameters:
  Matrix1: Matrix Np, Ns:
mesh:
  Length1: LengthBased Objects=[Body1, Body1_1..Body1_5] MaxLength=5mm
  Length2: LengthBased Objects=[Np1..Np8, Ns1..Ns8, plate_1, plate_2] MaxLength=2mm
  initial mesh: GlobalSurfApproximation{CurvedSurfaceApproxChoice=UseSlider SliderMeshSettings=9} GlobalCurvilinear{Apply}
setups:
  Setup1: EddyCurrent MaximumPasses=20 MinimumPasses=6 MinimumConvergedPasses=1 PercentRefinement=30 PercentError=1 NonLinearResidual=0.0001 SmoothBHCurve Frequency=28.5kHz
field plots:
  Mag_B1: B over a plane on Setup1 : LastAdaptive at Freq=28.5kHz Phase=45deg
  Mesh1: MeshPlots in Np1..Np8, Ns1..Ns8 on Setup1 : LastAdaptive at Freq=28.5kHz Phase=0deg
  Mesh2: MeshPlots over a plane on Setup1 : LastAdaptive at Freq=28.5kHz Phase=0deg
reports:
  L Table 1: Matrix1.L(Np,Np), Matrix1.L(Ns,Np), Matrix1.L(Np,Ns), Matrix1.L(Ns,Ns), Matrix1.R(Np,Np), Matrix1.R(Ns,Np), Matrix1.R(Np,Ns), Matrix1.R(Ns,Ns) vs Freq on Setup1 : LastAdaptive

design Flatwise_0.30_interleaved_full6 (Maxwell 3D, EddyCurrent, model units mm)
variables:
  freq_hz = 28500Hz
  volt_ac = 141/28500*Freq
geometry:
  Region [vacuum] = region(percentage_offset=0 on all sides)
  Np1..Np8, Ns1..Ns8 [copper] = imported_body(C:\Users\karlr\Documents\ICMaSS_sweeping\flatwise_0.1_0.3.step)
  plate_1, plate_2 [silicon - Copy] = imported_body(C:\Users\karlr\Documents\ICMaSS_sweeping\flatwise_0.1_0.3.step)
  Body1 [ferrite - Copy (2)] = imported_body(C:\Users\karlr\Documents\ICMaSS_sweeping\flatwise_0.1_0.3.step)
  Body1_1, Body1_2 [aluminum] = imported_body(C:\Users\karlr\Documents\ICMaSS_sweeping\flatwise_0.1_0.3.step)
  Body1_3 [ferrite - Copy (2)] = imported_body(C:\Users\karlr\Documents\ICMaSS_sweeping\flatwise_0.1_0.3.step)
  Body1_4, Body1_5 [aluminum] = imported_body(C:\Users\karlr\Documents\ICMaSS_sweeping\flatwise_0.1_0.3.step)
  Np1_Section1 = Np1.section(plane=ZX)
  Np2_Section1 = Np2.section(plane=ZX)
  Np3_Section1 [copper] = Np3.section(plane=ZX)
  Np4_Section1 [copper] = Np4.section(plane=ZX)
  Np5_Section1 [copper] = Np5.section(plane=ZX)
  Np6_Section1 [copper] = Np6.section(plane=ZX)
  Np7_Section1 [copper] = Np7.section(plane=ZX)
  Np8_Section1 [copper] = Np8.section(plane=ZX)
  Ns1_Section1 = Ns1.section(plane=ZX)
  Ns2_Section1 = Ns2.section(plane=ZX)
  Ns3_Section1 [copper] = Ns3.section(plane=ZX)
  Ns4_Section1 [copper] = Ns4.section(plane=ZX)
  Ns5_Section1 [copper] = Ns5.section(plane=ZX)
  Ns6_Section1 [copper] = Ns6.section(plane=ZX)
  Ns7_Section1 [copper] = Ns7.section(plane=ZX)
  Ns8_Section1 [copper] = Ns8.section(plane=ZX)
  Np1_Section1_Separate1 [copper] = Np1_Section1.separate_bodies()
  Np1_Section1.delete()
  Np2_Section1_Separate1 [copper] = Np2_Section1.separate_bodies()
  Np2_Section1.delete()
  Np3_Section1.separate_bodies()
  Np4_Section1.separate_bodies()
  Np5_Section1.separate_bodies()
  Np6_Section1.separate_bodies()
  Np7_Section1.separate_bodies()
  Np8_Section1.separate_bodies()
  Ns1_Section1_Separate1 [copper] = Ns1_Section1.separate_bodies()
  Ns1_Section1.delete()
  Ns2_Section1_Separate1 [copper] = Ns2_Section1.separate_bodies()
  Ns2_Section1.delete()
  Ns3_Section1.separate_bodies()
  Ns4_Section1.separate_bodies()
  Ns5_Section1.separate_bodies()
  Ns6_Section1.separate_bodies()
  Ns7_Section1.separate_bodies()
  Ns8_Section1.separate_bodies()
  Rectangle1 [non-model] = rectangle(corner=(36.6mm, 25.43mm, 1.6666608e-08mm), z_size=18.666667mm, x_size=-36.6mm)
  [Np1..Np8, Ns1..Ns8, plate_1, plate_2, Body1, Body1_1..Body1_5, Np3_Section1, Np4_Section1, Np5_Section1, Np6_Section1, Np7_Section1, Np8_Section1, Ns3_Section1, Ns4_Section1, Ns5_Section1, Ns6_Section1, Ns7_Section1, Ns8_Section1, Np1_Section1_Separate1, Np2_Section1_Separate1, Ns1_Section1_Separate1, Ns2_Section1_Separate1, Rectangle1].move(-18.3mm, -25.43mm, 5.4698143e-14mm)
  group core_assembled_flatwise = Np1..Np8, Ns1..Ns8, plate_1, plate_2, Np3_Section1, Np4_Section1, Np5_Section1, Np6_Section1, Np7_Section1, Np8_Section1, Ns3_Section1, Ns4_Section1, Ns5_Section1, Ns6_Section1, Ns7_Section1, Ns8_Section1, Np1_Section1_Separate1, Np2_Section1_Separate1, Ns1_Section1_Separate1, Ns2_Section1_Separate1
  group core_together_1 = Body1, Body1_1, Body1_2
  group core_together = Body1_3, Body1_4, Body1_5
boundaries and excitations:
  Ns_1: Coil Terminal Objects=Ns1_Section1_Separate1 Conductor_number=1 Winding=Ns Point_out_of_terminal=true
  Ns_2: Coil Terminal Objects=Ns2_Section1_Separate1 Conductor_number=1 Winding=Ns Point_out_of_terminal=true
  Ns_3: Coil Terminal Objects=Ns3_Section1 Conductor_number=1 Winding=Ns Point_out_of_terminal=true
  Ns_4: Coil Terminal Objects=Ns4_Section1 Conductor_number=1 Winding=Ns Point_out_of_terminal=true
  Ns_5: Coil Terminal Objects=Ns5_Section1 Conductor_number=1 Winding=Ns Point_out_of_terminal=true
  Ns_6: Coil Terminal Objects=Ns6_Section1 Conductor_number=1 Winding=Ns Point_out_of_terminal=true
  Ns_7: Coil Terminal Objects=Ns7_Section1 Conductor_number=1 Winding=Ns Point_out_of_terminal=true
  Ns_8: Coil Terminal Objects=Ns8_Section1 Conductor_number=1 Winding=Ns Point_out_of_terminal=true
  Np_1: Coil Terminal Objects=Np1_Section1_Separate1 Conductor_number=1 Winding=Np Point_out_of_terminal=false
  Np_2: Coil Terminal Objects=Np2_Section1_Separate1 Conductor_number=1 Winding=Np Point_out_of_terminal=false
  Np_3: Coil Terminal Objects=Np3_Section1 Conductor_number=1 Winding=Np Point_out_of_terminal=false
  Np_4: Coil Terminal Objects=Np4_Section1 Conductor_number=1 Winding=Np Point_out_of_terminal=false
  Np_5: Coil Terminal Objects=Np5_Section1 Conductor_number=1 Winding=Np Point_out_of_terminal=false
  Np_6: Coil Terminal Objects=Np6_Section1 Conductor_number=1 Winding=Np Point_out_of_terminal=false
  Np_7: Coil Terminal Objects=Np7_Section1 Conductor_number=1 Winding=Np Point_out_of_terminal=false
  Np_8: Coil Terminal Objects=Np8_Section1 Conductor_number=1 Winding=Np Point_out_of_terminal=false
  Np: Winding Group Type=Voltage IsSolid=true Current=16.36A Resistance=0ohm Inductance=0nH Voltage=volt_ac ParallelBranchesNum=1 Phase=0rad
  Ns: Winding Group Type=Current IsSolid=true Current=1000*1.41/volt_ac*1.414 ParallelBranchesNum=1 Phase=0.1522rad
  core loss on: Body1, Body1_3
parameters:
  Matrix1: Matrix Np, Ns:
mesh:
  Length1: LengthBased Objects=[Body1, Body1_1..Body1_5] MaxLength=5mm
  Length2: LengthBased Objects=[Np1..Np8, Ns1..Ns8, plate_1, plate_2] MaxLength=2mm
  initial mesh: GlobalSurfApproximation{CurvedSurfaceApproxChoice=UseSlider SliderMeshSettings=9} GlobalCurvilinear{Apply}
setups:
  Setup1: EddyCurrent MaximumPasses=20 MinimumPasses=2 MinimumConvergedPasses=1 PercentRefinement=30 PercentError=1 NonLinearResidual=0.0001 SmoothBHCurve Frequency=28.5kHz
field plots:
  Mag_B1: B over a plane on Setup1 : LastAdaptive at Freq=28.5kHz Phase=45deg
  Mesh1: MeshPlots in Np1..Np8, Ns1..Ns8 on Setup1 : LastAdaptive at Freq=28.5kHz Phase=0deg
  Mesh2: MeshPlots over a plane on Setup1 : LastAdaptive at Freq=28.5kHz Phase=0deg
  Mag_J1, Mag_J2: J over Np1_Section1_Separate1.face Np2_Section1_Separate1.face Np3_Section1.face(at (-7.75, -25.43, 9.33333)) Np4_Section1.face(at (-8.55, -25.43, 9.33333)) Np5_Section1.face(at (-9.35, -25.43, 9.33333)) Np6_Section1.face(at (-10.15, -25.43, 9.33333)) Np7_Section1.face(at (-10.95, -25.43, 9.33333)) Np8_Section1.face(at (-11.75, -25.43, 9.33333)) Ns1_Section1_Separate1.face Ns2_Section1_Separate1.face Ns3_Section1.face(at (-8.15, -25.43, 9.33333)) Ns4_Section1.face(at (-8.95, -25.43, 9.33333)) Ns5_Section1.face(at (-9.75, -25.43, 9.33333)) Ns6_Section1.face(at (-10.55, -25.43, 9.33333)) Ns7_Section1.face(at (-11.35, -25.43, 9.33333)) Ns8_Section1.face(at (-12.15, -25.43, 9.33333)) on Setup1 : LastAdaptive at Freq=28.5kHz Phase=45deg
  Mag_B2: B over Body1_3, Body1 on Setup1 : LastAdaptive at Freq=28.5kHz Phase=45deg
  Mag_J3: J over Np1..Np8, Ns1..Ns8 on Setup1 : LastAdaptive at Freq=28.5kHz Phase=45deg
reports:
  L Table 1: Matrix1.L(Np,Np), Matrix1.L(Ns,Np), Matrix1.L(Np,Ns), Matrix1.L(Ns,Ns), Matrix1.R(Np,Np), Matrix1.R(Ns,Np), Matrix1.R(Np,Ns), Matrix1.R(Ns,Ns) vs Freq on Setup1 : LastAdaptive

design Maxwell2DDesign3 (Maxwell 2D, EddyCurrent, XY geometry, model units mm)
options: ModelDepth=1meter
geometry:
  Region [vacuum] = region(percentage_offset: +X=100, -X=100, +Y=100, -Y=100, +Z=0, -Z=0)
  Np1#30839, Np2#30891, Np3#30943, Np4#30995, Np5#31047, Np6#31099, Np7#31151, Np8#31203, Ns1#31255, Ns2#31307, Ns3#31359, Ns4#31411, Ns5#31463, Ns6#31515, Ns7#31567, Ns8#31619, plate_1#31671, plate_2#31723, Body1#31775, Body1_3#31955 = imported_body(C:\Users\karlr\Documents\ICMaSS_sweeping\flatwise_0.1_0.3.step)
  [Np1#30839, Np2#30891, Np3#30943, Np4#30995, Np5#31047, Np6#31099, Np7#31151, Np8#31203, Ns1#31255, Ns2#31307, Ns3#31359, Ns4#31411, Ns5#31463, Ns6#31515, Ns7#31567, Ns8#31619, plate_1#31671, plate_2#31723, Body1#31775, Body1_3#31955].move(-18.3mm, -25.43mm, -9.2833333mm)
  Np1 [copper] = Np1#30839.section(plane=ZX)
  Np1#30839.delete()
  Np1.rotate(axis=X, angle=-90deg)
  Np2 [copper] = Np2#30891.section(plane=ZX)
  Np2#30891.delete()
  Np2.rotate(axis=X, angle=-90deg)
  Np3 [copper] = Np3#30943.section(plane=ZX)
  Np3#30943.delete()
  Np3.rotate(axis=X, angle=-90deg)
  Np4 [copper] = Np4#30995.section(plane=ZX)
  Np4#30995.delete()
  Np4.rotate(axis=X, angle=-90deg)
  Np5 [copper] = Np5#31047.section(plane=ZX)
  Np5#31047.delete()
  Np5.rotate(axis=X, angle=-90deg)
  Np6 [copper] = Np6#31099.section(plane=ZX)
  Np6#31099.delete()
  Np6.rotate(axis=X, angle=-90deg)
  Np7 [copper] = Np7#31151.section(plane=ZX)
  Np7#31151.delete()
  Np7.rotate(axis=X, angle=-90deg)
  Np8 [copper] = Np8#31203.section(plane=ZX)
  Np8#31203.delete()
  Np8.rotate(axis=X, angle=-90deg)
  Ns1 [copper] = Ns1#31255.section(plane=ZX)
  Ns1#31255.delete()
  Ns1.rotate(axis=X, angle=-90deg)
  Ns2 [copper] = Ns2#31307.section(plane=ZX)
  Ns2#31307.delete()
  Ns2.rotate(axis=X, angle=-90deg)
  Ns3 [copper] = Ns3#31359.section(plane=ZX)
  Ns3#31359.delete()
  Ns3.rotate(axis=X, angle=-90deg)
  Ns4 [copper] = Ns4#31411.section(plane=ZX)
  Ns4#31411.delete()
  Ns4.rotate(axis=X, angle=-90deg)
  Ns5 [copper] = Ns5#31463.section(plane=ZX)
  Ns5#31463.delete()
  Ns5.rotate(axis=X, angle=-90deg)
  Ns6 [copper] = Ns6#31515.section(plane=ZX)
  Ns6#31515.delete()
  Ns6.rotate(axis=X, angle=-90deg)
  Ns7 [copper] = Ns7#31567.section(plane=ZX)
  Ns7#31567.delete()
  Ns7.rotate(axis=X, angle=-90deg)
  Ns8 [copper] = Ns8#31619.section(plane=ZX)
  Ns8#31619.delete()
  Ns8.rotate(axis=X, angle=-90deg)
  plate_1 [silicon - Copy] = plate_1#31671.section(plane=ZX)
  plate_1#31671.delete()
  plate_1.rotate(axis=X, angle=-90deg)
  plate_2 [silicon - Copy] = plate_2#31723.section(plane=ZX)
  plate_2#31723.delete()
  plate_2.rotate(axis=X, angle=-90deg)
  Body1 [ferrite - Copy (2)] = Body1#31775.section(plane=ZX)
  Body1#31775.delete()
  Body1.rotate(axis=X, angle=-90deg)
  Body1_3 [ferrite - Copy (2)] = Body1_3#31955.section(plane=ZX)
  Body1_3#31955.delete()
  Body1_3.rotate(axis=X, angle=-90deg)
  [Np1..Np8, Ns1..Ns8, plate_1, plate_2, Body1, Body1_3].split(plane=YZ, keep=PositiveOnly)
  group core_assembled_flatwise = Np1..Np8, Ns1..Ns8, plate_1, plate_2
  group core_together_1 = Body1
  group core_together = Body1_3
boundaries and excitations:
  Balloon1: Balloon Edges=Region.edge(all 4)
  Current_1: Current Objects=Np1 Phase=0deg Current=1A IsSolid=true IsPositive=true
  Current_2: Current Objects=Np2 Phase=0deg Current=1A IsSolid=true IsPositive=true
  Current_3: Current Objects=Np3 Phase=0deg Current=1A IsSolid=true IsPositive=true
  Current_4: Current Objects=Np4 Phase=0deg Current=1A IsSolid=true IsPositive=true
  Current_5: Current Objects=Np5 Phase=0deg Current=1A IsSolid=true IsPositive=true
  Current_6: Current Objects=Np6 Phase=0deg Current=1A IsSolid=true IsPositive=true
  Current_7: Current Objects=Np7 Phase=0deg Current=1A IsSolid=true IsPositive=true
  Current_8: Current Objects=Np8 Phase=0deg Current=1A IsSolid=true IsPositive=true
  Current_9: Current Objects=Ns1 Phase=0deg Current=-1A IsSolid=true IsPositive=true
  Current_10: Current Objects=Ns2 Phase=0deg Current=-1A IsSolid=true IsPositive=true
  Current_11: Current Objects=Ns3 Phase=0deg Current=-1A IsSolid=true IsPositive=true
  Current_12: Current Objects=Ns4 Phase=0deg Current=-1A IsSolid=true IsPositive=true
  Current_13: Current Objects=Ns5 Phase=0deg Current=-1A IsSolid=true IsPositive=true
  Current_14: Current Objects=Ns6 Phase=0deg Current=-1A IsSolid=true IsPositive=true
  Current_15: Current Objects=Ns7 Phase=0deg Current=-1A IsSolid=true IsPositive=true
  Current_16: Current Objects=Ns8 Phase=0deg Current=-1A IsSolid=true IsPositive=true
mesh:
  Length1: LengthBased Objects=[Np1..Np8, Ns1..Ns8, plate_1, plate_2, Body1, Body1_3] MaxLength=0.1mm
  initial mesh: GlobalSurfApproximation{CurvedSurfaceApproxChoice=UseSlider SliderMeshSettings=9}
setups:
  Setup1: EddyCurrent MaximumPasses=20 MinimumPasses=2 MinimumConvergedPasses=1 PercentRefinement=30 PercentError=1 NonLinearResidual=0.0001 Frequency=28500Hz
field plots:
  JAtPhase1: J over Np1..Np8, Ns1..Ns8 on Setup1 : LastAdaptive at Freq=28.5kHz Phase=45deg

design Maxwell2DDesign1 (Maxwell 2D, Magnetostatic, XY geometry, model units mm)
options: ModelDepth=1meter
geometry:
  Region [vacuum] = region(percentage_offset=0 on all sides)
  Np1#30839, Np2#30891, Np3#30943, Np4#30995, Np5#31047, Np6#31099, Np7#31151, Np8#31203, Ns1#31255, Ns2#31307, Ns3#31359, Ns4#31411, Ns5#31463, Ns6#31515, Ns7#31567, Ns8#31619, plate_1#31671, plate_2#31723, Body1#31775, Body1_3#31955 = imported_body(C:\Users\karlr\Documents\ICMaSS_sweeping\flatwise_0.1_0.3.step)
  [Np1#30839, Np2#30891, Np3#30943, Np4#30995, Np5#31047, Np6#31099, Np7#31151, Np8#31203, Ns1#31255, Ns2#31307, Ns3#31359, Ns4#31411, Ns5#31463, Ns6#31515, Ns7#31567, Ns8#31619, plate_1#31671, plate_2#31723, Body1#31775, Body1_3#31955].move(-18.3mm, -25.43mm, 5.4698143e-14mm)
  Np1 [copper] = Np1#30839.section(plane=ZX)
  Np1#30839.delete()
  Np1.rotate(axis=X, angle=-90deg)
  Np2 [copper] = Np2#30891.section(plane=ZX)
  Np2#30891.delete()
  Np2.rotate(axis=X, angle=-90deg)
  Np3 [copper] = Np3#30943.section(plane=ZX)
  Np3#30943.delete()
  Np3.rotate(axis=X, angle=-90deg)
  Np4 [copper] = Np4#30995.section(plane=ZX)
  Np4#30995.delete()
  Np4.rotate(axis=X, angle=-90deg)
  Np5 [copper] = Np5#31047.section(plane=ZX)
  Np5#31047.delete()
  Np5.rotate(axis=X, angle=-90deg)
  Np6 [copper] = Np6#31099.section(plane=ZX)
  Np6#31099.delete()
  Np6.rotate(axis=X, angle=-90deg)
  Np7 [copper] = Np7#31151.section(plane=ZX)
  Np7#31151.delete()
  Np7.rotate(axis=X, angle=-90deg)
  Np8 [copper] = Np8#31203.section(plane=ZX)
  Np8#31203.delete()
  Np8.rotate(axis=X, angle=-90deg)
  Ns1 [copper] = Ns1#31255.section(plane=ZX)
  Ns1#31255.delete()
  Ns1.rotate(axis=X, angle=-90deg)
  Ns2 [copper] = Ns2#31307.section(plane=ZX)
  Ns2#31307.delete()
  Ns2.rotate(axis=X, angle=-90deg)
  Ns3 [copper] = Ns3#31359.section(plane=ZX)
  Ns3#31359.delete()
  Ns3.rotate(axis=X, angle=-90deg)
  Ns4 [copper] = Ns4#31411.section(plane=ZX)
  Ns4#31411.delete()
  Ns4.rotate(axis=X, angle=-90deg)
  Ns5 [copper] = Ns5#31463.section(plane=ZX)
  Ns5#31463.delete()
  Ns5.rotate(axis=X, angle=-90deg)
  Ns6 [copper] = Ns6#31515.section(plane=ZX)
  Ns6#31515.delete()
  Ns6.rotate(axis=X, angle=-90deg)
  Ns7 [copper] = Ns7#31567.section(plane=ZX)
  Ns7#31567.delete()
  Ns7.rotate(axis=X, angle=-90deg)
  Ns8 [copper] = Ns8#31619.section(plane=ZX)
  Ns8#31619.delete()
  Ns8.rotate(axis=X, angle=-90deg)
  plate_1 [silicon - Copy] = plate_1#31671.section(plane=ZX)
  plate_1#31671.delete()
  plate_1.rotate(axis=X, angle=-90deg)
  plate_2 [silicon - Copy] = plate_2#31723.section(plane=ZX)
  plate_2#31723.delete()
  plate_2.rotate(axis=X, angle=-90deg)
  Body1 [ferrite - Copy (2)] = Body1#31775.section(plane=ZX)
  Body1#31775.delete()
  Body1.rotate(axis=X, angle=-90deg)
  Body1_3 [ferrite - Copy (2)] = Body1_3#31955.section(plane=ZX)
  Body1_3#31955.delete()
  Body1_3.rotate(axis=X, angle=-90deg)
  [Np1..Np8, Ns1..Ns8, plate_1, plate_2, Body1, Body1_3].split(plane=YZ, keep=PositiveOnly)
  group core_assembled_flatwise = Np1..Np8, Ns1..Ns8, plate_1, plate_2
  group core_together_1 = Body1
  group core_together = Body1_3

design 10kW (Maxwell 2D, Electrostatic, XY geometry, model units mm)
geometry:
  Region [air] = region(percentage_offset: +X=50, -X=0, +Y=50, -Y=50, +Z=0, -Z=0)
  Np9 = imported_body(C:\Users\karlr\Documents\ICMaSS_sweeping\flatwise_0.1_0.3.step)
  Np9.move(-18.3mm, -25.43mm, 5.4698143e-14mm)
  Np1 [copper] = Np9.section(plane=ZX)
  Np9.delete()
  Np1.rotate(axis=X, angle=-90deg)
  Np1.split(plane=YZ, keep=PositiveOnly)
  Np10 = imported_body(C:\Users\karlr\Documents\ICMaSS_sweeping\flatwise_0.1_0.3.step)
  Np10.move(-18.3mm, -25.43mm, 5.4698143e-14mm)
  Np2 [copper] = Np10.section(plane=ZX)
  Np10.delete()
  Np2.rotate(axis=X, angle=-90deg)
  Np2.split(plane=YZ, keep=PositiveOnly)
  Np11 = imported_body(C:\Users\karlr\Documents\ICMaSS_sweeping\flatwise_0.1_0.3.step)
  Np11.move(-18.3mm, -25.43mm, 5.4698143e-14mm)
  Np3 [copper] = Np11.section(plane=ZX)
  Np11.delete()
  Np3.rotate(axis=X, angle=-90deg)
  Np3.split(plane=YZ, keep=PositiveOnly)
  Np12 = imported_body(C:\Users\karlr\Documents\ICMaSS_sweeping\flatwise_0.1_0.3.step)
  Np12.move(-18.3mm, -25.43mm, 5.4698143e-14mm)
  Np4 [copper] = Np12.section(plane=ZX)
  Np12.delete()
  Np4.rotate(axis=X, angle=-90deg)
  Np4.split(plane=YZ, keep=PositiveOnly)
  Np13 = imported_body(C:\Users\karlr\Documents\ICMaSS_sweeping\flatwise_0.1_0.3.step)
  Np13.move(-18.3mm, -25.43mm, 5.4698143e-14mm)
  Np5 [copper] = Np13.section(plane=ZX)
  Np13.delete()
  Np5.rotate(axis=X, angle=-90deg)
  Np5.split(plane=YZ, keep=PositiveOnly)
  Np14 = imported_body(C:\Users\karlr\Documents\ICMaSS_sweeping\flatwise_0.1_0.3.step)
  Np14.move(-18.3mm, -25.43mm, 5.4698143e-14mm)
  Np6 [copper] = Np14.section(plane=ZX)
  Np14.delete()
  Np6.rotate(axis=X, angle=-90deg)
  Np6.split(plane=YZ, keep=PositiveOnly)
  Np15 = imported_body(C:\Users\karlr\Documents\ICMaSS_sweeping\flatwise_0.1_0.3.step)
  Np15.move(-18.3mm, -25.43mm, 5.4698143e-14mm)
  Np7 [copper] = Np15.section(plane=ZX)
  Np15.delete()
  Np7.rotate(axis=X, angle=-90deg)
  Np7.split(plane=YZ, keep=PositiveOnly)
  Np16 = imported_body(C:\Users\karlr\Documents\ICMaSS_sweeping\flatwise_0.1_0.3.step)
  Np16.move(-18.3mm, -25.43mm, 5.4698143e-14mm)
  Np8 [copper] = Np16.section(plane=ZX)
  Np16.delete()
  Np8.rotate(axis=X, angle=-90deg)
  Np8.split(plane=YZ, keep=PositiveOnly)
  Ns9 = imported_body(C:\Users\karlr\Documents\ICMaSS_sweeping\flatwise_0.1_0.3.step)
  Ns9.move(-18.3mm, -25.43mm, 5.4698143e-14mm)
  Ns1 [copper] = Ns9.section(plane=ZX)
  Ns9.delete()
  Ns1.rotate(axis=X, angle=-90deg)
  Ns1.split(plane=YZ, keep=PositiveOnly)
  Ns10 = imported_body(C:\Users\karlr\Documents\ICMaSS_sweeping\flatwise_0.1_0.3.step)
  Ns10.move(-18.3mm, -25.43mm, 5.4698143e-14mm)
  Ns2 [copper] = Ns10.section(plane=ZX)
  Ns10.delete()
  Ns2.rotate(axis=X, angle=-90deg)
  Ns2.split(plane=YZ, keep=PositiveOnly)
  Ns11 = imported_body(C:\Users\karlr\Documents\ICMaSS_sweeping\flatwise_0.1_0.3.step)
  Ns11.move(-18.3mm, -25.43mm, 5.4698143e-14mm)
  Ns3 [copper] = Ns11.section(plane=ZX)
  Ns11.delete()
  Ns3.rotate(axis=X, angle=-90deg)
  Ns3.split(plane=YZ, keep=PositiveOnly)
  Ns12 = imported_body(C:\Users\karlr\Documents\ICMaSS_sweeping\flatwise_0.1_0.3.step)
  Ns12.move(-18.3mm, -25.43mm, 5.4698143e-14mm)
  Ns4 [copper] = Ns12.section(plane=ZX)
  Ns12.delete()
  Ns4.rotate(axis=X, angle=-90deg)
  Ns4.split(plane=YZ, keep=PositiveOnly)
  Ns13 = imported_body(C:\Users\karlr\Documents\ICMaSS_sweeping\flatwise_0.1_0.3.step)
  Ns13.move(-18.3mm, -25.43mm, 5.4698143e-14mm)
  Ns5 [copper] = Ns13.section(plane=ZX)
  Ns13.delete()
  Ns5.rotate(axis=X, angle=-90deg)
  Ns5.split(plane=YZ, keep=PositiveOnly)
  Ns14 = imported_body(C:\Users\karlr\Documents\ICMaSS_sweeping\flatwise_0.1_0.3.step)
  Ns14.move(-18.3mm, -25.43mm, 5.4698143e-14mm)
  Ns6 [copper] = Ns14.section(plane=ZX)
  Ns14.delete()
  Ns6.rotate(axis=X, angle=-90deg)
  Ns6.split(plane=YZ, keep=PositiveOnly)
  Ns15 = imported_body(C:\Users\karlr\Documents\ICMaSS_sweeping\flatwise_0.1_0.3.step)
  Ns15.move(-18.3mm, -25.43mm, 5.4698143e-14mm)
  Ns7 [copper] = Ns15.section(plane=ZX)
  Ns15.delete()
  Ns7.rotate(axis=X, angle=-90deg)
  Ns7.split(plane=YZ, keep=PositiveOnly)
  Ns16 = imported_body(C:\Users\karlr\Documents\ICMaSS_sweeping\flatwise_0.1_0.3.step)
  Ns16.move(-18.3mm, -25.43mm, 5.4698143e-14mm)
  Ns8 [copper] = Ns16.section(plane=ZX)
  Ns16.delete()
  Ns8.rotate(axis=X, angle=-90deg)
  Ns8.split(plane=YZ, keep=PositiveOnly)
  plate_3 = imported_body(C:\Users\karlr\Documents\ICMaSS_sweeping\flatwise_0.1_0.3.step)
  plate_3.move(-18.3mm, -25.43mm, 5.4698143e-14mm)
  plate_1 [silicon - Copy] = plate_3.section(plane=ZX)
  plate_3.delete()
  plate_1.rotate(axis=X, angle=-90deg)
  plate_1.split(plane=YZ, keep=PositiveOnly)
  plate_4 = imported_body(C:\Users\karlr\Documents\ICMaSS_sweeping\flatwise_0.1_0.3.step)
  plate_4.move(-18.3mm, -25.43mm, 5.4698143e-14mm)
  plate_2 [silicon - Copy] = plate_4.section(plane=ZX)
  plate_4.delete()
  plate_2.rotate(axis=X, angle=-90deg)
  plate_2.split(plane=YZ, keep=PositiveOnly)
  Body2 = imported_body(C:\Users\karlr\Documents\ICMaSS_sweeping\flatwise_0.1_0.3.step)
  Body2.move(-18.3mm, -25.43mm, 5.4698143e-14mm)
  Body1 [ferrite - Copy (2)] = Body2.section(plane=ZX)
  Body2.delete()
  Body1.rotate(axis=X, angle=-90deg)
  Body1.split(plane=YZ, keep=PositiveOnly)
  Body1_4 = imported_body(C:\Users\karlr\Documents\ICMaSS_sweeping\flatwise_0.1_0.3.step)
  Body1_4.move(-18.3mm, -25.43mm, 5.4698143e-14mm)
  Body1_3 [ferrite - Copy (2)] = Body1_4.section(plane=ZX)
  Body1_4.delete()
  Body1_3.rotate(axis=X, angle=-90deg)
  Body1_3.split(plane=YZ, keep=PositiveOnly)
  Rectangle1 [air] = rectangle(corner=(0mm, 0mm, 0mm), x_size=18.3mm, y_size=18.666667mm)
  group core_assembled_flatwise = Np1..Np8, Ns1..Ns8, plate_1, plate_2
  group core_together_1 = Body1
  group core_together = Body1_3
boundaries and excitations:
  Symmetry1: Symmetry Edges=Region.edge(at (0, 9.33333, 0)) IsOdd=false
  Balloon1: Balloon Edges=Region.edge(at (13.725, 28, 0), at (27.45, 9.33333, 0), at (13.725, -9.33333, 0)) IsOfTypeVoltage=false
  Voltage1: Voltage Objects=[Np1..Np8] Value=200V
  Voltage2: Voltage Objects=[Ns1..Ns8] Value=0V
mesh:
  EdgeCut1: EdgeCutLayerMesh Objects=[plate_2, plate_1] Layer_Thickenss=0.05mm
  c: EdgeCutLayerMesh Objects=[Body1, Body1_3] Layer_Thickenss=0.05mm
  EdgeCut2: EdgeCutLayerMesh Objects=[Np1..Np8, Ns1..Ns8] Layer_Thickenss=0.05mm
  EdgeCut3: EdgeCutLayerMesh Objects=Rectangle1 Layer_Thickenss=0.05mm
setups:
  Setup1: Electrostatic MaximumPasses=20 MinimumPasses=10 MinimumConvergedPasses=1 PercentRefinement=70 PercentError=0.5 NonLinearResidual=0.001
field plots:
  Mag_E1: E over plate_1, plate_2, Rectangle1 on Setup1 : LastAdaptive

design [Thermal]Flatwise_0.2_fix (Icepak, SteadyState TemperatureAndFlow, model units mm)
options: Default_Fluid_Material=air Default_Solid_Material=Al-Extruded Default_Surface_Material=Steel-oxidised-surface AmbientTemperature=25cel AmbientPressure=0n_per_meter_sq AmbientRadiationTemperature=25cel Gravity_Vector_CS_ID=Global Gravity_Vector_Axis=Z Positive=false SherlockExportDirectory=C:/Users/karlr/Documents/Ansoft/1kW_Final.aedtexport/[Thermal]8turns_3D_CoreLoss_FullInterleaved_Flatwise/ Altitude=0meter
geometry:
  Region [air] = region(percentage_offset=1000 on all sides)
  Np1 [copper] = imported_body(C:\Users\karlr\Documents\ICMaSS_sweeping\flatwise_0.1_0.2.step)
  Np2 [copper] = imported_body(C:\Users\karlr\Documents\ICMaSS_sweeping\flatwise_0.1_0.2.step)
  Np3 [copper] = imported_body(C:\Users\karlr\Documents\ICMaSS_sweeping\flatwise_0.1_0.2.step)
  Np4 [copper] = imported_body(C:\Users\karlr\Documents\ICMaSS_sweeping\flatwise_0.1_0.2.step)
  Np5 [copper] = imported_body(C:\Users\karlr\Documents\ICMaSS_sweeping\flatwise_0.1_0.2.step)
  Np6 [copper] = imported_body(C:\Users\karlr\Documents\ICMaSS_sweeping\flatwise_0.1_0.2.step)
  Np7 [copper] = imported_body(C:\Users\karlr\Documents\ICMaSS_sweeping\flatwise_0.1_0.2.step)
  Np8 [copper] = imported_body(C:\Users\karlr\Documents\ICMaSS_sweeping\flatwise_0.1_0.2.step)
  Ns1 [copper] = imported_body(C:\Users\karlr\Documents\ICMaSS_sweeping\flatwise_0.1_0.2.step)
  Ns2 [copper] = imported_body(C:\Users\karlr\Documents\ICMaSS_sweeping\flatwise_0.1_0.2.step)
  Ns3 [copper] = imported_body(C:\Users\karlr\Documents\ICMaSS_sweeping\flatwise_0.1_0.2.step)
  Ns4 [copper] = imported_body(C:\Users\karlr\Documents\ICMaSS_sweeping\flatwise_0.1_0.2.step)
  Ns5 [copper] = imported_body(C:\Users\karlr\Documents\ICMaSS_sweeping\flatwise_0.1_0.2.step)
  Ns6 [copper] = imported_body(C:\Users\karlr\Documents\ICMaSS_sweeping\flatwise_0.1_0.2.step)
  Ns7 [copper] = imported_body(C:\Users\karlr\Documents\ICMaSS_sweeping\flatwise_0.1_0.2.step)
  Ns8 [copper] = imported_body(C:\Users\karlr\Documents\ICMaSS_sweeping\flatwise_0.1_0.2.step)
  plate_1, plate_2 [silicon - Copy] = imported_body(C:\Users\karlr\Documents\ICMaSS_sweeping\flatwise_0.1_0.2.step)
  Body1 [ferrite - Copy (2)] = imported_body(C:\Users\karlr\Documents\ICMaSS_sweeping\flatwise_0.1_0.2.step)
  Body1_1, Body1_2 [aluminum] = imported_body(C:\Users\karlr\Documents\ICMaSS_sweeping\flatwise_0.1_0.2.step)
  Body1_3 [ferrite - Copy (2)] = imported_body(C:\Users\karlr\Documents\ICMaSS_sweeping\flatwise_0.1_0.2.step)
  Body1_4, Body1_5 [aluminum] = imported_body(C:\Users\karlr\Documents\ICMaSS_sweeping\flatwise_0.1_0.2.step)
  Rectangle1 [Al-Extruded, non-model] = rectangle(corner=(35mm, 25.43mm, 0mm), z_size=20mm, x_size=-35mm)
  group core_assembled_flatwise = Np1..Np8, Ns1..Ns8, plate_1, plate_2
  group core_together_2 = Body1, Body1_1, Body1_2
  group core_together1 = Body1_3, Body1_4, Body1_5
boundaries and excitations:
  Opening1: Opening Faces=Region.face(-y) Temperature=AmbientTemp External_Rad._Temperature=AmbientRadTemp Inlet_Type=Pressure Total_Pressure=AmbientPressure
  Opening2: Opening Faces=Region.face(+y) Temperature=AmbientTemp External_Rad._Temperature=AmbientRadTemp Inlet_Type=Velocity Static_Pressure=AmbientPressure X_Velocity=0m_per_sec Y_Velocity=0m_per_sec Z_Velocity=0m_per_sec
  EMLoss1: EM Loss Objects=[Body1, Body1_1..Body1_5, Np1..Np8, Ns1..Ns8] LinkID=403 Project="This Project*" Product=ElectronicsDesktop Design=Flatwise_0.2_interleaved_full Params{freq_hz=28500Hz} ForceSourceToSolve PreservePartnerSoln PathRelativeTo=TargetProject Intrinsics(28.5kHz) LossMultiplier=1
mesh:
  MeshRegions:  Global{MeshMethod=MesherHD ComputeGap MeshRegionResolution=5 MinGapX=1mm MinGapY=1mm MinGapZ=1mm Objects=Region FacetLevel=5 ProximitySizeFunction CurvatureSizeFunction OptimizePCBMesh}
  MeshOperations:
setups:
  Setup1: IcepakSteadyState Flow_Regime=Laminar Include_Temperature=true Include_Flow=true Include_Gravity Solution_Initialization_-_Z_Velocity=0.000980665m_per_sec Convergence_Criteria_-_Flow=0.001 Convergence_Criteria_-_Energy=1e-07 Convergence_Criteria_-_Discrete_Ordinates=1e-06 Radiation_Model="Discrete Ordinates Model" Flow_Iteration_Per_Radiation_Iteration=10 ThetaDivision=2 PhiDivision=2 ThetaPixels=2 PhiPixels=2 Under-relaxation_-_Pressure=0.7 Under-relaxation_-_Momentum=0.3 Under-relaxation_-_Temperature=1 Discretization_Scheme_-_Pressure=Standard Discretization_Scheme_-_Momentum=First Discretization_Scheme_-_Temperature=First Discretization_Scheme_-_Discrete_Ordinates=First Convergence_Criteria_-_Max_Iterations=10000
field plots:
  Temperature1: Temperature over Np1..Np8, Ns1..Ns8, plate_1, plate_2, Body1, Body1_1..Body1_5 on Setup1 : SteadyState
  Temperature2: Temperature over a plane on Setup1 : SteadyState

design [Thermal]Flatwise_0.3_fix (Icepak, SteadyState TemperatureAndFlow, model units mm)
options: Default_Fluid_Material=air Default_Solid_Material=Al-Extruded Default_Surface_Material=Steel-oxidised-surface AmbientTemperature=25cel AmbientPressure=0n_per_meter_sq AmbientRadiationTemperature=25cel Gravity_Vector_CS_ID=Global Gravity_Vector_Axis=Z Positive=false SherlockExportDirectory=C:/Users/karlr/Documents/Ansoft/1kW_Final.aedtexport/[Thermal]8turns_3D_CoreLoss_FullInterleaved_Flatwise/ Altitude=0meter
geometry:
  Region [air] = region(percentage_offset=1000 on all sides)
  Np1 [copper] = imported_body(C:\Users\karlr\Documents\ICMaSS_sweeping\flatwise_0.1_0.3.step)
  Np2 [copper] = imported_body(C:\Users\karlr\Documents\ICMaSS_sweeping\flatwise_0.1_0.3.step)
  Np3 [copper] = imported_body(C:\Users\karlr\Documents\ICMaSS_sweeping\flatwise_0.1_0.3.step)
  Np4 [copper] = imported_body(C:\Users\karlr\Documents\ICMaSS_sweeping\flatwise_0.1_0.3.step)
  Np5 [copper] = imported_body(C:\Users\karlr\Documents\ICMaSS_sweeping\flatwise_0.1_0.3.step)
  Np6 [copper] = imported_body(C:\Users\karlr\Documents\ICMaSS_sweeping\flatwise_0.1_0.3.step)
  Np7 [copper] = imported_body(C:\Users\karlr\Documents\ICMaSS_sweeping\flatwise_0.1_0.3.step)
  Np8 [copper] = imported_body(C:\Users\karlr\Documents\ICMaSS_sweeping\flatwise_0.1_0.3.step)
  Ns1 [copper] = imported_body(C:\Users\karlr\Documents\ICMaSS_sweeping\flatwise_0.1_0.3.step)
  Ns2 [copper] = imported_body(C:\Users\karlr\Documents\ICMaSS_sweeping\flatwise_0.1_0.3.step)
  Ns3 [copper] = imported_body(C:\Users\karlr\Documents\ICMaSS_sweeping\flatwise_0.1_0.3.step)
  Ns4 [copper] = imported_body(C:\Users\karlr\Documents\ICMaSS_sweeping\flatwise_0.1_0.3.step)
  Ns5 [copper] = imported_body(C:\Users\karlr\Documents\ICMaSS_sweeping\flatwise_0.1_0.3.step)
  Ns6 [copper] = imported_body(C:\Users\karlr\Documents\ICMaSS_sweeping\flatwise_0.1_0.3.step)
  Ns7 [copper] = imported_body(C:\Users\karlr\Documents\ICMaSS_sweeping\flatwise_0.1_0.3.step)
  Ns8 [copper] = imported_body(C:\Users\karlr\Documents\ICMaSS_sweeping\flatwise_0.1_0.3.step)
  plate_1, plate_2 [silicon - Copy] = imported_body(C:\Users\karlr\Documents\ICMaSS_sweeping\flatwise_0.1_0.3.step)
  Body1 [ferrite - Copy (2)] = imported_body(C:\Users\karlr\Documents\ICMaSS_sweeping\flatwise_0.1_0.3.step)
  Body1_1, Body1_2 [aluminum] = imported_body(C:\Users\karlr\Documents\ICMaSS_sweeping\flatwise_0.1_0.3.step)
  Body1_3 [ferrite - Copy (2)] = imported_body(C:\Users\karlr\Documents\ICMaSS_sweeping\flatwise_0.1_0.3.step)
  Body1_4, Body1_5 [aluminum] = imported_body(C:\Users\karlr\Documents\ICMaSS_sweeping\flatwise_0.1_0.3.step)
  Rectangle1 [Al-Extruded, non-model] = rectangle(corner=(36.6mm, 25.43mm, 0mm), z_size=18.666667mm, x_size=-36.6mm)
  group core_assembled_flatwise = Np1..Np8, Ns1..Ns8, plate_1, plate_2
  group core_together_1 = Body1, Body1_1, Body1_2
  group core_together = Body1_3, Body1_4, Body1_5
boundaries and excitations:
  Opening1: Opening Faces=Region.face(-y) Temperature=AmbientTemp External_Rad._Temperature=AmbientRadTemp Inlet_Type=Pressure Total_Pressure=AmbientPressure
  Opening2: Opening Faces=Region.face(+y) Temperature=AmbientTemp External_Rad._Temperature=AmbientRadTemp Inlet_Type=Velocity Static_Pressure=AmbientPressure X_Velocity=0m_per_sec Y_Velocity=0m_per_sec Z_Velocity=0m_per_sec
  EMLoss1: EM Loss Objects=[Body1, Body1_1..Body1_5, Np1..Np8, Ns1..Ns8] LinkID=418 Project="This Project*" Product=ElectronicsDesktop Design=Flatwise_0.30_interleaved_full Params{freq_hz=28500Hz} ForceSourceToSolve PreservePartnerSoln PathRelativeTo=TargetProject Intrinsics(28.5kHz) LossMultiplier=1
mesh:
  MeshRegions:  Global{MeshMethod=MesherHD ComputeGap MeshRegionResolution=5 MinGapX=1mm MinGapY=1mm MinGapZ=1mm Objects=Region FacetLevel=5 ProximitySizeFunction CurvatureSizeFunction OptimizePCBMesh}
  MeshOperations:
setups:
  Setup1: IcepakSteadyState Flow_Regime=Laminar Include_Temperature=true Include_Flow=true Include_Gravity Solution_Initialization_-_Z_Velocity=0.000980665m_per_sec Convergence_Criteria_-_Flow=0.001 Convergence_Criteria_-_Energy=1e-07 Convergence_Criteria_-_Discrete_Ordinates=1e-06 Radiation_Model="Discrete Ordinates Model" Flow_Iteration_Per_Radiation_Iteration=10 ThetaDivision=2 PhiDivision=2 ThetaPixels=2 PhiPixels=2 Under-relaxation_-_Pressure=0.7 Under-relaxation_-_Momentum=0.3 Under-relaxation_-_Temperature=1 Discretization_Scheme_-_Pressure=Standard Discretization_Scheme_-_Momentum=First Discretization_Scheme_-_Temperature=First Discretization_Scheme_-_Discrete_Ordinates=First Convergence_Criteria_-_Max_Iterations=10000
field plots:
  Temperature1: Temperature over Np1..Np8, Ns1..Ns8, plate_1, plate_2, Body1, Body1_1..Body1_5 on Setup1 : SteadyState
  Temperature2: Temperature over a plane on Setup1 : SteadyState

design [Thermal]Flatwise_0.4_fix (Icepak, SteadyState TemperatureAndFlow, model units mm)
options: Default_Fluid_Material=air Default_Solid_Material=Al-Extruded Default_Surface_Material=Steel-oxidised-surface AmbientTemperature=25cel AmbientPressure=0n_per_meter_sq AmbientRadiationTemperature=25cel Gravity_Vector_CS_ID=Global Gravity_Vector_Axis=Z Positive=false SherlockExportDirectory=C:/Users/karlr/Documents/Ansoft/1kW_Final.aedtexport/[Thermal]8turns_3D_CoreLoss_FullInterleaved_Flatwise/ Altitude=0meter
geometry:
  Region [air] = region(percentage_offset=1000 on all sides)
  Np1 [copper] = imported_body(C:\Users\karlr\Documents\ICMaSS_sweeping\flatwise_0.1_0.4.step)
  Np2 [copper] = imported_body(C:\Users\karlr\Documents\ICMaSS_sweeping\flatwise_0.1_0.4.step)
  Np3 [copper] = imported_body(C:\Users\karlr\Documents\ICMaSS_sweeping\flatwise_0.1_0.4.step)
  Np4 [copper] = imported_body(C:\Users\karlr\Documents\ICMaSS_sweeping\flatwise_0.1_0.4.step)
  Np5 [copper] = imported_body(C:\Users\karlr\Documents\ICMaSS_sweeping\flatwise_0.1_0.4.step)
  Np6 [copper] = imported_body(C:\Users\karlr\Documents\ICMaSS_sweeping\flatwise_0.1_0.4.step)
  Np7 [copper] = imported_body(C:\Users\karlr\Documents\ICMaSS_sweeping\flatwise_0.1_0.4.step)
  Np8 [copper] = imported_body(C:\Users\karlr\Documents\ICMaSS_sweeping\flatwise_0.1_0.4.step)
  Ns1 [copper] = imported_body(C:\Users\karlr\Documents\ICMaSS_sweeping\flatwise_0.1_0.4.step)
  Ns2 [copper] = imported_body(C:\Users\karlr\Documents\ICMaSS_sweeping\flatwise_0.1_0.4.step)
  Ns3 [copper] = imported_body(C:\Users\karlr\Documents\ICMaSS_sweeping\flatwise_0.1_0.4.step)
  Ns4 [copper] = imported_body(C:\Users\karlr\Documents\ICMaSS_sweeping\flatwise_0.1_0.4.step)
  Ns5 [copper] = imported_body(C:\Users\karlr\Documents\ICMaSS_sweeping\flatwise_0.1_0.4.step)
  Ns6 [copper] = imported_body(C:\Users\karlr\Documents\ICMaSS_sweeping\flatwise_0.1_0.4.step)
  Ns7 [copper] = imported_body(C:\Users\karlr\Documents\ICMaSS_sweeping\flatwise_0.1_0.4.step)
  Ns8 [copper] = imported_body(C:\Users\karlr\Documents\ICMaSS_sweeping\flatwise_0.1_0.4.step)
  plate_1, plate_2 [silicon - Copy] = imported_body(C:\Users\karlr\Documents\ICMaSS_sweeping\flatwise_0.1_0.4.step)
  Body1 [ferrite - Copy (2)] = imported_body(C:\Users\karlr\Documents\ICMaSS_sweeping\flatwise_0.1_0.4.step)
  Body1_1, Body1_2 [aluminum] = imported_body(C:\Users\karlr\Documents\ICMaSS_sweeping\flatwise_0.1_0.4.step)
  Body1_3 [ferrite - Copy (2)] = imported_body(C:\Users\karlr\Documents\ICMaSS_sweeping\flatwise_0.1_0.4.step)
  Body1_4, Body1_5 [aluminum] = imported_body(C:\Users\karlr\Documents\ICMaSS_sweeping\flatwise_0.1_0.4.step)
  group core_assembled_flatwise = Np1..Np8, Ns1..Ns8, plate_1, plate_2
  group core_together_1 = Body1, Body1_1, Body1_2
  group core_together = Body1_3, Body1_4, Body1_5
boundaries and excitations:
  Opening1: Opening Faces=Region.face(-y) Temperature=AmbientTemp External_Rad._Temperature=AmbientRadTemp Inlet_Type=Pressure Total_Pressure=AmbientPressure
  Opening2: Opening Faces=Region.face(+y) Temperature=AmbientTemp External_Rad._Temperature=AmbientRadTemp Inlet_Type=Velocity Static_Pressure=AmbientPressure X_Velocity=0m_per_sec Y_Velocity=0m_per_sec Z_Velocity=0m_per_sec
  EMLoss1: EM Loss Objects=[Body1, Body1_1..Body1_5, Np1..Np8, Ns1..Ns8] LinkID=433 Project="This Project*" Product=ElectronicsDesktop Design=Flatwise_0.40_interleaved_full Params{freq_hz=28500Hz} ForceSourceToSolve PreservePartnerSoln PathRelativeTo=TargetProject Intrinsics(28.5kHz) LossMultiplier=1
mesh:
  MeshRegions:  Global{MeshMethod=MesherHD ComputeGap MeshRegionResolution=5 MinGapX=1mm MinGapY=1mm MinGapZ=1mm Objects=Region FacetLevel=5 ProximitySizeFunction CurvatureSizeFunction OptimizePCBMesh}
  MeshOperations:
setups:
  Setup1: IcepakSteadyState Flow_Regime=Laminar Include_Temperature=true Include_Flow=true Include_Gravity Solution_Initialization_-_Z_Velocity=0.000980665m_per_sec Convergence_Criteria_-_Flow=0.001 Convergence_Criteria_-_Energy=1e-07 Convergence_Criteria_-_Discrete_Ordinates=1e-06 Radiation_Model="Discrete Ordinates Model" Flow_Iteration_Per_Radiation_Iteration=10 ThetaDivision=2 PhiDivision=2 ThetaPixels=2 PhiPixels=2 Under-relaxation_-_Pressure=0.7 Under-relaxation_-_Momentum=0.3 Under-relaxation_-_Temperature=1 Discretization_Scheme_-_Pressure=Standard Discretization_Scheme_-_Momentum=First Discretization_Scheme_-_Temperature=First Discretization_Scheme_-_Discrete_Ordinates=First Convergence_Criteria_-_Max_Iterations=10000

design [Thermal]Flatwise_0.5_fix (Icepak, SteadyState TemperatureAndFlow, model units mm)
options: Default_Fluid_Material=air Default_Solid_Material=Al-Extruded Default_Surface_Material=Steel-oxidised-surface AmbientTemperature=25cel AmbientPressure=0n_per_meter_sq AmbientRadiationTemperature=25cel Gravity_Vector_CS_ID=Global Gravity_Vector_Axis=Z Positive=false SherlockExportDirectory=C:/Users/karlr/Documents/Ansoft/1kW_Final.aedtexport/[Thermal]8turns_3D_CoreLoss_FullInterleaved_Flatwise/ Altitude=0meter
geometry:
  Region [air] = region(percentage_offset=1000 on all sides)
  Np1 [copper] = imported_body(C:\Users\karlr\Documents\ICMaSS_sweeping\flatwise_0.1_0.5.step)
  Np2 [copper] = imported_body(C:\Users\karlr\Documents\ICMaSS_sweeping\flatwise_0.1_0.5.step)
  Np3 [copper] = imported_body(C:\Users\karlr\Documents\ICMaSS_sweeping\flatwise_0.1_0.5.step)
  Np4 [copper] = imported_body(C:\Users\karlr\Documents\ICMaSS_sweeping\flatwise_0.1_0.5.step)
  Np5 [copper] = imported_body(C:\Users\karlr\Documents\ICMaSS_sweeping\flatwise_0.1_0.5.step)
  Np6 [copper] = imported_body(C:\Users\karlr\Documents\ICMaSS_sweeping\flatwise_0.1_0.5.step)
  Np7 [copper] = imported_body(C:\Users\karlr\Documents\ICMaSS_sweeping\flatwise_0.1_0.5.step)
  Np8 [copper] = imported_body(C:\Users\karlr\Documents\ICMaSS_sweeping\flatwise_0.1_0.5.step)
  Ns1 [copper] = imported_body(C:\Users\karlr\Documents\ICMaSS_sweeping\flatwise_0.1_0.5.step)
  Ns2 [copper] = imported_body(C:\Users\karlr\Documents\ICMaSS_sweeping\flatwise_0.1_0.5.step)
  Ns3 [copper] = imported_body(C:\Users\karlr\Documents\ICMaSS_sweeping\flatwise_0.1_0.5.step)
  Ns4 [copper] = imported_body(C:\Users\karlr\Documents\ICMaSS_sweeping\flatwise_0.1_0.5.step)
  Ns5 [copper] = imported_body(C:\Users\karlr\Documents\ICMaSS_sweeping\flatwise_0.1_0.5.step)
  Ns6 [copper] = imported_body(C:\Users\karlr\Documents\ICMaSS_sweeping\flatwise_0.1_0.5.step)
  Ns7 [copper] = imported_body(C:\Users\karlr\Documents\ICMaSS_sweeping\flatwise_0.1_0.5.step)
  Ns8 [copper] = imported_body(C:\Users\karlr\Documents\ICMaSS_sweeping\flatwise_0.1_0.5.step)
  plate_1, plate_2 [silicon - Copy] = imported_body(C:\Users\karlr\Documents\ICMaSS_sweeping\flatwise_0.1_0.5.step)
  Body1 [ferrite - Copy (2)] = imported_body(C:\Users\karlr\Documents\ICMaSS_sweeping\flatwise_0.1_0.5.step)
  Body1_1, Body1_2 [aluminum] = imported_body(C:\Users\karlr\Documents\ICMaSS_sweeping\flatwise_0.1_0.5.step)
  Body1_3 [ferrite - Copy (2)] = imported_body(C:\Users\karlr\Documents\ICMaSS_sweeping\flatwise_0.1_0.5.step)
  Body1_4, Body1_5 [aluminum] = imported_body(C:\Users\karlr\Documents\ICMaSS_sweeping\flatwise_0.1_0.5.step)
  Rectangle1 [Al-Extruded, non-model] = rectangle(corner=(43mm, 25.56mm, 0mm), z_size=16mm, x_size=-43mm)
  group core_assembled_flatwise = Np1..Np8, Ns1..Ns8, plate_1, plate_2
  group core_together_1 = Body1, Body1_1, Body1_2
  group core_together = Body1_3, Body1_4, Body1_5
boundaries and excitations:
  Opening1: Opening Faces=Region.face(-y) Temperature=AmbientTemp External_Rad._Temperature=AmbientRadTemp Inlet_Type=Pressure Total_Pressure=AmbientPressure
  Opening2: Opening Faces=Region.face(+y) Temperature=AmbientTemp External_Rad._Temperature=AmbientRadTemp Inlet_Type=Velocity Static_Pressure=AmbientPressure X_Velocity=0m_per_sec Y_Velocity=0m_per_sec Z_Velocity=0m_per_sec
  EMLoss1: EM Loss Objects=[Body1, Body1_1..Body1_5, Np1..Np8, Ns1..Ns8] LinkID=448 Project="This Project*" Product=ElectronicsDesktop Design=Flatwise_0.50_interleaved_full Params{freq_hz=28500Hz} ForceSourceToSolve PreservePartnerSoln PathRelativeTo=TargetProject Intrinsics(28.5kHz) LossMultiplier=1
mesh:
  MeshRegions:  Global{MeshMethod=MesherHD ComputeGap MeshRegionResolution=5 MinGapX=1mm MinGapY=1mm MinGapZ=1mm Objects=Region FacetLevel=5 ProximitySizeFunction CurvatureSizeFunction OptimizePCBMesh}
  MeshOperations:
setups:
  Setup1: IcepakSteadyState Flow_Regime=Laminar Include_Temperature=true Include_Flow=true Include_Gravity Solution_Initialization_-_Z_Velocity=0.000980665m_per_sec Convergence_Criteria_-_Flow=0.001 Convergence_Criteria_-_Energy=1e-07 Convergence_Criteria_-_Discrete_Ordinates=1e-06 Radiation_Model="Discrete Ordinates Model" Flow_Iteration_Per_Radiation_Iteration=10 ThetaDivision=2 PhiDivision=2 ThetaPixels=2 PhiPixels=2 Under-relaxation_-_Pressure=0.7 Under-relaxation_-_Momentum=0.3 Under-relaxation_-_Temperature=1 Discretization_Scheme_-_Pressure=Standard Discretization_Scheme_-_Momentum=First Discretization_Scheme_-_Temperature=First Discretization_Scheme_-_Discrete_Ordinates=First Convergence_Criteria_-_Max_Iterations=10000
field plots:
  Temperature1: Temperature over Np1..Np8, Ns1..Ns8, plate_1, plate_2, Body1, Body1_1..Body1_5 on Setup1 : SteadyState
  Temperature2: Temperature over a plane on Setup1 : SteadyState

design [Thermal]Flatwise_0.25_fix (Icepak, SteadyState TemperatureAndFlow, model units mm)
options: Default_Fluid_Material=air Default_Solid_Material=Al-Extruded Default_Surface_Material=Steel-oxidised-surface AmbientTemperature=25cel AmbientPressure=0n_per_meter_sq AmbientRadiationTemperature=25cel Gravity_Vector_CS_ID=Global Gravity_Vector_Axis=Z Positive=false SherlockExportDirectory=C:/Users/karlr/Documents/Ansoft/1kW_Final.aedtexport/[Thermal]8turns_3D_CoreLoss_FullInterleaved_Flatwise/ Altitude=0meter
geometry:
  Region [air] = region(percentage_offset=1000 on all sides)
  Np1 [copper] = imported_body(C:\Users\karlr\Documents\ICMaSS_sweeping\flatwise_0.1_0.25.step)
  Np2 [copper] = imported_body(C:\Users\karlr\Documents\ICMaSS_sweeping\flatwise_0.1_0.25.step)
  Np3 [copper] = imported_body(C:\Users\karlr\Documents\ICMaSS_sweeping\flatwise_0.1_0.25.step)
  Np4 [copper] = imported_body(C:\Users\karlr\Documents\ICMaSS_sweeping\flatwise_0.1_0.25.step)
  Np5 [copper] = imported_body(C:\Users\karlr\Documents\ICMaSS_sweeping\flatwise_0.1_0.25.step)
  Np6 [copper] = imported_body(C:\Users\karlr\Documents\ICMaSS_sweeping\flatwise_0.1_0.25.step)
  Np7 [copper] = imported_body(C:\Users\karlr\Documents\ICMaSS_sweeping\flatwise_0.1_0.25.step)
  Np8 [copper] = imported_body(C:\Users\karlr\Documents\ICMaSS_sweeping\flatwise_0.1_0.25.step)
  Ns1 [copper] = imported_body(C:\Users\karlr\Documents\ICMaSS_sweeping\flatwise_0.1_0.25.step)
  Ns2 [copper] = imported_body(C:\Users\karlr\Documents\ICMaSS_sweeping\flatwise_0.1_0.25.step)
  Ns3 [copper] = imported_body(C:\Users\karlr\Documents\ICMaSS_sweeping\flatwise_0.1_0.25.step)
  Ns4 [copper] = imported_body(C:\Users\karlr\Documents\ICMaSS_sweeping\flatwise_0.1_0.25.step)
  Ns5 [copper] = imported_body(C:\Users\karlr\Documents\ICMaSS_sweeping\flatwise_0.1_0.25.step)
  Ns6 [copper] = imported_body(C:\Users\karlr\Documents\ICMaSS_sweeping\flatwise_0.1_0.25.step)
  Ns7 [copper] = imported_body(C:\Users\karlr\Documents\ICMaSS_sweeping\flatwise_0.1_0.25.step)
  Ns8 [copper] = imported_body(C:\Users\karlr\Documents\ICMaSS_sweeping\flatwise_0.1_0.25.step)
  plate_1, plate_2 [silicon - Copy] = imported_body(C:\Users\karlr\Documents\ICMaSS_sweeping\flatwise_0.1_0.25.step)
  Body1 [ferrite - Copy (2)] = imported_body(C:\Users\karlr\Documents\ICMaSS_sweeping\flatwise_0.1_0.25.step)
  Body1_1, Body1_2 [aluminum] = imported_body(C:\Users\karlr\Documents\ICMaSS_sweeping\flatwise_0.1_0.25.step)
  Body1_3 [ferrite - Copy (2)] = imported_body(C:\Users\karlr\Documents\ICMaSS_sweeping\flatwise_0.1_0.25.step)
  Body1_4, Body1_5 [aluminum] = imported_body(C:\Users\karlr\Documents\ICMaSS_sweeping\flatwise_0.1_0.25.step)
  group core_assembled_flatwise = Np1..Np8, Ns1..Ns8, plate_1, plate_2
  group core_together_1 = Body1, Body1_1, Body1_2
  group core_together = Body1_3, Body1_4, Body1_5
boundaries and excitations:
  Opening1: Opening Faces=Region.face(-y) Temperature=AmbientTemp External_Rad._Temperature=AmbientRadTemp Inlet_Type=Pressure Total_Pressure=AmbientPressure
  Opening2: Opening Faces=Region.face(+y) Temperature=AmbientTemp External_Rad._Temperature=AmbientRadTemp Inlet_Type=Velocity Static_Pressure=AmbientPressure X_Velocity=0m_per_sec Y_Velocity=0m_per_sec Z_Velocity=0m_per_sec
  EMLoss1: EM Loss Objects=[Body1, Body1_1..Body1_5, Np1..Np8, Ns1..Ns8] LinkID=466 Project="This Project*" Product=ElectronicsDesktop Design=Flatwise_0.25_interleaved_full Params{freq_hz=28500Hz} ForceSourceToSolve PreservePartnerSoln PathRelativeTo=TargetProject Intrinsics(28.5kHz) LossMultiplier=1
mesh:
  MeshRegions:  Global{MeshMethod=MesherHD ComputeGap MeshRegionResolution=5 MinGapX=1mm MinGapY=1mm MinGapZ=1mm Objects=Region FacetLevel=5 ProximitySizeFunction CurvatureSizeFunction OptimizePCBMesh}
  MeshOperations:
setups:
  Setup1: IcepakSteadyState Flow_Regime=Laminar Include_Temperature=true Include_Flow=true Include_Gravity Solution_Initialization_-_Z_Velocity=0.000980665m_per_sec Convergence_Criteria_-_Flow=0.001 Convergence_Criteria_-_Energy=1e-07 Convergence_Criteria_-_Discrete_Ordinates=1e-06 Radiation_Model="Discrete Ordinates Model" Flow_Iteration_Per_Radiation_Iteration=10 ThetaDivision=2 PhiDivision=2 ThetaPixels=2 PhiPixels=2 Under-relaxation_-_Pressure=0.7 Under-relaxation_-_Momentum=0.3 Under-relaxation_-_Temperature=1 Discretization_Scheme_-_Pressure=Standard Discretization_Scheme_-_Momentum=First Discretization_Scheme_-_Temperature=First Discretization_Scheme_-_Discrete_Ordinates=First Convergence_Criteria_-_Max_Iterations=10000

design [Thermal]Flatwise_0.2_fix_heatsink (Icepak, SteadyState TemperatureAndFlow, model units mm)
options: Default_Fluid_Material=air Default_Solid_Material=Al-Extruded Default_Surface_Material=Steel-oxidised-surface AmbientTemperature=25cel AmbientPressure=0n_per_meter_sq AmbientRadiationTemperature=25cel Gravity_Vector_CS_ID=Global Gravity_Vector_Axis=Z Positive=false SherlockExportDirectory=C:/Users/karlr/Documents/Ansoft/1kW_Final.aedtexport/[Thermal]8turns_3D_CoreLoss_FullInterleaved_Flatwise/ Altitude=0meter
geometry:
  Region [air] = region(percentage_offset: +X=1000, -X=1000, +Y=1000, -Y=1000, +Z=1000, -Z=0)
  Np1 [copper] = imported_body(C:\Users\karlr\Documents\ICMaSS_sweeping\flatwise_0.1_0.2.step)
  Np2 [copper] = imported_body(C:\Users\karlr\Documents\ICMaSS_sweeping\flatwise_0.1_0.2.step)
  Np3 [copper] = imported_body(C:\Users\karlr\Documents\ICMaSS_sweeping\flatwise_0.1_0.2.step)
  Np4 [copper] = imported_body(C:\Users\karlr\Documents\ICMaSS_sweeping\flatwise_0.1_0.2.step)
  Np5 [copper] = imported_body(C:\Users\karlr\Documents\ICMaSS_sweeping\flatwise_0.1_0.2.step)
  Np6 [copper] = imported_body(C:\Users\karlr\Documents\ICMaSS_sweeping\flatwise_0.1_0.2.step)
  Np7 [copper] = imported_body(C:\Users\karlr\Documents\ICMaSS_sweeping\flatwise_0.1_0.2.step)
  Np8 [copper] = imported_body(C:\Users\karlr\Documents\ICMaSS_sweeping\flatwise_0.1_0.2.step)
  Ns1 [copper] = imported_body(C:\Users\karlr\Documents\ICMaSS_sweeping\flatwise_0.1_0.2.step)
  Ns2 [copper] = imported_body(C:\Users\karlr\Documents\ICMaSS_sweeping\flatwise_0.1_0.2.step)
  Ns3 [copper] = imported_body(C:\Users\karlr\Documents\ICMaSS_sweeping\flatwise_0.1_0.2.step)
  Ns4 [copper] = imported_body(C:\Users\karlr\Documents\ICMaSS_sweeping\flatwise_0.1_0.2.step)
  Ns5 [copper] = imported_body(C:\Users\karlr\Documents\ICMaSS_sweeping\flatwise_0.1_0.2.step)
  Ns6 [copper] = imported_body(C:\Users\karlr\Documents\ICMaSS_sweeping\flatwise_0.1_0.2.step)
  Ns7 [copper] = imported_body(C:\Users\karlr\Documents\ICMaSS_sweeping\flatwise_0.1_0.2.step)
  Ns8 [copper] = imported_body(C:\Users\karlr\Documents\ICMaSS_sweeping\flatwise_0.1_0.2.step)
  plate_1, plate_2 [silicon - Copy] = imported_body(C:\Users\karlr\Documents\ICMaSS_sweeping\flatwise_0.1_0.2.step)
  Body1 [ferrite - Copy (2)] = imported_body(C:\Users\karlr\Documents\ICMaSS_sweeping\flatwise_0.1_0.2.step)
  Body1_1, Body1_2 [aluminum] = imported_body(C:\Users\karlr\Documents\ICMaSS_sweeping\flatwise_0.1_0.2.step)
  Body1_3 [ferrite - Copy (2)] = imported_body(C:\Users\karlr\Documents\ICMaSS_sweeping\flatwise_0.1_0.2.step)
  Body1_4, Body1_5 [aluminum] = imported_body(C:\Users\karlr\Documents\ICMaSS_sweeping\flatwise_0.1_0.2.step)
  Rectangle1 [Al-Extruded, non-model] = rectangle(corner=(35mm, 25.43mm, 0mm), z_size=20mm, x_size=-35mm)
  Box1 [silicon - Copy] = box(corner=(1.666653e-08mm, -7.5mm, 1.6666667e-08mm), size=(35mm, 65.86mm, -1mm))
  Box2 [aluminum] = box(corner=(70mm, -50mm, -1mm), size=(-100mm, 150mm, -5mm))
  group core_assembled_flatwise = Np1..Np8, Ns1..Ns8, plate_1, plate_2
  group core_together_2 = Body1, Body1_1, Body1_2
  group core_together1 = Body1_3, Body1_4, Body1_5
boundaries and excitations:
  Opening1: Opening Faces=Region.face(-y) Temperature=AmbientTemp External_Rad._Temperature=AmbientRadTemp Inlet_Type=Pressure Total_Pressure=AmbientPressure
  Opening2: Opening Faces=Region.face(+y) Temperature=AmbientTemp External_Rad._Temperature=AmbientRadTemp Inlet_Type=Velocity Static_Pressure=AmbientPressure X_Velocity=0m_per_sec Y_Velocity=0m_per_sec Z_Velocity=0m_per_sec
  EMLoss1: EM Loss Objects=[Body1, Body1_1..Body1_5, Np1..Np8, Ns1..Ns8] LinkID=403 Project="This Project*" Product=ElectronicsDesktop Design=Flatwise_0.2_interleaved_full Params{freq_hz=28500Hz} ForceSourceToSolve PreservePartnerSoln PathRelativeTo=TargetProject Intrinsics(28.5kHz) LossMultiplier=1
  StationaryWall1: Stationary Wall Faces=Box2.face(-z) Thickness=0mm Solid_Material=Al-Extruded External_Condition="Heat Transfer Coefficient" Heat_Flux=0irrad_W_per_m2 Temperature=AmbientTemp Heat_Transfer_Coefficient=50w_per_m2kel Reference_Temperature=AmbientTemp Heat_Transfer_Data{Heat_Transfer_Convection_Type="Forced Convection"} External_Material=Steel-oxidised-surface External_Radiation_Reference_Temperature=AmbientTemp External_Radiation_View_Factor=1
mesh:
  MeshRegions:  Global{MeshMethod=MesherHD ComputeGap MeshRegionResolution=5 MinGapX=1mm MinGapY=1mm MinGapZ=1mm Objects=Region FacetLevel=5 ProximitySizeFunction CurvatureSizeFunction OptimizePCBMesh}
  MeshOperations:
setups:
  Setup1: IcepakSteadyState Flow_Regime=Laminar Include_Temperature=true Include_Flow=true Include_Gravity Solution_Initialization_-_Z_Velocity=0.000980665m_per_sec Convergence_Criteria_-_Flow=0.001 Convergence_Criteria_-_Energy=1e-07 Convergence_Criteria_-_Discrete_Ordinates=1e-06 Radiation_Model="Discrete Ordinates Model" Flow_Iteration_Per_Radiation_Iteration=10 ThetaDivision=2 PhiDivision=2 ThetaPixels=2 PhiPixels=2 Under-relaxation_-_Pressure=0.7 Under-relaxation_-_Momentum=0.3 Under-relaxation_-_Temperature=1 Discretization_Scheme_-_Pressure=Standard Discretization_Scheme_-_Momentum=First Discretization_Scheme_-_Temperature=First Discretization_Scheme_-_Discrete_Ordinates=First Convergence_Criteria_-_Max_Iterations=10000
field plots:
  Temperature1: Temperature over Np1..Np8, Ns1..Ns8, plate_1, plate_2, Body1, Body1_1..Body1_5 on Setup1 : SteadyState
  Temperature2: Temperature over a plane on Setup1 : SteadyState

design [Thermal]Flatwise_0.3_fix_heatsink (Icepak, SteadyState TemperatureAndFlow, model units mm)
options: Default_Fluid_Material=air Default_Solid_Material=Al-Extruded Default_Surface_Material=Steel-oxidised-surface AmbientTemperature=25cel AmbientPressure=0n_per_meter_sq AmbientRadiationTemperature=25cel Gravity_Vector_CS_ID=Global Gravity_Vector_Axis=Z Positive=false SherlockExportDirectory=C:/Users/karlr/Documents/Ansoft/1kW_Final.aedtexport/[Thermal]8turns_3D_CoreLoss_FullInterleaved_Flatwise/ Altitude=0meter
geometry:
  Region [air] = region(percentage_offset: +X=1000, -X=1000, +Y=1000, -Y=1000, +Z=1000, -Z=0)
  Np1 [copper] = imported_body(C:\Users\karlr\Documents\ICMaSS_sweeping\flatwise_0.1_0.3.step)
  Np2 [copper] = imported_body(C:\Users\karlr\Documents\ICMaSS_sweeping\flatwise_0.1_0.3.step)
  Np3 [copper] = imported_body(C:\Users\karlr\Documents\ICMaSS_sweeping\flatwise_0.1_0.3.step)
  Np4 [copper] = imported_body(C:\Users\karlr\Documents\ICMaSS_sweeping\flatwise_0.1_0.3.step)
  Np5 [copper] = imported_body(C:\Users\karlr\Documents\ICMaSS_sweeping\flatwise_0.1_0.3.step)
  Np6 [copper] = imported_body(C:\Users\karlr\Documents\ICMaSS_sweeping\flatwise_0.1_0.3.step)
  Np7 [copper] = imported_body(C:\Users\karlr\Documents\ICMaSS_sweeping\flatwise_0.1_0.3.step)
  Np8 [copper] = imported_body(C:\Users\karlr\Documents\ICMaSS_sweeping\flatwise_0.1_0.3.step)
  Ns1 [copper] = imported_body(C:\Users\karlr\Documents\ICMaSS_sweeping\flatwise_0.1_0.3.step)
  Ns2 [copper] = imported_body(C:\Users\karlr\Documents\ICMaSS_sweeping\flatwise_0.1_0.3.step)
  Ns3 [copper] = imported_body(C:\Users\karlr\Documents\ICMaSS_sweeping\flatwise_0.1_0.3.step)
  Ns4 [copper] = imported_body(C:\Users\karlr\Documents\ICMaSS_sweeping\flatwise_0.1_0.3.step)
  Ns5 [copper] = imported_body(C:\Users\karlr\Documents\ICMaSS_sweeping\flatwise_0.1_0.3.step)
  Ns6 [copper] = imported_body(C:\Users\karlr\Documents\ICMaSS_sweeping\flatwise_0.1_0.3.step)
  Ns7 [copper] = imported_body(C:\Users\karlr\Documents\ICMaSS_sweeping\flatwise_0.1_0.3.step)
  Ns8 [copper] = imported_body(C:\Users\karlr\Documents\ICMaSS_sweeping\flatwise_0.1_0.3.step)
  plate_1, plate_2 [silicon - Copy] = imported_body(C:\Users\karlr\Documents\ICMaSS_sweeping\flatwise_0.1_0.3.step)
  Body1 [ferrite - Copy (2)] = imported_body(C:\Users\karlr\Documents\ICMaSS_sweeping\flatwise_0.1_0.3.step)
  Body1_1, Body1_2 [aluminum] = imported_body(C:\Users\karlr\Documents\ICMaSS_sweeping\flatwise_0.1_0.3.step)
  Body1_3 [ferrite - Copy (2)] = imported_body(C:\Users\karlr\Documents\ICMaSS_sweeping\flatwise_0.1_0.3.step)
  Body1_4, Body1_5 [aluminum] = imported_body(C:\Users\karlr\Documents\ICMaSS_sweeping\flatwise_0.1_0.3.step)
  Rectangle1 [Al-Extruded, non-model] = rectangle(corner=(36.6mm, 25.43mm, 0mm), z_size=18.666667mm, x_size=-36.6mm)
  Box1 [silicon - Copy] = box(corner=(1.666653e-08mm, -8.3mm, 1.6666666e-08mm), size=(36.6mm, 67.46mm, -1mm))
  Box2 [aluminum] = box(corner=(70mm, -50mm, -1mm), size=(-100mm, 150mm, -5mm))
  group core_assembled_flatwise = Np1..Np8, Ns1..Ns8, plate_1, plate_2
  group core_together_1 = Body1, Body1_1, Body1_2
  group core_together = Body1_3, Body1_4, Body1_5
boundaries and excitations:
  Opening1: Opening Faces=Region.face(-y) Temperature=AmbientTemp External_Rad._Temperature=AmbientRadTemp Inlet_Type=Pressure Total_Pressure=AmbientPressure
  Opening2: Opening Faces=Region.face(+y) Temperature=AmbientTemp External_Rad._Temperature=AmbientRadTemp Inlet_Type=Velocity Static_Pressure=AmbientPressure X_Velocity=0m_per_sec Y_Velocity=0m_per_sec Z_Velocity=0m_per_sec
  EMLoss1: EM Loss Objects=[Body1, Body1_1..Body1_5, Np1..Np8, Ns1..Ns8] LinkID=418 Project="This Project*" Product=ElectronicsDesktop Design=Flatwise_0.30_interleaved_full Params{freq_hz=28500Hz} ForceSourceToSolve PreservePartnerSoln PathRelativeTo=TargetProject Intrinsics(28.5kHz) LossMultiplier=1
  StationaryWall1: Stationary Wall Faces=Box2.face(-z) Thickness=0mm Solid_Material=Al-Extruded External_Condition="Heat Transfer Coefficient" Heat_Flux=0irrad_W_per_m2 Temperature=AmbientTemp Heat_Transfer_Coefficient=50w_per_m2kel Reference_Temperature=AmbientTemp Heat_Transfer_Data{Heat_Transfer_Convection_Type="Forced Convection"} External_Material=Steel-oxidised-surface External_Radiation_Reference_Temperature=AmbientTemp External_Radiation_View_Factor=1
mesh:
  MeshRegions:  Global{MeshMethod=MesherHD ComputeGap MeshRegionResolution=5 MinGapX=1mm MinGapY=1mm MinGapZ=1mm Objects=Region FacetLevel=5 ProximitySizeFunction CurvatureSizeFunction OptimizePCBMesh}
  MeshOperations:
setups:
  Setup1: IcepakSteadyState Flow_Regime=Laminar Include_Temperature=true Include_Flow=true Include_Gravity Solution_Initialization_-_Z_Velocity=0.000980665m_per_sec Convergence_Criteria_-_Flow=0.001 Convergence_Criteria_-_Energy=1e-07 Convergence_Criteria_-_Discrete_Ordinates=1e-06 Radiation_Model="Discrete Ordinates Model" Flow_Iteration_Per_Radiation_Iteration=10 ThetaDivision=2 PhiDivision=2 ThetaPixels=2 PhiPixels=2 Under-relaxation_-_Pressure=0.7 Under-relaxation_-_Momentum=0.3 Under-relaxation_-_Temperature=1 Discretization_Scheme_-_Pressure=Standard Discretization_Scheme_-_Momentum=First Discretization_Scheme_-_Temperature=First Discretization_Scheme_-_Discrete_Ordinates=First Convergence_Criteria_-_Max_Iterations=10000
field plots:
  Temperature1: Temperature over Np1..Np8, Ns1..Ns8, plate_1, plate_2, Body1, Body1_1..Body1_5 on Setup1 : SteadyState
  Temperature2: Temperature over a plane on Setup1 : SteadyState

design [Thermal]Flatwise_0.5_fix_heatsink (Icepak, SteadyState TemperatureAndFlow, model units mm)
options: Default_Fluid_Material=air Default_Solid_Material=Al-Extruded Default_Surface_Material=Steel-oxidised-surface AmbientTemperature=25cel AmbientPressure=0n_per_meter_sq AmbientRadiationTemperature=25cel Gravity_Vector_CS_ID=Global Gravity_Vector_Axis=Z Positive=false SherlockExportDirectory=C:/Users/karlr/Documents/Ansoft/1kW_Final.aedtexport/[Thermal]8turns_3D_CoreLoss_FullInterleaved_Flatwise/ Altitude=0meter
geometry:
  Region [air] = region(percentage_offset: +X=1000, -X=1000, +Y=1000, -Y=1000, +Z=1000, -Z=0)
  Np1 [copper] = imported_body(C:\Users\karlr\Documents\ICMaSS_sweeping\flatwise_0.1_0.5.step)
  Np2 [copper] = imported_body(C:\Users\karlr\Documents\ICMaSS_sweeping\flatwise_0.1_0.5.step)
  Np3 [copper] = imported_body(C:\Users\karlr\Documents\ICMaSS_sweeping\flatwise_0.1_0.5.step)
  Np4 [copper] = imported_body(C:\Users\karlr\Documents\ICMaSS_sweeping\flatwise_0.1_0.5.step)
  Np5 [copper] = imported_body(C:\Users\karlr\Documents\ICMaSS_sweeping\flatwise_0.1_0.5.step)
  Np6 [copper] = imported_body(C:\Users\karlr\Documents\ICMaSS_sweeping\flatwise_0.1_0.5.step)
  Np7 [copper] = imported_body(C:\Users\karlr\Documents\ICMaSS_sweeping\flatwise_0.1_0.5.step)
  Np8 [copper] = imported_body(C:\Users\karlr\Documents\ICMaSS_sweeping\flatwise_0.1_0.5.step)
  Ns1 [copper] = imported_body(C:\Users\karlr\Documents\ICMaSS_sweeping\flatwise_0.1_0.5.step)
  Ns2 [copper] = imported_body(C:\Users\karlr\Documents\ICMaSS_sweeping\flatwise_0.1_0.5.step)
  Ns3 [copper] = imported_body(C:\Users\karlr\Documents\ICMaSS_sweeping\flatwise_0.1_0.5.step)
  Ns4 [copper] = imported_body(C:\Users\karlr\Documents\ICMaSS_sweeping\flatwise_0.1_0.5.step)
  Ns5 [copper] = imported_body(C:\Users\karlr\Documents\ICMaSS_sweeping\flatwise_0.1_0.5.step)
  Ns6 [copper] = imported_body(C:\Users\karlr\Documents\ICMaSS_sweeping\flatwise_0.1_0.5.step)
  Ns7 [copper] = imported_body(C:\Users\karlr\Documents\ICMaSS_sweeping\flatwise_0.1_0.5.step)
  Ns8 [copper] = imported_body(C:\Users\karlr\Documents\ICMaSS_sweeping\flatwise_0.1_0.5.step)
  plate_1, plate_2 [silicon - Copy] = imported_body(C:\Users\karlr\Documents\ICMaSS_sweeping\flatwise_0.1_0.5.step)
  Body1 [ferrite - Copy (2)] = imported_body(C:\Users\karlr\Documents\ICMaSS_sweeping\flatwise_0.1_0.5.step)
  Body1_1, Body1_2 [aluminum] = imported_body(C:\Users\karlr\Documents\ICMaSS_sweeping\flatwise_0.1_0.5.step)
  Body1_3 [ferrite - Copy (2)] = imported_body(C:\Users\karlr\Documents\ICMaSS_sweeping\flatwise_0.1_0.5.step)
  Body1_4, Body1_5 [aluminum] = imported_body(C:\Users\karlr\Documents\ICMaSS_sweeping\flatwise_0.1_0.5.step)
  Rectangle1 [Al-Extruded, non-model] = rectangle(corner=(43mm, 25.56mm, 0mm), z_size=16mm, x_size=-43mm)
  Box1 [silicon - Copy] = box(corner=(1.6666535e-08mm, -11.5mm, 1.6666667e-08mm), size=(43mm, 74.12mm, -1mm))
  Box2 [aluminum] = box(corner=(70mm, -50mm, -1mm), size=(-100mm, 150mm, -5mm))
  group core_assembled_flatwise = Np1..Np8, Ns1..Ns8, plate_1, plate_2
  group core_together_1 = Body1, Body1_1, Body1_2
  group core_together = Body1_3, Body1_4, Body1_5
boundaries and excitations:
  Opening1: Opening Faces=Region.face(-y) Temperature=AmbientTemp External_Rad._Temperature=AmbientRadTemp Inlet_Type=Pressure Total_Pressure=AmbientPressure
  Opening2: Opening Faces=Region.face(+y) Temperature=AmbientTemp External_Rad._Temperature=AmbientRadTemp Inlet_Type=Velocity Static_Pressure=AmbientPressure X_Velocity=0m_per_sec Y_Velocity=0m_per_sec Z_Velocity=0m_per_sec
  EMLoss1: EM Loss Objects=[Body1, Body1_1..Body1_5, Np1..Np8, Ns1..Ns8] LinkID=448 Project="This Project*" Product=ElectronicsDesktop Design=Flatwise_0.50_interleaved_full Params{freq_hz=28500Hz} ForceSourceToSolve PreservePartnerSoln PathRelativeTo=TargetProject Intrinsics(28.5kHz) LossMultiplier=1
  StationaryWall1: Stationary Wall Faces=Box2.face(-z) Thickness=0mm Solid_Material=Al-Extruded External_Condition="Heat Transfer Coefficient" Heat_Flux=0irrad_W_per_m2 Temperature=AmbientTemp Heat_Transfer_Coefficient=50w_per_m2kel Reference_Temperature=AmbientTemp Heat_Transfer_Data{Heat_Transfer_Convection_Type="Forced Convection"} External_Material=Steel-oxidised-surface External_Radiation_Reference_Temperature=AmbientTemp External_Radiation_View_Factor=1
mesh:
  MeshRegions:  Global{MeshMethod=MesherHD ComputeGap MeshRegionResolution=5 MinGapX=1mm MinGapY=1mm MinGapZ=1mm Objects=Region FacetLevel=5 ProximitySizeFunction CurvatureSizeFunction OptimizePCBMesh}
  MeshOperations:
setups:
  Setup1: IcepakSteadyState Flow_Regime=Laminar Include_Temperature=true Include_Flow=true Include_Gravity Solution_Initialization_-_Z_Velocity=0.000980665m_per_sec Convergence_Criteria_-_Flow=0.001 Convergence_Criteria_-_Energy=1e-07 Convergence_Criteria_-_Discrete_Ordinates=1e-06 Radiation_Model="Discrete Ordinates Model" Flow_Iteration_Per_Radiation_Iteration=10 ThetaDivision=2 PhiDivision=2 ThetaPixels=2 PhiPixels=2 Under-relaxation_-_Pressure=0.7 Under-relaxation_-_Momentum=0.3 Under-relaxation_-_Temperature=1 Discretization_Scheme_-_Pressure=Standard Discretization_Scheme_-_Momentum=First Discretization_Scheme_-_Temperature=First Discretization_Scheme_-_Discrete_Ordinates=First Convergence_Criteria_-_Max_Iterations=10000
field plots:
  Temperature1: Temperature over Np1..Np8, Ns1..Ns8, plate_1, plate_2, Body1, Body1_1..Body1_5 on Setup1 : SteadyState
  Temperature2: Temperature over a plane on Setup1 : SteadyState

design [Thermal]Flatwise_0.3_fix1 (Icepak, SteadyState TemperatureAndFlow, model units mm)
options: Default_Fluid_Material=air Default_Solid_Material=Al-Extruded Default_Surface_Material=Steel-oxidised-surface AmbientTemperature=25cel AmbientPressure=0n_per_meter_sq AmbientRadiationTemperature=25cel Gravity_Vector_CS_ID=Global Gravity_Vector_Axis=Z Positive=false SherlockExportDirectory=C:/Users/karlr/Documents/Ansoft/1kW_Final.aedtexport/[Thermal]8turns_3D_CoreLoss_FullInterleaved_Flatwise/ Altitude=0meter
geometry:
  Region [air] = region(percentage_offset=1000 on all sides)
  Np1 [copper] = imported_body(C:\Users\karlr\Documents\ICMaSS_sweeping\flatwise_0.1_0.3.step)
  Np2 [copper] = imported_body(C:\Users\karlr\Documents\ICMaSS_sweeping\flatwise_0.1_0.3.step)
  Np3 [copper] = imported_body(C:\Users\karlr\Documents\ICMaSS_sweeping\flatwise_0.1_0.3.step)
  Np4 [copper] = imported_body(C:\Users\karlr\Documents\ICMaSS_sweeping\flatwise_0.1_0.3.step)
  Np5 [copper] = imported_body(C:\Users\karlr\Documents\ICMaSS_sweeping\flatwise_0.1_0.3.step)
  Np6 [copper] = imported_body(C:\Users\karlr\Documents\ICMaSS_sweeping\flatwise_0.1_0.3.step)
  Np7 [copper] = imported_body(C:\Users\karlr\Documents\ICMaSS_sweeping\flatwise_0.1_0.3.step)
  Np8 [copper] = imported_body(C:\Users\karlr\Documents\ICMaSS_sweeping\flatwise_0.1_0.3.step)
  Ns1 [copper] = imported_body(C:\Users\karlr\Documents\ICMaSS_sweeping\flatwise_0.1_0.3.step)
  Ns2 [copper] = imported_body(C:\Users\karlr\Documents\ICMaSS_sweeping\flatwise_0.1_0.3.step)
  Ns3 [copper] = imported_body(C:\Users\karlr\Documents\ICMaSS_sweeping\flatwise_0.1_0.3.step)
  Ns4 [copper] = imported_body(C:\Users\karlr\Documents\ICMaSS_sweeping\flatwise_0.1_0.3.step)
  Ns5 [copper] = imported_body(C:\Users\karlr\Documents\ICMaSS_sweeping\flatwise_0.1_0.3.step)
  Ns6 [copper] = imported_body(C:\Users\karlr\Documents\ICMaSS_sweeping\flatwise_0.1_0.3.step)
  Ns7 [copper] = imported_body(C:\Users\karlr\Documents\ICMaSS_sweeping\flatwise_0.1_0.3.step)
  Ns8 [copper] = imported_body(C:\Users\karlr\Documents\ICMaSS_sweeping\flatwise_0.1_0.3.step)
  plate_1, plate_2 [silicon - Copy] = imported_body(C:\Users\karlr\Documents\ICMaSS_sweeping\flatwise_0.1_0.3.step)
  Body1 [ferrite - Copy (2)] = imported_body(C:\Users\karlr\Documents\ICMaSS_sweeping\flatwise_0.1_0.3.step)
  Body1_1, Body1_2 [aluminum] = imported_body(C:\Users\karlr\Documents\ICMaSS_sweeping\flatwise_0.1_0.3.step)
  Body1_3 [ferrite - Copy (2)] = imported_body(C:\Users\karlr\Documents\ICMaSS_sweeping\flatwise_0.1_0.3.step)
  Body1_4, Body1_5 [aluminum] = imported_body(C:\Users\karlr\Documents\ICMaSS_sweeping\flatwise_0.1_0.3.step)
  Rectangle1 [Al-Extruded, non-model] = rectangle(corner=(36.6mm, 25.43mm, 0mm), z_size=18.666667mm, x_size=-36.6mm)
  Box2 = box(corner=(24.3mm, -0.99999998mm, 6mm), size=(-12mm, 52.86mm, 6.6666666mm))
  Box2.delete()
  Box3 [non-model] = box(corner=(5mm, -8.3mm, 5mm), size=(26.6mm, 67.46mm, 8.6666667mm))
  Box1 [polyimide] = imported_body()
  group core_assembled_flatwise = Np1..Np8, Ns1..Ns8, plate_1, plate_2
  group core_together_1 = Body1, Body1_1, Body1_2
  group core_together = Body1_3, Body1_4, Body1_5
boundaries and excitations:
  Opening1: Opening Faces=Region.face(-y) Temperature=AmbientTemp External_Rad._Temperature=AmbientRadTemp Inlet_Type=Pressure Total_Pressure=AmbientPressure
  Opening2: Opening Faces=Region.face(+y) Temperature=AmbientTemp External_Rad._Temperature=AmbientRadTemp Inlet_Type=Velocity Static_Pressure=AmbientPressure X_Velocity=0m_per_sec Y_Velocity=0m_per_sec Z_Velocity=0m_per_sec
  EMLoss1: EM Loss Objects=[Body1, Body1_1..Body1_5, Np1..Np8, Ns1..Ns8] LinkID=418 Project="This Project*" Product=ElectronicsDesktop Design=Flatwise_0.30_interleaved_full Params{freq_hz=28500Hz} ForceSourceToSolve PreservePartnerSoln PathRelativeTo=TargetProject Intrinsics(28.5kHz) LossMultiplier=1
mesh:
  MeshRegions:  Global{MeshMethod=MesherHD ComputeGap MeshRegionResolution=5 MinGapX=1mm MinGapY=1mm MinGapZ=1mm Objects=Region FacetLevel=5 ProximitySizeFunction CurvatureSizeFunction OptimizePCBMesh} MeshRegion1{MeshMethod=MesherHD MeshRegionResolution=3 MinGapX=1mm MinGapY=1mm MinGapZ=1mm Objects=Box3 ProximitySizeFunction CurvatureSizeFunction OptimizePCBMesh}
  MeshOperations:
setups:
  Setup1: IcepakSteadyState Flow_Regime=Laminar Include_Temperature=true Include_Flow=true Include_Gravity Solution_Initialization_-_Z_Velocity=0.000980665m_per_sec Convergence_Criteria_-_Flow=0.001 Convergence_Criteria_-_Energy=1e-07 Convergence_Criteria_-_Discrete_Ordinates=1e-06 Radiation_Model="Discrete Ordinates Model" Flow_Iteration_Per_Radiation_Iteration=10 ThetaDivision=2 PhiDivision=2 ThetaPixels=2 PhiPixels=2 Under-relaxation_-_Pressure=0.7 Under-relaxation_-_Momentum=0.3 Under-relaxation_-_Temperature=1 Discretization_Scheme_-_Pressure=Standard Discretization_Scheme_-_Momentum=First Discretization_Scheme_-_Temperature=First Discretization_Scheme_-_Discrete_Ordinates=First Convergence_Criteria_-_Max_Iterations=10000
field plots:
  Temperature1: Temperature over Np1..Np8, Ns1..Ns8, plate_1, plate_2, Body1, Body1_1..Body1_5 on Setup1 : SteadyState
  Temperature2: Temperature over a plane on Setup1 : SteadyState

design [Thermal]Flatwise_0.3_fix_coldplate (Icepak, SteadyState TemperatureAndFlow, model units mm)
options: Default_Fluid_Material=air Default_Solid_Material=Al-Extruded Default_Surface_Material=Steel-oxidised-surface AmbientTemperature=25cel AmbientPressure=0n_per_meter_sq AmbientRadiationTemperature=25cel Gravity_Vector_CS_ID=Global Gravity_Vector_Axis=Z Positive=false SherlockExportDirectory=C:/Users/karlr/Documents/Ansoft/1kW_Final.aedtexport/[Thermal]8turns_3D_CoreLoss_FullInterleaved_Flatwise/ Altitude=0meter
geometry:
  Region [air] = region(percentage_offset: +X=1000, -X=1000, +Y=1000, -Y=1000, +Z=1000, -Z=0)
  Np1 [copper] = imported_body(C:\Users\karlr\Documents\ICMaSS_sweeping\flatwise_0.1_0.3.step)
  Np2 [copper] = imported_body(C:\Users\karlr\Documents\ICMaSS_sweeping\flatwise_0.1_0.3.step)
  Np3 [copper] = imported_body(C:\Users\karlr\Documents\ICMaSS_sweeping\flatwise_0.1_0.3.step)
  Np4 [copper] = imported_body(C:\Users\karlr\Documents\ICMaSS_sweeping\flatwise_0.1_0.3.step)
  Np5 [copper] = imported_body(C:\Users\karlr\Documents\ICMaSS_sweeping\flatwise_0.1_0.3.step)
  Np6 [copper] = imported_body(C:\Users\karlr\Documents\ICMaSS_sweeping\flatwise_0.1_0.3.step)
  Np7 [copper] = imported_body(C:\Users\karlr\Documents\ICMaSS_sweeping\flatwise_0.1_0.3.step)
  Np8 [copper] = imported_body(C:\Users\karlr\Documents\ICMaSS_sweeping\flatwise_0.1_0.3.step)
  Ns1 [copper] = imported_body(C:\Users\karlr\Documents\ICMaSS_sweeping\flatwise_0.1_0.3.step)
  Ns2 [copper] = imported_body(C:\Users\karlr\Documents\ICMaSS_sweeping\flatwise_0.1_0.3.step)
  Ns3 [copper] = imported_body(C:\Users\karlr\Documents\ICMaSS_sweeping\flatwise_0.1_0.3.step)
  Ns4 [copper] = imported_body(C:\Users\karlr\Documents\ICMaSS_sweeping\flatwise_0.1_0.3.step)
  Ns5 [copper] = imported_body(C:\Users\karlr\Documents\ICMaSS_sweeping\flatwise_0.1_0.3.step)
  Ns6 [copper] = imported_body(C:\Users\karlr\Documents\ICMaSS_sweeping\flatwise_0.1_0.3.step)
  Ns7 [copper] = imported_body(C:\Users\karlr\Documents\ICMaSS_sweeping\flatwise_0.1_0.3.step)
  Ns8 [copper] = imported_body(C:\Users\karlr\Documents\ICMaSS_sweeping\flatwise_0.1_0.3.step)
  plate_1, plate_2 [silicon - Copy] = imported_body(C:\Users\karlr\Documents\ICMaSS_sweeping\flatwise_0.1_0.3.step)
  Body1 [ferrite - Copy (2)] = imported_body(C:\Users\karlr\Documents\ICMaSS_sweeping\flatwise_0.1_0.3.step)
  Body1_1, Body1_2 [aluminum] = imported_body(C:\Users\karlr\Documents\ICMaSS_sweeping\flatwise_0.1_0.3.step)
  Body1_3 [ferrite - Copy (2)] = imported_body(C:\Users\karlr\Documents\ICMaSS_sweeping\flatwise_0.1_0.3.step)
  Body1_4, Body1_5 [aluminum] = imported_body(C:\Users\karlr\Documents\ICMaSS_sweeping\flatwise_0.1_0.3.step)
  Rectangle1 [Al-Extruded, non-model] = rectangle(corner=(36.6mm, 25.43mm, 0mm), z_size=18.666667mm, x_size=-36.6mm)
  Box1 [silicon - Copy] = box(corner=(1.666653e-08mm, -8.3mm, 1.6666666e-08mm), size=(36.6mm, 67.46mm, -1mm))
  group core_assembled_flatwise = Np1..Np8, Ns1..Ns8, plate_1, plate_2
  group core_together_1 = Body1, Body1_1, Body1_2
  group core_together = Body1_3, Body1_4, Body1_5
boundaries and excitations:
  Opening1: Opening Faces=Region.face(-y) Temperature=AmbientTemp External_Rad._Temperature=AmbientRadTemp Inlet_Type=Pressure Total_Pressure=AmbientPressure
  Opening2: Opening Faces=Region.face(+y) Temperature=AmbientTemp External_Rad._Temperature=AmbientRadTemp Inlet_Type=Velocity Static_Pressure=AmbientPressure X_Velocity=0m_per_sec Y_Velocity=0m_per_sec Z_Velocity=0m_per_sec
  EMLoss1: EM Loss Objects=[Body1, Body1_1..Body1_5, Np1..Np8, Ns1..Ns8] LinkID=418 Project="This Project*" Product=ElectronicsDesktop Design=Flatwise_0.30_interleaved_full Params{freq_hz=28500Hz} ForceSourceToSolve PreservePartnerSoln PathRelativeTo=TargetProject Intrinsics(28.5kHz) LossMultiplier=1
  StationaryWall1: Stationary Wall Faces=Box1.face(-z) Thickness=0mm Solid_Material=Al-Extruded External_Condition=Temperature Heat_Flux=0irrad_W_per_m2 Temperature=20cel Heat_Transfer_Coefficient=0w_per_m2kel Reference_Temperature=AmbientTemp Heat_Transfer_Data{Heat_Transfer_Convection_Type="Forced Convection"} External_Material=Steel-oxidised-surface External_Radiation_Reference_Temperature=AmbientTemp External_Radiation_View_Factor=1
mesh:
  MeshRegions:  Global{MeshMethod=MesherHD ComputeGap MeshRegionResolution=5 MinGapX=1mm MinGapY=1mm MinGapZ=1mm Objects=Region FacetLevel=5 ProximitySizeFunction CurvatureSizeFunction OptimizePCBMesh}
  MeshOperations:
setups:
  Setup1: IcepakSteadyState Flow_Regime=Laminar Include_Temperature=true Include_Flow=true Include_Gravity Solution_Initialization_-_Z_Velocity=0.000980665m_per_sec Convergence_Criteria_-_Flow=0.001 Convergence_Criteria_-_Energy=1e-07 Convergence_Criteria_-_Discrete_Ordinates=1e-06 Radiation_Model="Discrete Ordinates Model" Flow_Iteration_Per_Radiation_Iteration=10 ThetaDivision=2 PhiDivision=2 ThetaPixels=2 PhiPixels=2 Under-relaxation_-_Pressure=0.7 Under-relaxation_-_Momentum=0.3 Under-relaxation_-_Temperature=1 Discretization_Scheme_-_Pressure=Standard Discretization_Scheme_-_Momentum=First Discretization_Scheme_-_Temperature=First Discretization_Scheme_-_Discrete_Ordinates=First Convergence_Criteria_-_Max_Iterations=10000
field plots:
  Temperature1: Temperature over Np1..Np8, Ns1..Ns8, plate_1, plate_2, Body1, Body1_1..Body1_5 on Setup1 : SteadyState
  Temperature2: Temperature over a plane on Setup1 : SteadyState
